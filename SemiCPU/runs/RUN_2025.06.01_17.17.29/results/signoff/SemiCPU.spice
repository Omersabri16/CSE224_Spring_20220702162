* NGSPICE file created from SemiCPU.ext - technology: sky130A

* Black-box entry subcircuit for sky130_fd_sc_hd__nor2_1 abstract view
.subckt sky130_fd_sc_hd__nor2_1 A B VGND VNB VPB VPWR Y
.ends

* Black-box entry subcircuit for sky130_fd_sc_hd__nand3b_2 abstract view
.subckt sky130_fd_sc_hd__nand3b_2 A_N B C VGND VNB VPB VPWR Y
.ends

* Black-box entry subcircuit for sky130_fd_sc_hd__or3_1 abstract view
.subckt sky130_fd_sc_hd__or3_1 A B C VGND VNB VPB VPWR X
.ends

* Black-box entry subcircuit for sky130_fd_sc_hd__fill_1 abstract view
.subckt sky130_fd_sc_hd__fill_1 VGND VNB VPB VPWR
.ends

* Black-box entry subcircuit for sky130_fd_sc_hd__and3_1 abstract view
.subckt sky130_fd_sc_hd__and3_1 A B C VGND VNB VPB VPWR X
.ends

* Black-box entry subcircuit for sky130_fd_sc_hd__clkbuf_2 abstract view
.subckt sky130_fd_sc_hd__clkbuf_2 A VGND VNB VPB VPWR X
.ends

* Black-box entry subcircuit for sky130_fd_sc_hd__decap_4 abstract view
.subckt sky130_fd_sc_hd__decap_4 VGND VNB VPB VPWR
.ends

* Black-box entry subcircuit for sky130_fd_sc_hd__decap_8 abstract view
.subckt sky130_fd_sc_hd__decap_8 VGND VNB VPB VPWR
.ends

* Black-box entry subcircuit for sky130_fd_sc_hd__tapvpwrvgnd_1 abstract view
.subckt sky130_fd_sc_hd__tapvpwrvgnd_1 VGND VPWR
.ends

* Black-box entry subcircuit for sky130_ef_sc_hd__decap_12 abstract view
.subckt sky130_ef_sc_hd__decap_12 VPWR VGND VPB VNB
.ends

* Black-box entry subcircuit for sky130_fd_sc_hd__decap_3 abstract view
.subckt sky130_fd_sc_hd__decap_3 VGND VNB VPB VPWR
.ends

* Black-box entry subcircuit for sky130_fd_sc_hd__dlymetal6s4s_1 abstract view
.subckt sky130_fd_sc_hd__dlymetal6s4s_1 A VGND VNB VPB VPWR X
.ends

* Black-box entry subcircuit for sky130_fd_sc_hd__o221a_1 abstract view
.subckt sky130_fd_sc_hd__o221a_1 A1 A2 B1 B2 C1 VGND VNB VPB VPWR X
.ends

* Black-box entry subcircuit for sky130_fd_sc_hd__a2bb2o_1 abstract view
.subckt sky130_fd_sc_hd__a2bb2o_1 A1_N A2_N B1 B2 VGND VNB VPB VPWR X
.ends

* Black-box entry subcircuit for sky130_fd_sc_hd__inv_2 abstract view
.subckt sky130_fd_sc_hd__inv_2 A VGND VNB VPB VPWR Y
.ends

* Black-box entry subcircuit for sky130_fd_sc_hd__and2_1 abstract view
.subckt sky130_fd_sc_hd__and2_1 A B VGND VNB VPB VPWR X
.ends

* Black-box entry subcircuit for sky130_fd_sc_hd__mux2_1 abstract view
.subckt sky130_fd_sc_hd__mux2_1 A0 A1 S VGND VNB VPB VPWR X
.ends

* Black-box entry subcircuit for sky130_fd_sc_hd__fill_2 abstract view
.subckt sky130_fd_sc_hd__fill_2 VGND VNB VPB VPWR
.ends

* Black-box entry subcircuit for sky130_fd_sc_hd__nand2_1 abstract view
.subckt sky130_fd_sc_hd__nand2_1 A B VGND VNB VPB VPWR Y
.ends

* Black-box entry subcircuit for sky130_fd_sc_hd__decap_6 abstract view
.subckt sky130_fd_sc_hd__decap_6 VGND VNB VPB VPWR
.ends

* Black-box entry subcircuit for sky130_fd_sc_hd__and2b_1 abstract view
.subckt sky130_fd_sc_hd__and2b_1 A_N B VGND VNB VPB VPWR X
.ends

* Black-box entry subcircuit for sky130_fd_sc_hd__a31o_1 abstract view
.subckt sky130_fd_sc_hd__a31o_1 A1 A2 A3 B1 VGND VNB VPB VPWR X
.ends

* Black-box entry subcircuit for sky130_fd_sc_hd__clkbuf_1 abstract view
.subckt sky130_fd_sc_hd__clkbuf_1 A VGND VNB VPB VPWR X
.ends

* Black-box entry subcircuit for sky130_fd_sc_hd__dfrtp_1 abstract view
.subckt sky130_fd_sc_hd__dfrtp_1 CLK D RESET_B VGND VNB VPB VPWR Q
.ends

* Black-box entry subcircuit for sky130_fd_sc_hd__a21oi_1 abstract view
.subckt sky130_fd_sc_hd__a21oi_1 A1 A2 B1 VGND VNB VPB VPWR Y
.ends

* Black-box entry subcircuit for sky130_fd_sc_hd__or4b_1 abstract view
.subckt sky130_fd_sc_hd__or4b_1 A B C D_N VGND VNB VPB VPWR X
.ends

* Black-box entry subcircuit for sky130_fd_sc_hd__dfrtp_2 abstract view
.subckt sky130_fd_sc_hd__dfrtp_2 CLK D RESET_B VGND VNB VPB VPWR Q
.ends

* Black-box entry subcircuit for sky130_fd_sc_hd__clkbuf_4 abstract view
.subckt sky130_fd_sc_hd__clkbuf_4 A VGND VNB VPB VPWR X
.ends

* Black-box entry subcircuit for sky130_fd_sc_hd__a21oi_2 abstract view
.subckt sky130_fd_sc_hd__a21oi_2 A1 A2 B1 VGND VNB VPB VPWR Y
.ends

* Black-box entry subcircuit for sky130_fd_sc_hd__xnor2_1 abstract view
.subckt sky130_fd_sc_hd__xnor2_1 A B VGND VNB VPB VPWR Y
.ends

* Black-box entry subcircuit for sky130_fd_sc_hd__a22oi_2 abstract view
.subckt sky130_fd_sc_hd__a22oi_2 A1 A2 B1 B2 VGND VNB VPB VPWR Y
.ends

* Black-box entry subcircuit for sky130_fd_sc_hd__dlygate4sd1_1 abstract view
.subckt sky130_fd_sc_hd__dlygate4sd1_1 A VGND VNB VPB VPWR X
.ends

* Black-box entry subcircuit for sky130_fd_sc_hd__a21o_1 abstract view
.subckt sky130_fd_sc_hd__a21o_1 A1 A2 B1 VGND VNB VPB VPWR X
.ends

* Black-box entry subcircuit for sky130_fd_sc_hd__buf_2 abstract view
.subckt sky130_fd_sc_hd__buf_2 A VGND VNB VPB VPWR X
.ends

* Black-box entry subcircuit for sky130_fd_sc_hd__o31a_1 abstract view
.subckt sky130_fd_sc_hd__o31a_1 A1 A2 A3 B1 VGND VNB VPB VPWR X
.ends

* Black-box entry subcircuit for sky130_fd_sc_hd__buf_1 abstract view
.subckt sky130_fd_sc_hd__buf_1 A VGND VNB VPB VPWR X
.ends

* Black-box entry subcircuit for sky130_fd_sc_hd__a211oi_2 abstract view
.subckt sky130_fd_sc_hd__a211oi_2 A1 A2 B1 C1 VGND VNB VPB VPWR Y
.ends

* Black-box entry subcircuit for sky130_fd_sc_hd__a32o_1 abstract view
.subckt sky130_fd_sc_hd__a32o_1 A1 A2 A3 B1 B2 VGND VNB VPB VPWR X
.ends

* Black-box entry subcircuit for sky130_fd_sc_hd__or2_1 abstract view
.subckt sky130_fd_sc_hd__or2_1 A B VGND VNB VPB VPWR X
.ends

* Black-box entry subcircuit for sky130_fd_sc_hd__a22o_1 abstract view
.subckt sky130_fd_sc_hd__a22o_1 A1 A2 B1 B2 VGND VNB VPB VPWR X
.ends

* Black-box entry subcircuit for sky130_fd_sc_hd__o22ai_2 abstract view
.subckt sky130_fd_sc_hd__o22ai_2 A1 A2 B1 B2 VGND VNB VPB VPWR Y
.ends

* Black-box entry subcircuit for sky130_fd_sc_hd__a22oi_4 abstract view
.subckt sky130_fd_sc_hd__a22oi_4 A1 A2 B1 B2 VGND VNB VPB VPWR Y
.ends

* Black-box entry subcircuit for sky130_fd_sc_hd__nand4_2 abstract view
.subckt sky130_fd_sc_hd__nand4_2 A B C D VGND VNB VPB VPWR Y
.ends

* Black-box entry subcircuit for sky130_fd_sc_hd__o21a_4 abstract view
.subckt sky130_fd_sc_hd__o21a_4 A1 A2 B1 VGND VNB VPB VPWR X
.ends

* Black-box entry subcircuit for sky130_fd_sc_hd__dfxtp_1 abstract view
.subckt sky130_fd_sc_hd__dfxtp_1 CLK D VGND VNB VPB VPWR Q
.ends

* Black-box entry subcircuit for sky130_fd_sc_hd__a22o_2 abstract view
.subckt sky130_fd_sc_hd__a22o_2 A1 A2 B1 B2 VGND VNB VPB VPWR X
.ends

* Black-box entry subcircuit for sky130_fd_sc_hd__o21a_1 abstract view
.subckt sky130_fd_sc_hd__o21a_1 A1 A2 B1 VGND VNB VPB VPWR X
.ends

* Black-box entry subcircuit for sky130_fd_sc_hd__a221o_1 abstract view
.subckt sky130_fd_sc_hd__a221o_1 A1 A2 B1 B2 C1 VGND VNB VPB VPWR X
.ends

* Black-box entry subcircuit for sky130_fd_sc_hd__o21ai_1 abstract view
.subckt sky130_fd_sc_hd__o21ai_1 A1 A2 B1 VGND VNB VPB VPWR Y
.ends

* Black-box entry subcircuit for sky130_fd_sc_hd__buf_4 abstract view
.subckt sky130_fd_sc_hd__buf_4 A VGND VNB VPB VPWR X
.ends

* Black-box entry subcircuit for sky130_fd_sc_hd__dlymetal6s2s_1 abstract view
.subckt sky130_fd_sc_hd__dlymetal6s2s_1 A VGND VNB VPB VPWR X
.ends

* Black-box entry subcircuit for sky130_fd_sc_hd__a211o_1 abstract view
.subckt sky130_fd_sc_hd__a211o_1 A1 A2 B1 C1 VGND VNB VPB VPWR X
.ends

* Black-box entry subcircuit for sky130_fd_sc_hd__a22oi_1 abstract view
.subckt sky130_fd_sc_hd__a22oi_1 A1 A2 B1 B2 VGND VNB VPB VPWR Y
.ends

* Black-box entry subcircuit for sky130_fd_sc_hd__o221ai_4 abstract view
.subckt sky130_fd_sc_hd__o221ai_4 A1 A2 B1 B2 C1 VGND VNB VPB VPWR Y
.ends

* Black-box entry subcircuit for sky130_fd_sc_hd__xor2_1 abstract view
.subckt sky130_fd_sc_hd__xor2_1 A B VGND VNB VPB VPWR X
.ends

* Black-box entry subcircuit for sky130_fd_sc_hd__xnor2_2 abstract view
.subckt sky130_fd_sc_hd__xnor2_2 A B VGND VNB VPB VPWR Y
.ends

* Black-box entry subcircuit for sky130_fd_sc_hd__nor2_2 abstract view
.subckt sky130_fd_sc_hd__nor2_2 A B VGND VNB VPB VPWR Y
.ends

* Black-box entry subcircuit for sky130_fd_sc_hd__a31oi_1 abstract view
.subckt sky130_fd_sc_hd__a31oi_1 A1 A2 A3 B1 VGND VNB VPB VPWR Y
.ends

* Black-box entry subcircuit for sky130_fd_sc_hd__and2_4 abstract view
.subckt sky130_fd_sc_hd__and2_4 A B VGND VNB VPB VPWR X
.ends

* Black-box entry subcircuit for sky130_fd_sc_hd__xor2_2 abstract view
.subckt sky130_fd_sc_hd__xor2_2 A B VGND VNB VPB VPWR X
.ends

* Black-box entry subcircuit for sky130_fd_sc_hd__o311a_1 abstract view
.subckt sky130_fd_sc_hd__o311a_1 A1 A2 A3 B1 C1 VGND VNB VPB VPWR X
.ends

* Black-box entry subcircuit for sky130_fd_sc_hd__o22a_4 abstract view
.subckt sky130_fd_sc_hd__o22a_4 A1 A2 B1 B2 VGND VNB VPB VPWR X
.ends

* Black-box entry subcircuit for sky130_fd_sc_hd__a21bo_1 abstract view
.subckt sky130_fd_sc_hd__a21bo_1 A1 A2 B1_N VGND VNB VPB VPWR X
.ends

* Black-box entry subcircuit for sky130_fd_sc_hd__o2bb2a_2 abstract view
.subckt sky130_fd_sc_hd__o2bb2a_2 A1_N A2_N B1 B2 VGND VNB VPB VPWR X
.ends

* Black-box entry subcircuit for sky130_fd_sc_hd__or3_4 abstract view
.subckt sky130_fd_sc_hd__or3_4 A B C VGND VNB VPB VPWR X
.ends

* Black-box entry subcircuit for sky130_fd_sc_hd__a21boi_1 abstract view
.subckt sky130_fd_sc_hd__a21boi_1 A1 A2 B1_N VGND VNB VPB VPWR Y
.ends

* Black-box entry subcircuit for sky130_fd_sc_hd__or3b_1 abstract view
.subckt sky130_fd_sc_hd__or3b_1 A B C_N VGND VNB VPB VPWR X
.ends

* Black-box entry subcircuit for sky130_fd_sc_hd__clkbuf_8 abstract view
.subckt sky130_fd_sc_hd__clkbuf_8 A VGND VNB VPB VPWR X
.ends

* Black-box entry subcircuit for sky130_fd_sc_hd__nand2_4 abstract view
.subckt sky130_fd_sc_hd__nand2_4 A B VGND VNB VPB VPWR Y
.ends

* Black-box entry subcircuit for sky130_fd_sc_hd__buf_8 abstract view
.subckt sky130_fd_sc_hd__buf_8 A VGND VNB VPB VPWR X
.ends

* Black-box entry subcircuit for sky130_fd_sc_hd__or2_4 abstract view
.subckt sky130_fd_sc_hd__or2_4 A B VGND VNB VPB VPWR X
.ends

* Black-box entry subcircuit for sky130_fd_sc_hd__clkinvlp_4 abstract view
.subckt sky130_fd_sc_hd__clkinvlp_4 A VGND VNB VPB VPWR Y
.ends

* Black-box entry subcircuit for sky130_fd_sc_hd__nor3_4 abstract view
.subckt sky130_fd_sc_hd__nor3_4 A B C VGND VNB VPB VPWR Y
.ends

* Black-box entry subcircuit for sky130_fd_sc_hd__and2_2 abstract view
.subckt sky130_fd_sc_hd__and2_2 A B VGND VNB VPB VPWR X
.ends

* Black-box entry subcircuit for sky130_fd_sc_hd__a41o_1 abstract view
.subckt sky130_fd_sc_hd__a41o_1 A1 A2 A3 A4 B1 VGND VNB VPB VPWR X
.ends

* Black-box entry subcircuit for sky130_fd_sc_hd__o21ba_4 abstract view
.subckt sky130_fd_sc_hd__o21ba_4 A1 A2 B1_N VGND VNB VPB VPWR X
.ends

* Black-box entry subcircuit for sky130_fd_sc_hd__bufinv_16 abstract view
.subckt sky130_fd_sc_hd__bufinv_16 A VGND VNB VPB VPWR Y
.ends

* Black-box entry subcircuit for sky130_fd_sc_hd__nor3_1 abstract view
.subckt sky130_fd_sc_hd__nor3_1 A B C VGND VNB VPB VPWR Y
.ends

* Black-box entry subcircuit for sky130_fd_sc_hd__o32a_1 abstract view
.subckt sky130_fd_sc_hd__o32a_1 A1 A2 A3 B1 B2 VGND VNB VPB VPWR X
.ends

* Black-box entry subcircuit for sky130_fd_sc_hd__a311o_1 abstract view
.subckt sky130_fd_sc_hd__a311o_1 A1 A2 A3 B1 C1 VGND VNB VPB VPWR X
.ends

* Black-box entry subcircuit for sky130_fd_sc_hd__inv_6 abstract view
.subckt sky130_fd_sc_hd__inv_6 A VGND VNB VPB VPWR Y
.ends

* Black-box entry subcircuit for sky130_fd_sc_hd__o211a_1 abstract view
.subckt sky130_fd_sc_hd__o211a_1 A1 A2 B1 C1 VGND VNB VPB VPWR X
.ends

* Black-box entry subcircuit for sky130_fd_sc_hd__or4_4 abstract view
.subckt sky130_fd_sc_hd__or4_4 A B C D VGND VNB VPB VPWR X
.ends

* Black-box entry subcircuit for sky130_fd_sc_hd__nand3_1 abstract view
.subckt sky130_fd_sc_hd__nand3_1 A B C VGND VNB VPB VPWR Y
.ends

* Black-box entry subcircuit for sky130_fd_sc_hd__o2111ai_2 abstract view
.subckt sky130_fd_sc_hd__o2111ai_2 A1 A2 B1 C1 D1 VGND VNB VPB VPWR Y
.ends

* Black-box entry subcircuit for sky130_fd_sc_hd__clkinv_8 abstract view
.subckt sky130_fd_sc_hd__clkinv_8 A VGND VNB VPB VPWR Y
.ends

* Black-box entry subcircuit for sky130_fd_sc_hd__nor3_2 abstract view
.subckt sky130_fd_sc_hd__nor3_2 A B C VGND VNB VPB VPWR Y
.ends

* Black-box entry subcircuit for sky130_fd_sc_hd__clkbuf_16 abstract view
.subckt sky130_fd_sc_hd__clkbuf_16 A VGND VNB VPB VPWR X
.ends

* Black-box entry subcircuit for sky130_fd_sc_hd__a21o_2 abstract view
.subckt sky130_fd_sc_hd__a21o_2 A1 A2 B1 VGND VNB VPB VPWR X
.ends

* Black-box entry subcircuit for sky130_fd_sc_hd__clkinv_4 abstract view
.subckt sky130_fd_sc_hd__clkinv_4 A VGND VNB VPB VPWR Y
.ends

* Black-box entry subcircuit for sky130_fd_sc_hd__nand3_2 abstract view
.subckt sky130_fd_sc_hd__nand3_2 A B C VGND VNB VPB VPWR Y
.ends

* Black-box entry subcircuit for sky130_fd_sc_hd__clkinv_1 abstract view
.subckt sky130_fd_sc_hd__clkinv_1 A VGND VNB VPB VPWR Y
.ends

* Black-box entry subcircuit for sky130_fd_sc_hd__and4bb_1 abstract view
.subckt sky130_fd_sc_hd__and4bb_1 A_N B_N C D VGND VNB VPB VPWR X
.ends

* Black-box entry subcircuit for sky130_fd_sc_hd__a21oi_4 abstract view
.subckt sky130_fd_sc_hd__a21oi_4 A1 A2 B1 VGND VNB VPB VPWR Y
.ends

* Black-box entry subcircuit for sky130_fd_sc_hd__and4b_4 abstract view
.subckt sky130_fd_sc_hd__and4b_4 A_N B C D VGND VNB VPB VPWR X
.ends

* Black-box entry subcircuit for sky130_fd_sc_hd__clkinv_2 abstract view
.subckt sky130_fd_sc_hd__clkinv_2 A VGND VNB VPB VPWR Y
.ends

* Black-box entry subcircuit for sky130_fd_sc_hd__or3b_4 abstract view
.subckt sky130_fd_sc_hd__or3b_4 A B C_N VGND VNB VPB VPWR X
.ends

* Black-box entry subcircuit for sky130_fd_sc_hd__dfxtp_2 abstract view
.subckt sky130_fd_sc_hd__dfxtp_2 CLK D VGND VNB VPB VPWR Q
.ends

* Black-box entry subcircuit for sky130_fd_sc_hd__or2_2 abstract view
.subckt sky130_fd_sc_hd__or2_2 A B VGND VNB VPB VPWR X
.ends

* Black-box entry subcircuit for sky130_fd_sc_hd__and3b_2 abstract view
.subckt sky130_fd_sc_hd__and3b_2 A_N B C VGND VNB VPB VPWR X
.ends

* Black-box entry subcircuit for sky130_fd_sc_hd__dfrtp_4 abstract view
.subckt sky130_fd_sc_hd__dfrtp_4 CLK D RESET_B VGND VNB VPB VPWR Q
.ends

* Black-box entry subcircuit for sky130_fd_sc_hd__o211ai_1 abstract view
.subckt sky130_fd_sc_hd__o211ai_1 A1 A2 B1 C1 VGND VNB VPB VPWR Y
.ends

* Black-box entry subcircuit for sky130_fd_sc_hd__inv_8 abstract view
.subckt sky130_fd_sc_hd__inv_8 A VGND VNB VPB VPWR Y
.ends

* Black-box entry subcircuit for sky130_fd_sc_hd__nor4_4 abstract view
.subckt sky130_fd_sc_hd__nor4_4 A B C D VGND VNB VPB VPWR Y
.ends

* Black-box entry subcircuit for sky130_fd_sc_hd__or2b_1 abstract view
.subckt sky130_fd_sc_hd__or2b_1 A B_N VGND VNB VPB VPWR X
.ends

* Black-box entry subcircuit for sky130_fd_sc_hd__o21bai_1 abstract view
.subckt sky130_fd_sc_hd__o21bai_1 A1 A2 B1_N VGND VNB VPB VPWR Y
.ends

* Black-box entry subcircuit for sky130_fd_sc_hd__and3b_1 abstract view
.subckt sky130_fd_sc_hd__and3b_1 A_N B C VGND VNB VPB VPWR X
.ends

* Black-box entry subcircuit for sky130_fd_sc_hd__nand3b_4 abstract view
.subckt sky130_fd_sc_hd__nand3b_4 A_N B C VGND VNB VPB VPWR Y
.ends

* Black-box entry subcircuit for sky130_fd_sc_hd__nand2_2 abstract view
.subckt sky130_fd_sc_hd__nand2_2 A B VGND VNB VPB VPWR Y
.ends

* Black-box entry subcircuit for sky130_fd_sc_hd__xnor2_4 abstract view
.subckt sky130_fd_sc_hd__xnor2_4 A B VGND VNB VPB VPWR Y
.ends

* Black-box entry subcircuit for sky130_fd_sc_hd__or4_1 abstract view
.subckt sky130_fd_sc_hd__or4_1 A B C D VGND VNB VPB VPWR X
.ends

* Black-box entry subcircuit for sky130_fd_sc_hd__o2111a_1 abstract view
.subckt sky130_fd_sc_hd__o2111a_1 A1 A2 B1 C1 D1 VGND VNB VPB VPWR X
.ends

* Black-box entry subcircuit for sky130_fd_sc_hd__o21ai_2 abstract view
.subckt sky130_fd_sc_hd__o21ai_2 A1 A2 B1 VGND VNB VPB VPWR Y
.ends

* Black-box entry subcircuit for sky130_fd_sc_hd__and3_2 abstract view
.subckt sky130_fd_sc_hd__and3_2 A B C VGND VNB VPB VPWR X
.ends

* Black-box entry subcircuit for sky130_fd_sc_hd__a311oi_1 abstract view
.subckt sky130_fd_sc_hd__a311oi_1 A1 A2 A3 B1 C1 VGND VNB VPB VPWR Y
.ends

* Black-box entry subcircuit for sky130_fd_sc_hd__a311oi_2 abstract view
.subckt sky130_fd_sc_hd__a311oi_2 A1 A2 A3 B1 C1 VGND VNB VPB VPWR Y
.ends

* Black-box entry subcircuit for sky130_fd_sc_hd__or4bb_1 abstract view
.subckt sky130_fd_sc_hd__or4bb_1 A B C_N D_N VGND VNB VPB VPWR X
.ends

* Black-box entry subcircuit for sky130_fd_sc_hd__buf_6 abstract view
.subckt sky130_fd_sc_hd__buf_6 A VGND VNB VPB VPWR X
.ends

* Black-box entry subcircuit for sky130_fd_sc_hd__a2bb2o_2 abstract view
.subckt sky130_fd_sc_hd__a2bb2o_2 A1_N A2_N B1 B2 VGND VNB VPB VPWR X
.ends

* Black-box entry subcircuit for sky130_fd_sc_hd__o31ai_1 abstract view
.subckt sky130_fd_sc_hd__o31ai_1 A1 A2 A3 B1 VGND VNB VPB VPWR Y
.ends

* Black-box entry subcircuit for sky130_fd_sc_hd__nor4_2 abstract view
.subckt sky130_fd_sc_hd__nor4_2 A B C D VGND VNB VPB VPWR Y
.ends

* Black-box entry subcircuit for sky130_fd_sc_hd__o21ba_1 abstract view
.subckt sky130_fd_sc_hd__o21ba_1 A1 A2 B1_N VGND VNB VPB VPWR X
.ends

* Black-box entry subcircuit for sky130_fd_sc_hd__and4b_1 abstract view
.subckt sky130_fd_sc_hd__and4b_1 A_N B C D VGND VNB VPB VPWR X
.ends

* Black-box entry subcircuit for sky130_fd_sc_hd__nor2_4 abstract view
.subckt sky130_fd_sc_hd__nor2_4 A B VGND VNB VPB VPWR Y
.ends

* Black-box entry subcircuit for sky130_fd_sc_hd__a221o_2 abstract view
.subckt sky130_fd_sc_hd__a221o_2 A1 A2 B1 B2 C1 VGND VNB VPB VPWR X
.ends

* Black-box entry subcircuit for sky130_fd_sc_hd__or3_2 abstract view
.subckt sky130_fd_sc_hd__or3_2 A B C VGND VNB VPB VPWR X
.ends

* Black-box entry subcircuit for sky130_fd_sc_hd__nand3b_1 abstract view
.subckt sky130_fd_sc_hd__nand3b_1 A_N B C VGND VNB VPB VPWR Y
.ends

* Black-box entry subcircuit for sky130_fd_sc_hd__and4bb_2 abstract view
.subckt sky130_fd_sc_hd__and4bb_2 A_N B_N C D VGND VNB VPB VPWR X
.ends

* Black-box entry subcircuit for sky130_fd_sc_hd__o21bai_4 abstract view
.subckt sky130_fd_sc_hd__o21bai_4 A1 A2 B1_N VGND VNB VPB VPWR Y
.ends

* Black-box entry subcircuit for sky130_fd_sc_hd__nor4_1 abstract view
.subckt sky130_fd_sc_hd__nor4_1 A B C D VGND VNB VPB VPWR Y
.ends

* Black-box entry subcircuit for sky130_fd_sc_hd__nor3b_4 abstract view
.subckt sky130_fd_sc_hd__nor3b_4 A B C_N VGND VNB VPB VPWR Y
.ends

* Black-box entry subcircuit for sky130_fd_sc_hd__o22ai_1 abstract view
.subckt sky130_fd_sc_hd__o22ai_1 A1 A2 B1 B2 VGND VNB VPB VPWR Y
.ends

* Black-box entry subcircuit for sky130_fd_sc_hd__a221oi_4 abstract view
.subckt sky130_fd_sc_hd__a221oi_4 A1 A2 B1 B2 C1 VGND VNB VPB VPWR Y
.ends

* Black-box entry subcircuit for sky130_fd_sc_hd__o22a_1 abstract view
.subckt sky130_fd_sc_hd__o22a_1 A1 A2 B1 B2 VGND VNB VPB VPWR X
.ends

* Black-box entry subcircuit for sky130_fd_sc_hd__o2bb2a_1 abstract view
.subckt sky130_fd_sc_hd__o2bb2a_1 A1_N A2_N B1 B2 VGND VNB VPB VPWR X
.ends

* Black-box entry subcircuit for sky130_fd_sc_hd__o2bb2a_4 abstract view
.subckt sky130_fd_sc_hd__o2bb2a_4 A1_N A2_N B1 B2 VGND VNB VPB VPWR X
.ends

.subckt SemiCPU VGND VPWR an[0] an[1] an[2] an[3] an[4] an[5] an[6] an[7] clk control
+ reset seg[0] seg[1] seg[2] seg[3] seg[4] seg[5] seg[6]
X_2106_ net42 _0617_ VGND VGND VPWR VPWR _0704_ sky130_fd_sc_hd__nor2_1
X_2037_ _0625_ _0628_ _0634_ VGND VGND VPWR VPWR _0635_ sky130_fd_sc_hd__nand3b_2
X_3086_ display.digit_sel\[1\] display.digit_sel\[2\] _1584_ VGND VGND VPWR VPWR _1587_
+ sky130_fd_sc_hd__or3_1
XFILLER_0_27_82 VGND VGND VPWR VPWR sky130_fd_sc_hd__fill_1
X_3155_ _1648_ _1616_ _1651_ VGND VGND VPWR VPWR _1652_ sky130_fd_sc_hd__and3_1
X_2939_ _1483_ VGND VGND VPWR VPWR _1495_ sky130_fd_sc_hd__clkbuf_2
XFILLER_0_9_444 VGND VGND VPWR VPWR sky130_fd_sc_hd__decap_4
XFILLER_0_17_200 VGND VGND VPWR VPWR sky130_fd_sc_hd__decap_8
XTAP_TAPCELL_ROW_20_312 VGND VPWR sky130_fd_sc_hd__tapvpwrvgnd_1
XFILLER_0_32_247 VGND VGND VPWR VPWR sky130_fd_sc_hd__fill_1
XFILLER_0_7_81 VPWR VGND VPWR VGND sky130_ef_sc_hd__decap_12
XFILLER_0_40_291 VGND VGND VPWR VPWR sky130_fd_sc_hd__decap_3
XTAP_TAPCELL_ROW_71_735 VGND VPWR sky130_fd_sc_hd__tapvpwrvgnd_1
XTAP_TAPCELL_ROW_71_724 VGND VPWR sky130_fd_sc_hd__tapvpwrvgnd_1
XFILLER_0_70_309 VPWR VGND VPWR VGND sky130_ef_sc_hd__decap_12
Xrebuffer7 net22 VGND VGND VPWR VPWR net23 sky130_fd_sc_hd__dlymetal6s4s_1
XFILLER_0_23_225 VPWR VGND VPWR VGND sky130_ef_sc_hd__decap_12
XFILLER_0_3_39 VPWR VGND VPWR VGND sky130_ef_sc_hd__decap_12
XFILLER_0_58_111 VGND VGND VPWR VPWR sky130_fd_sc_hd__fill_1
XTAP_TAPCELL_ROW_34_426 VGND VPWR sky130_fd_sc_hd__tapvpwrvgnd_1
XFILLER_0_13_51 VGND VGND VPWR VPWR sky130_fd_sc_hd__decap_4
XTAP_TAPCELL_ROW_42_492 VGND VPWR sky130_fd_sc_hd__tapvpwrvgnd_1
X_2724_ _1128_ _1225_ _1230_ _1145_ _1140_ VGND VGND VPWR VPWR _1315_ sky130_fd_sc_hd__o221a_1
X_2655_ _1239_ _1243_ _1246_ _1248_ VGND VGND VPWR VPWR _1249_ sky130_fd_sc_hd__a2bb2o_1
XFILLER_0_6_447 VGND VGND VPWR VPWR sky130_fd_sc_hd__fill_1
X_2586_ _1181_ VGND VGND VPWR VPWR _1182_ sky130_fd_sc_hd__inv_2
X_3207_ display.counter\[15\] _1680_ VGND VGND VPWR VPWR _1682_ sky130_fd_sc_hd__and2_1
X_3069_ _1571_ _1176_ _1004_ VGND VGND VPWR VPWR _1572_ sky130_fd_sc_hd__mux2_1
XFILLER_0_49_155 VGND VGND VPWR VPWR sky130_fd_sc_hd__decap_3
XFILLER_0_49_133 VGND VGND VPWR VPWR sky130_fd_sc_hd__fill_2
X_3138_ _1557_ _1558_ VGND VGND VPWR VPWR _0412_ sky130_fd_sc_hd__nand2_1
XFILLER_0_60_320 VGND VGND VPWR VPWR sky130_fd_sc_hd__fill_1
XFILLER_0_49_177 VGND VGND VPWR VPWR sky130_fd_sc_hd__decap_8
XFILLER_0_37_328 VGND VGND VPWR VPWR sky130_fd_sc_hd__decap_8
XTAP_TAPCELL_ROW_5_195 VGND VPWR sky130_fd_sc_hd__tapvpwrvgnd_1
XFILLER_0_18_29 VPWR VGND VPWR VGND sky130_ef_sc_hd__decap_12
XFILLER_0_50_27 VGND VGND VPWR VPWR sky130_fd_sc_hd__fill_1
XTAP_TAPCELL_ROW_31_407 VGND VPWR sky130_fd_sc_hd__tapvpwrvgnd_1
XFILLER_0_28_339 VGND VGND VPWR VPWR sky130_fd_sc_hd__decap_3
XFILLER_0_51_386 VGND VGND VPWR VPWR sky130_fd_sc_hd__decap_6
X_2440_ _0803_ _0847_ _0995_ VGND VGND VPWR VPWR _1038_ sky130_fd_sc_hd__mux2_1
XFILLER_0_36_372 VGND VGND VPWR VPWR sky130_fd_sc_hd__decap_6
XFILLER_0_36_361 VGND VGND VPWR VPWR sky130_fd_sc_hd__decap_3
XFILLER_0_3_417 VPWR VGND VPWR VGND sky130_ef_sc_hd__decap_12
XFILLER_0_11_217 VGND VGND VPWR VPWR sky130_fd_sc_hd__decap_6
X_2371_ _0967_ _0687_ VGND VGND VPWR VPWR _0969_ sky130_fd_sc_hd__and2b_1
XFILLER_0_19_306 VGND VGND VPWR VPWR sky130_fd_sc_hd__decap_4
XFILLER_0_46_125 VGND VGND VPWR VPWR sky130_fd_sc_hd__decap_8
XFILLER_0_34_309 VPWR VGND VPWR VGND sky130_ef_sc_hd__decap_12
XFILLER_0_6_233 VPWR VGND VPWR VGND sky130_ef_sc_hd__decap_12
XFILLER_0_6_277 VPWR VGND VPWR VGND sky130_ef_sc_hd__decap_12
XFILLER_0_71_3 VPWR VGND VPWR VGND sky130_ef_sc_hd__decap_12
X_2569_ _1163_ _1164_ _1152_ VGND VGND VPWR VPWR _1165_ sky130_fd_sc_hd__mux2_1
X_2707_ _0914_ _0913_ _1155_ VGND VGND VPWR VPWR _1299_ sky130_fd_sc_hd__mux2_1
X_2638_ _1209_ _1065_ _1210_ _1232_ VGND VGND VPWR VPWR _1233_ sky130_fd_sc_hd__a31o_1
XTAP_TAPCELL_ROW_53_576 VGND VPWR sky130_fd_sc_hd__tapvpwrvgnd_1
XFILLER_0_37_125 VGND VGND VPWR VPWR sky130_fd_sc_hd__decap_8
XFILLER_0_37_169 VPWR VGND VPWR VGND sky130_ef_sc_hd__decap_12
XTAP_TAPCELL_ROW_44_510 VGND VPWR sky130_fd_sc_hd__tapvpwrvgnd_1
XFILLER_0_0_29 VPWR VGND VPWR VGND sky130_ef_sc_hd__decap_12
X_1940_ reg_file.registers\[10\]\[7\] _0539_ VGND VGND VPWR VPWR _0546_ sky130_fd_sc_hd__and2_1
XFILLER_0_61_48 VGND VGND VPWR VPWR sky130_fd_sc_hd__decap_3
XFILLER_0_61_26 VGND VGND VPWR VPWR sky130_fd_sc_hd__fill_1
X_1871_ _0509_ VGND VGND VPWR VPWR _0350_ sky130_fd_sc_hd__clkbuf_1
XFILLER_0_43_139 VGND VGND VPWR VPWR sky130_fd_sc_hd__fill_2
X_3610_ clknet_leaf_1_clk _0372_ _0183_ VGND VGND VPWR VPWR reg_file.registers\[5\]\[30\]
+ sky130_fd_sc_hd__dfrtp_1
XFILLER_0_9_27 VPWR VGND VPWR VGND sky130_ef_sc_hd__decap_12
XFILLER_0_16_309 VGND VGND VPWR VPWR sky130_fd_sc_hd__decap_6
X_3472_ clknet_leaf_6_clk _0241_ _0052_ VGND VGND VPWR VPWR imem.address\[27\] sky130_fd_sc_hd__dfrtp_1
XFILLER_0_51_194 VGND VGND VPWR VPWR sky130_fd_sc_hd__fill_2
XFILLER_0_3_225 VPWR VGND VPWR VGND sky130_ef_sc_hd__decap_12
XFILLER_0_10_41 VPWR VGND VPWR VGND sky130_ef_sc_hd__decap_12
XFILLER_0_10_85 VPWR VGND VPWR VGND sky130_ef_sc_hd__decap_12
X_3541_ clknet_leaf_19_clk _0303_ _0114_ VGND VGND VPWR VPWR reg_file.registers\[11\]\[25\]
+ sky130_fd_sc_hd__dfrtp_1
X_2423_ _1020_ _0699_ _0996_ VGND VGND VPWR VPWR _1021_ sky130_fd_sc_hd__mux2_1
X_2285_ _0659_ VGND VGND VPWR VPWR _0883_ sky130_fd_sc_hd__inv_2
X_2354_ _0950_ _0951_ VGND VGND VPWR VPWR _0952_ sky130_fd_sc_hd__and2_1
XFILLER_0_66_209 VGND VGND VPWR VPWR sky130_fd_sc_hd__decap_6
XTAP_TAPCELL_ROW_50_557 VGND VPWR sky130_fd_sc_hd__tapvpwrvgnd_1
XFILLER_0_42_161 VGND VGND VPWR VPWR sky130_fd_sc_hd__decap_4
XTAP_TAPCELL_ROW_7_213 VGND VPWR sky130_fd_sc_hd__tapvpwrvgnd_1
XFILLER_0_38_412 VGND VGND VPWR VPWR sky130_fd_sc_hd__decap_8
XTAP_TAPCELL_ROW_13_259 VGND VPWR sky130_fd_sc_hd__tapvpwrvgnd_1
XFILLER_0_56_15 VGND VGND VPWR VPWR sky130_fd_sc_hd__decap_8
X_2070_ _0575_ _0664_ _0667_ VGND VGND VPWR VPWR _0668_ sky130_fd_sc_hd__a21oi_1
XFILLER_0_56_220 VGND VGND VPWR VPWR sky130_fd_sc_hd__decap_4
X_2972_ reg_file.registers\[15\]\[5\] _1483_ VGND VGND VPWR VPWR _1512_ sky130_fd_sc_hd__and2_1
XFILLER_0_8_306 VGND VGND VPWR VPWR sky130_fd_sc_hd__fill_2
X_1785_ imem.address\[5\] imem.address\[3\] imem.address\[2\] imem.address\[4\] VGND
+ VGND VPWR VPWR _0447_ sky130_fd_sc_hd__or4b_1
XFILLER_0_56_253 VPWR VGND VPWR VGND sky130_ef_sc_hd__decap_12
X_1923_ reg_file.registers\[10\]\[15\] _0528_ VGND VGND VPWR VPWR _0537_ sky130_fd_sc_hd__and2_1
X_1854_ _0500_ VGND VGND VPWR VPWR _0358_ sky130_fd_sc_hd__clkbuf_1
XFILLER_0_31_109 VGND VGND VPWR VPWR sky130_fd_sc_hd__decap_3
XFILLER_0_21_51 VGND VGND VPWR VPWR sky130_fd_sc_hd__fill_1
X_3455_ clknet_leaf_9_clk _0224_ _0035_ VGND VGND VPWR VPWR imem.address\[10\] sky130_fd_sc_hd__dfrtp_1
X_3524_ clknet_leaf_12_clk _0286_ _0097_ VGND VGND VPWR VPWR reg_file.registers\[11\]\[8\]
+ sky130_fd_sc_hd__dfrtp_2
X_2406_ _1003_ VGND VGND VPWR VPWR _1004_ sky130_fd_sc_hd__clkbuf_4
X_3386_ _1712_ VGND VGND VPWR VPWR _0169_ sky130_fd_sc_hd__inv_2
X_2199_ _0789_ _0793_ _0796_ VGND VGND VPWR VPWR _0797_ sky130_fd_sc_hd__and3_1
XFILLER_0_34_3 VPWR VGND VPWR VGND sky130_ef_sc_hd__decap_12
X_2268_ _0858_ _0861_ _0864_ VGND VGND VPWR VPWR _0866_ sky130_fd_sc_hd__a21oi_2
X_2337_ _0933_ _0934_ VGND VGND VPWR VPWR _0935_ sky130_fd_sc_hd__xnor2_1
XTAP_TAPCELL_ROW_63_660 VGND VPWR sky130_fd_sc_hd__tapvpwrvgnd_1
XFILLER_0_47_264 VGND VGND VPWR VPWR sky130_fd_sc_hd__fill_1
XFILLER_0_30_131 VGND VGND VPWR VPWR sky130_fd_sc_hd__fill_1
XFILLER_0_7_372 VPWR VGND VPWR VGND sky130_ef_sc_hd__decap_12
XTAP_TAPCELL_ROW_26_362 VGND VPWR sky130_fd_sc_hd__tapvpwrvgnd_1
XFILLER_0_38_297 VGND VGND VPWR VPWR sky130_fd_sc_hd__decap_8
XFILLER_0_38_286 VGND VGND VPWR VPWR sky130_fd_sc_hd__decap_4
XFILLER_0_38_253 VPWR VGND VPWR VGND sky130_ef_sc_hd__decap_12
X_3240_ _1694_ VGND VGND VPWR VPWR _0041_ sky130_fd_sc_hd__inv_2
XTAP_TAPCELL_ROW_69_708 VGND VPWR sky130_fd_sc_hd__tapvpwrvgnd_1
X_2122_ reg_file.registers\[11\]\[2\] _0691_ _0696_ reg_file.registers\[10\]\[2\]
+ VGND VGND VPWR VPWR _0720_ sky130_fd_sc_hd__a22oi_2
Xrebuffer39 net54 VGND VGND VPWR VPWR net55 sky130_fd_sc_hd__dlygate4sd1_1
Xrebuffer28 _0600_ VGND VGND VPWR VPWR net44 sky130_fd_sc_hd__dlygate4sd1_1
X_2053_ reg_file.registers\[2\]\[16\] _0558_ VGND VGND VPWR VPWR _0651_ sky130_fd_sc_hd__and2_1
Xrebuffer17 net34 VGND VGND VPWR VPWR net33 sky130_fd_sc_hd__dlymetal6s4s_1
X_3171_ _1661_ _1662_ _1650_ VGND VGND VPWR VPWR _0005_ sky130_fd_sc_hd__a21o_1
X_2955_ _1503_ VGND VGND VPWR VPWR _0260_ sky130_fd_sc_hd__clkbuf_1
XFILLER_0_32_83 VGND VGND VPWR VPWR sky130_fd_sc_hd__fill_1
X_1906_ _0518_ VGND VGND VPWR VPWR _0528_ sky130_fd_sc_hd__buf_2
X_2886_ _0757_ _1456_ _0764_ _1063_ VGND VGND VPWR VPWR _1458_ sky130_fd_sc_hd__o31a_1
X_1768_ _0438_ VGND VGND VPWR VPWR _0382_ sky130_fd_sc_hd__clkbuf_1
X_3507_ clknet_leaf_21_clk _0269_ _0080_ VGND VGND VPWR VPWR reg_file.registers\[15\]\[23\]
+ sky130_fd_sc_hd__dfrtp_1
XFILLER_0_12_153 VPWR VGND VPWR VGND sky130_ef_sc_hd__decap_12
X_1837_ _0491_ VGND VGND VPWR VPWR _0366_ sky130_fd_sc_hd__clkbuf_1
X_3369_ _1711_ VGND VGND VPWR VPWR _0153_ sky130_fd_sc_hd__inv_2
X_3438_ _1719_ VGND VGND VPWR VPWR _0214_ sky130_fd_sc_hd__inv_2
XFILLER_0_12_197 VPWR VGND VPWR VGND sky130_ef_sc_hd__decap_12
XTAP_TAPCELL_ROW_23_343 VGND VPWR sky130_fd_sc_hd__tapvpwrvgnd_1
XFILLER_0_50_226 VPWR VGND VPWR VGND sky130_ef_sc_hd__decap_12
Xoutput7 net7 VGND VGND VPWR VPWR an[5] sky130_fd_sc_hd__buf_1
XFILLER_0_58_315 VGND VGND VPWR VPWR sky130_fd_sc_hd__decap_3
XFILLER_0_53_38 VGND VGND VPWR VPWR sky130_fd_sc_hd__fill_2
XFILLER_0_53_49 VGND VGND VPWR VPWR sky130_fd_sc_hd__decap_6
X_2671_ _1261_ _1263_ _1003_ VGND VGND VPWR VPWR _1264_ sky130_fd_sc_hd__mux2_1
XFILLER_0_41_237 VPWR VGND VPWR VGND sky130_ef_sc_hd__decap_12
X_2740_ _1015_ _1044_ _0991_ VGND VGND VPWR VPWR _1330_ sky130_fd_sc_hd__mux2_1
X_3223_ _1691_ VGND VGND VPWR VPWR _1692_ sky130_fd_sc_hd__buf_2
X_3085_ _0477_ _0410_ VGND VGND VPWR VPWR _1586_ sky130_fd_sc_hd__nor2_1
X_2036_ _0573_ _0630_ _0633_ _0578_ VGND VGND VPWR VPWR _0634_ sky130_fd_sc_hd__a211oi_2
XFILLER_0_27_72 VGND VGND VPWR VPWR sky130_fd_sc_hd__fill_1
X_2105_ _0701_ _0702_ VGND VGND VPWR VPWR _0703_ sky130_fd_sc_hd__xnor2_1
X_3154_ _1634_ _1644_ VGND VGND VPWR VPWR _1651_ sky130_fd_sc_hd__and2_1
X_2938_ _1494_ VGND VGND VPWR VPWR _0268_ sky130_fd_sc_hd__clkbuf_1
XFILLER_0_9_423 VGND VGND VPWR VPWR sky130_fd_sc_hd__fill_2
XTAP_TAPCELL_ROW_20_313 VGND VPWR sky130_fd_sc_hd__tapvpwrvgnd_1
X_2869_ _1064_ _1399_ _1443_ _1140_ _1312_ VGND VGND VPWR VPWR _1444_ sky130_fd_sc_hd__a32o_1
XFILLER_0_7_93 VPWR VGND VPWR VGND sky130_ef_sc_hd__decap_12
XTAP_TAPCELL_ROW_71_725 VGND VPWR sky130_fd_sc_hd__tapvpwrvgnd_1
XFILLER_0_67_167 VGND VGND VPWR VPWR sky130_fd_sc_hd__fill_1
XFILLER_0_55_318 VGND VGND VPWR VPWR sky130_fd_sc_hd__fill_1
Xrebuffer8 _0461_ VGND VGND VPWR VPWR net24 sky130_fd_sc_hd__dlygate4sd1_1
XPHY_EDGE_ROW_39_Left_111 VGND VGND VPWR VPWR sky130_fd_sc_hd__decap_3
XFILLER_0_23_237 VPWR VGND VPWR VGND sky130_ef_sc_hd__decap_12
XFILLER_0_23_215 VGND VGND VPWR VPWR sky130_fd_sc_hd__decap_8
XFILLER_0_2_109 VPWR VGND VPWR VGND sky130_ef_sc_hd__decap_12
XPHY_EDGE_ROW_48_Left_120 VGND VGND VPWR VPWR sky130_fd_sc_hd__decap_3
XFILLER_0_54_351 VGND VGND VPWR VPWR sky130_fd_sc_hd__decap_3
XFILLER_0_46_307 VGND VGND VPWR VPWR sky130_fd_sc_hd__fill_1
XTAP_TAPCELL_ROW_42_493 VGND VPWR sky130_fd_sc_hd__tapvpwrvgnd_1
X_2723_ _0991_ _1313_ VGND VGND VPWR VPWR _1314_ sky130_fd_sc_hd__nand2_1
XTAP_TAPCELL_ROW_34_427 VGND VPWR sky130_fd_sc_hd__tapvpwrvgnd_1
XFILLER_0_6_426 VGND VGND VPWR VPWR sky130_fd_sc_hd__fill_1
X_2585_ _1002_ _1180_ VGND VGND VPWR VPWR _1181_ sky130_fd_sc_hd__or2_1
X_2654_ _0991_ _1247_ VGND VGND VPWR VPWR _1248_ sky130_fd_sc_hd__nand2_1
XFILLER_0_14_248 VGND VGND VPWR VPWR sky130_fd_sc_hd__decap_4
XFILLER_0_38_82 VGND VGND VPWR VPWR sky130_fd_sc_hd__fill_2
X_3137_ _0477_ _0411_ VGND VGND VPWR VPWR _1635_ sky130_fd_sc_hd__nor2_1
X_3206_ _1680_ _1681_ VGND VGND VPWR VPWR _0012_ sky130_fd_sc_hd__nor2_1
X_3068_ _1168_ VGND VGND VPWR VPWR _1571_ sky130_fd_sc_hd__inv_2
X_2019_ net48 _0616_ VGND VGND VPWR VPWR _0617_ sky130_fd_sc_hd__nor2_1
XFILLER_0_49_189 VGND VGND VPWR VPWR sky130_fd_sc_hd__fill_1
XFILLER_0_60_365 VGND VGND VPWR VPWR sky130_fd_sc_hd__decap_6
XFILLER_0_13_281 VGND VGND VPWR VPWR sky130_fd_sc_hd__decap_8
XFILLER_0_68_421 VPWR VGND VPWR VGND sky130_ef_sc_hd__decap_12
XTAP_TAPCELL_ROW_5_196 VGND VPWR sky130_fd_sc_hd__tapvpwrvgnd_1
XFILLER_0_63_181 VGND VGND VPWR VPWR sky130_fd_sc_hd__decap_3
XFILLER_0_3_429 VPWR VGND VPWR VGND sky130_ef_sc_hd__decap_12
X_2370_ _0687_ _0967_ VGND VGND VPWR VPWR _0968_ sky130_fd_sc_hd__and2b_1
XFILLER_0_59_443 VGND VGND VPWR VPWR sky130_fd_sc_hd__decap_4
XTAP_TAPCELL_ROW_47_530 VGND VPWR sky130_fd_sc_hd__tapvpwrvgnd_1
X_2706_ _1297_ VGND VGND VPWR VPWR _1298_ sky130_fd_sc_hd__inv_2
XFILLER_0_42_365 VPWR VGND VPWR VGND sky130_ef_sc_hd__decap_12
XFILLER_0_6_245 VGND VGND VPWR VPWR sky130_fd_sc_hd__decap_6
XFILLER_0_6_289 VPWR VGND VPWR VGND sky130_ef_sc_hd__decap_12
XFILLER_0_64_3 VPWR VGND VPWR VGND sky130_ef_sc_hd__decap_12
X_2499_ _1095_ VGND VGND VPWR VPWR _1096_ sky130_fd_sc_hd__inv_2
X_2568_ reg_file.registers\[11\]\[9\] _0790_ _0791_ reg_file.registers\[10\]\[9\]
+ VGND VGND VPWR VPWR _1164_ sky130_fd_sc_hd__a22o_1
X_2637_ _1067_ _1221_ _1227_ _1231_ VGND VGND VPWR VPWR _1232_ sky130_fd_sc_hd__o22ai_2
XFILLER_0_10_251 VGND VGND VPWR VPWR sky130_fd_sc_hd__fill_1
XPHY_EDGE_ROW_12_Right_12 VGND VGND VPWR VPWR sky130_fd_sc_hd__decap_3
XFILLER_0_4_83 VGND VGND VPWR VPWR sky130_fd_sc_hd__fill_1
XPHY_EDGE_ROW_21_Right_21 VGND VGND VPWR VPWR sky130_fd_sc_hd__decap_3
XTAP_TAPCELL_ROW_53_577 VGND VPWR sky130_fd_sc_hd__tapvpwrvgnd_1
XFILLER_0_18_362 VGND VGND VPWR VPWR sky130_fd_sc_hd__fill_2
XFILLER_0_60_195 VGND VGND VPWR VPWR sky130_fd_sc_hd__fill_1
XFILLER_0_33_354 VGND VGND VPWR VPWR sky130_fd_sc_hd__decap_3
XPHY_EDGE_ROW_30_Right_30 VGND VGND VPWR VPWR sky130_fd_sc_hd__decap_3
XTAP_TAPCELL_ROW_44_511 VGND VPWR sky130_fd_sc_hd__tapvpwrvgnd_1
XFILLER_0_71_449 VGND VGND VPWR VPWR sky130_fd_sc_hd__fill_2
XFILLER_0_71_405 VPWR VGND VPWR VGND sky130_ef_sc_hd__decap_12
X_1870_ reg_file.registers\[5\]\[8\] _0504_ VGND VGND VPWR VPWR _0509_ sky130_fd_sc_hd__and2_1
XFILLER_0_9_39 VPWR VGND VPWR VGND sky130_ef_sc_hd__decap_12
X_3540_ clknet_leaf_16_clk _0302_ _0113_ VGND VGND VPWR VPWR reg_file.registers\[11\]\[24\]
+ sky130_fd_sc_hd__dfrtp_1
X_3471_ clknet_leaf_6_clk _0240_ _0051_ VGND VGND VPWR VPWR imem.address\[26\] sky130_fd_sc_hd__dfrtp_1
XFILLER_0_24_365 VPWR VGND VPWR VGND sky130_ef_sc_hd__decap_12
XPHY_EDGE_ROW_24_Left_96 VGND VGND VPWR VPWR sky130_fd_sc_hd__decap_3
XFILLER_0_3_237 VPWR VGND VPWR VGND sky130_ef_sc_hd__decap_12
XFILLER_0_10_53 VPWR VGND VPWR VGND sky130_ef_sc_hd__decap_12
XFILLER_0_10_97 VPWR VGND VPWR VGND sky130_ef_sc_hd__decap_12
X_2353_ reg_file.registers\[11\]\[26\] _0694_ _0698_ reg_file.registers\[10\]\[26\]
+ VGND VGND VPWR VPWR _0951_ sky130_fd_sc_hd__a22oi_4
X_2422_ _0702_ VGND VGND VPWR VPWR _1020_ sky130_fd_sc_hd__inv_2
X_2284_ _0867_ _0872_ _0876_ _0881_ VGND VGND VPWR VPWR _0882_ sky130_fd_sc_hd__nand4_2
XFILLER_0_19_62 VPWR VGND VPWR VGND sky130_ef_sc_hd__decap_12
XTAP_TAPCELL_ROW_50_558 VGND VPWR sky130_fd_sc_hd__tapvpwrvgnd_1
X_1999_ _0555_ _0596_ _0467_ VGND VGND VPWR VPWR _0597_ sky130_fd_sc_hd__o21a_4
X_3669_ clknet_leaf_11_clk _0411_ VGND VGND VPWR VPWR net5 sky130_fd_sc_hd__dfxtp_1
XFILLER_0_42_195 VGND VGND VPWR VPWR sky130_fd_sc_hd__fill_1
XFILLER_0_30_346 VGND VGND VPWR VPWR sky130_fd_sc_hd__decap_4
XTAP_TAPCELL_ROW_7_214 VGND VPWR sky130_fd_sc_hd__tapvpwrvgnd_1
XTAP_TAPCELL_ROW_66_680 VGND VPWR sky130_fd_sc_hd__tapvpwrvgnd_1
XFILLER_0_53_449 VGND VGND VPWR VPWR sky130_fd_sc_hd__fill_2
XFILLER_0_53_405 VGND VGND VPWR VPWR sky130_fd_sc_hd__decap_4
XFILLER_0_18_192 VGND VGND VPWR VPWR sky130_fd_sc_hd__decap_4
XFILLER_0_33_151 VGND VGND VPWR VPWR sky130_fd_sc_hd__decap_4
XFILLER_0_21_335 VGND VGND VPWR VPWR sky130_fd_sc_hd__fill_1
XFILLER_0_56_49 VGND VGND VPWR VPWR sky130_fd_sc_hd__fill_1
XFILLER_0_56_265 VGND VGND VPWR VPWR sky130_fd_sc_hd__fill_2
X_2971_ _1511_ VGND VGND VPWR VPWR _0252_ sky130_fd_sc_hd__clkbuf_1
X_1922_ _0536_ VGND VGND VPWR VPWR _0326_ sky130_fd_sc_hd__clkbuf_1
X_1784_ _0446_ VGND VGND VPWR VPWR _0374_ sky130_fd_sc_hd__clkbuf_1
X_3523_ clknet_leaf_11_clk _0285_ _0096_ VGND VGND VPWR VPWR reg_file.registers\[11\]\[7\]
+ sky130_fd_sc_hd__dfrtp_1
XFILLER_0_56_276 VPWR VGND VPWR VGND sky130_ef_sc_hd__decap_12
X_1853_ reg_file.registers\[5\]\[16\] _0493_ VGND VGND VPWR VPWR _0500_ sky130_fd_sc_hd__and2_1
XFILLER_0_24_162 VGND VGND VPWR VPWR sky130_fd_sc_hd__decap_3
XFILLER_0_12_313 VGND VGND VPWR VPWR sky130_fd_sc_hd__fill_1
XFILLER_0_21_63 VGND VGND VPWR VPWR sky130_fd_sc_hd__fill_2
X_3454_ clknet_leaf_9_clk _0223_ _0034_ VGND VGND VPWR VPWR imem.address\[9\] sky130_fd_sc_hd__dfrtp_1
X_2405_ _1002_ VGND VGND VPWR VPWR _1003_ sky130_fd_sc_hd__clkbuf_4
X_3385_ _1712_ VGND VGND VPWR VPWR _0168_ sky130_fd_sc_hd__inv_2
X_2336_ reg_file.registers\[11\]\[24\] _0694_ _0698_ reg_file.registers\[10\]\[24\]
+ VGND VGND VPWR VPWR _0934_ sky130_fd_sc_hd__a22o_2
XFILLER_0_46_93 VGND VGND VPWR VPWR sky130_fd_sc_hd__fill_2
X_2198_ _0794_ _0795_ VGND VGND VPWR VPWR _0796_ sky130_fd_sc_hd__xnor2_1
XFILLER_0_27_3 VPWR VGND VPWR VGND sky130_ef_sc_hd__decap_12
X_2267_ _0858_ _0861_ _0864_ VGND VGND VPWR VPWR _0865_ sky130_fd_sc_hd__and3_1
XFILLER_0_1_51 VGND VGND VPWR VPWR sky130_fd_sc_hd__decap_4
XTAP_TAPCELL_ROW_63_661 VGND VPWR sky130_fd_sc_hd__tapvpwrvgnd_1
XFILLER_0_62_246 VGND VGND VPWR VPWR sky130_fd_sc_hd__fill_2
XFILLER_0_35_449 VGND VGND VPWR VPWR sky130_fd_sc_hd__fill_2
XFILLER_0_35_427 VGND VGND VPWR VPWR sky130_fd_sc_hd__fill_1
XFILLER_0_50_419 VGND VGND VPWR VPWR sky130_fd_sc_hd__fill_1
XFILLER_0_30_165 VPWR VGND VPWR VGND sky130_ef_sc_hd__decap_12
XFILLER_0_42_29 VGND VGND VPWR VPWR sky130_fd_sc_hd__fill_2
XFILLER_0_38_265 VPWR VGND VPWR VGND sky130_ef_sc_hd__decap_12
XTAP_TAPCELL_ROW_26_363 VGND VPWR sky130_fd_sc_hd__tapvpwrvgnd_1
XFILLER_0_53_202 VPWR VGND VPWR VGND sky130_ef_sc_hd__decap_12
XFILLER_0_41_408 VGND VGND VPWR VPWR sky130_fd_sc_hd__fill_1
XTAP_TAPCELL_ROW_69_709 VGND VPWR sky130_fd_sc_hd__tapvpwrvgnd_1
XFILLER_0_6_29 VPWR VGND VPWR VGND sky130_ef_sc_hd__decap_12
X_3170_ _1616_ _1651_ _1608_ VGND VGND VPWR VPWR _1662_ sky130_fd_sc_hd__o21a_1
XFILLER_0_21_165 VGND VGND VPWR VPWR sky130_fd_sc_hd__decap_3
XFILLER_0_21_198 VPWR VGND VPWR VGND sky130_ef_sc_hd__decap_12
Xrebuffer29 net44 VGND VGND VPWR VPWR net45 sky130_fd_sc_hd__dlygate4sd1_1
X_2121_ _0597_ _0718_ VGND VGND VPWR VPWR _0719_ sky130_fd_sc_hd__xnor2_1
X_2052_ reg_file.registers\[5\]\[19\] _0564_ _0567_ reg_file.registers\[15\]\[19\]
+ _0649_ VGND VGND VPWR VPWR _0650_ sky130_fd_sc_hd__a221o_1
Xrebuffer18 _0912_ VGND VGND VPWR VPWR net34 sky130_fd_sc_hd__clkbuf_1
XFILLER_0_16_41 VGND VGND VPWR VPWR sky130_fd_sc_hd__fill_2
XFILLER_0_16_74 VGND VGND VPWR VPWR sky130_fd_sc_hd__fill_2
XFILLER_0_16_85 VGND VGND VPWR VPWR sky130_fd_sc_hd__decap_3
X_2885_ _0757_ _1456_ _0764_ VGND VGND VPWR VPWR _1457_ sky130_fd_sc_hd__o21ai_1
XFILLER_0_44_224 VPWR VGND VPWR VGND sky130_ef_sc_hd__decap_12
X_2954_ reg_file.registers\[15\]\[14\] _1495_ VGND VGND VPWR VPWR _1503_ sky130_fd_sc_hd__and2_1
XFILLER_0_32_95 VGND VGND VPWR VPWR sky130_fd_sc_hd__decap_8
X_1905_ _0527_ VGND VGND VPWR VPWR _0334_ sky130_fd_sc_hd__clkbuf_1
XFILLER_0_17_449 VGND VGND VPWR VPWR sky130_fd_sc_hd__fill_2
X_1767_ reg_file.registers\[2\]\[9\] VGND VGND VPWR VPWR _0438_ sky130_fd_sc_hd__clkbuf_1
XFILLER_0_40_441 VGND VGND VPWR VPWR sky130_fd_sc_hd__decap_6
X_3506_ clknet_leaf_21_clk _0268_ _0079_ VGND VGND VPWR VPWR reg_file.registers\[15\]\[22\]
+ sky130_fd_sc_hd__dfrtp_1
XFILLER_0_4_365 VPWR VGND VPWR VGND sky130_ef_sc_hd__decap_12
XFILLER_0_4_321 VPWR VGND VPWR VGND sky130_ef_sc_hd__decap_12
XPHY_EDGE_ROW_6_Right_6 VGND VGND VPWR VPWR sky130_fd_sc_hd__decap_3
XFILLER_0_12_165 VPWR VGND VPWR VGND sky130_ef_sc_hd__decap_12
X_1836_ reg_file.registers\[5\]\[24\] _0483_ VGND VGND VPWR VPWR _0491_ sky130_fd_sc_hd__and2_1
X_3299_ _1702_ VGND VGND VPWR VPWR _0092_ sky130_fd_sc_hd__inv_2
X_3368_ _1710_ VGND VGND VPWR VPWR _1711_ sky130_fd_sc_hd__buf_4
X_2319_ reg_file.registers\[11\]\[18\] _0862_ _0863_ reg_file.registers\[10\]\[18\]
+ VGND VGND VPWR VPWR _0917_ sky130_fd_sc_hd__a22o_1
X_3437_ _1719_ VGND VGND VPWR VPWR _0213_ sky130_fd_sc_hd__inv_2
XPHY_EDGE_ROW_11_Left_83 VGND VGND VPWR VPWR sky130_fd_sc_hd__decap_3
XFILLER_0_50_238 VPWR VGND VPWR VGND sky130_ef_sc_hd__decap_12
XFILLER_0_35_279 VGND VGND VPWR VPWR sky130_fd_sc_hd__fill_1
XFILLER_0_7_181 VPWR VGND VPWR VGND sky130_ef_sc_hd__decap_12
Xoutput8 net8 VGND VGND VPWR VPWR an[6] sky130_fd_sc_hd__buf_1
Xoutput10 net10 VGND VGND VPWR VPWR seg[0] sky130_fd_sc_hd__buf_1
XPHY_EDGE_ROW_59_Right_59 VGND VGND VPWR VPWR sky130_fd_sc_hd__decap_3
X_2670_ _1262_ _0755_ _0994_ VGND VGND VPWR VPWR _1263_ sky130_fd_sc_hd__mux2_1
XFILLER_0_41_249 VGND VGND VPWR VPWR sky130_fd_sc_hd__fill_2
XFILLER_0_41_205 VGND VGND VPWR VPWR sky130_fd_sc_hd__decap_6
XFILLER_0_1_335 VGND VGND VPWR VPWR sky130_fd_sc_hd__fill_1
XFILLER_0_14_408 VGND VGND VPWR VPWR sky130_fd_sc_hd__fill_1
XPHY_EDGE_ROW_68_Right_68 VGND VGND VPWR VPWR sky130_fd_sc_hd__decap_3
X_3222_ reset VGND VGND VPWR VPWR _1691_ sky130_fd_sc_hd__dlymetal6s2s_1
X_3153_ _1648_ _1649_ _1645_ VGND VGND VPWR VPWR _1650_ sky130_fd_sc_hd__and3_1
X_2104_ reg_file.registers\[11\]\[28\] _0694_ _0698_ reg_file.registers\[10\]\[28\]
+ VGND VGND VPWR VPWR _0702_ sky130_fd_sc_hd__a22oi_4
X_2035_ _0572_ _0632_ VGND VGND VPWR VPWR _0633_ sky130_fd_sc_hd__and2_1
X_3084_ _1585_ VGND VGND VPWR VPWR _0410_ sky130_fd_sc_hd__buf_1
XFILLER_0_57_393 VPWR VGND VPWR VGND sky130_ef_sc_hd__decap_12
X_2868_ _0708_ _0774_ _0828_ VGND VGND VPWR VPWR _1443_ sky130_fd_sc_hd__o21ai_1
X_2937_ reg_file.registers\[15\]\[22\] _1484_ VGND VGND VPWR VPWR _1494_ sky130_fd_sc_hd__and2_1
XFILLER_0_17_235 VPWR VGND VPWR VGND sky130_ef_sc_hd__decap_12
XTAP_TAPCELL_ROW_20_314 VGND VPWR sky130_fd_sc_hd__tapvpwrvgnd_1
X_1819_ _0480_ VGND VGND VPWR VPWR _0481_ sky130_fd_sc_hd__clkbuf_2
X_2799_ reg_file.registers\[11\]\[18\] _1383_ _1376_ VGND VGND VPWR VPWR _1384_ sky130_fd_sc_hd__mux2_1
XFILLER_0_4_195 VGND VGND VPWR VPWR sky130_fd_sc_hd__fill_1
XFILLER_0_13_441 VGND VGND VPWR VPWR sky130_fd_sc_hd__decap_6
XTAP_TAPCELL_ROW_71_726 VGND VPWR sky130_fd_sc_hd__tapvpwrvgnd_1
XFILLER_0_67_124 VPWR VGND VPWR VGND sky130_ef_sc_hd__decap_12
Xrebuffer9 net24 VGND VGND VPWR VPWR net25 sky130_fd_sc_hd__dlygate4sd1_1
XFILLER_0_23_249 VGND VGND VPWR VPWR sky130_fd_sc_hd__decap_4
XFILLER_0_64_27 VGND VGND VPWR VPWR sky130_fd_sc_hd__fill_1
XFILLER_0_48_17 VGND VGND VPWR VPWR sky130_fd_sc_hd__decap_8
XTAP_TAPCELL_ROW_34_428 VGND VPWR sky130_fd_sc_hd__tapvpwrvgnd_1
XTAP_TAPCELL_ROW_42_494 VGND VPWR sky130_fd_sc_hd__tapvpwrvgnd_1
X_2722_ _1216_ _1223_ _0742_ VGND VGND VPWR VPWR _1313_ sky130_fd_sc_hd__mux2_1
XFILLER_0_39_382 VGND VGND VPWR VPWR sky130_fd_sc_hd__decap_6
X_2584_ _1155_ _0727_ _1179_ VGND VGND VPWR VPWR _1180_ sky130_fd_sc_hd__o21ai_1
X_2653_ _1012_ _1039_ _1013_ VGND VGND VPWR VPWR _1247_ sky130_fd_sc_hd__mux2_1
X_3136_ _1581_ VGND VGND VPWR VPWR _0411_ sky130_fd_sc_hd__inv_2
X_3067_ _1108_ _1564_ _1569_ _0610_ VGND VGND VPWR VPWR _1570_ sky130_fd_sc_hd__a211o_1
X_3205_ display.counter\[13\] _1678_ display.counter\[14\] VGND VGND VPWR VPWR _1681_
+ sky130_fd_sc_hd__a21oi_1
XFILLER_0_54_93 VGND VGND VPWR VPWR sky130_fd_sc_hd__fill_2
XFILLER_0_54_82 VGND VGND VPWR VPWR sky130_fd_sc_hd__fill_2
X_2018_ reg_file.registers\[2\]\[6\] _0558_ _0615_ VGND VGND VPWR VPWR _0616_ sky130_fd_sc_hd__a21oi_1
XFILLER_0_49_102 VGND VGND VPWR VPWR sky130_fd_sc_hd__decap_8
XFILLER_0_60_300 VGND VGND VPWR VPWR sky130_fd_sc_hd__fill_1
XFILLER_0_45_363 VGND VGND VPWR VPWR sky130_fd_sc_hd__decap_6
XFILLER_0_68_433 VPWR VGND VPWR VGND sky130_ef_sc_hd__decap_12
XTAP_TAPCELL_ROW_5_197 VGND VPWR sky130_fd_sc_hd__tapvpwrvgnd_1
XFILLER_0_50_29 VGND VGND VPWR VPWR sky130_fd_sc_hd__decap_8
XFILLER_0_36_330 VGND VGND VPWR VPWR sky130_fd_sc_hd__fill_1
XTAP_TAPCELL_ROW_47_531 VGND VPWR sky130_fd_sc_hd__tapvpwrvgnd_1
XFILLER_0_24_63 VGND VGND VPWR VPWR sky130_fd_sc_hd__fill_1
X_2705_ _1182_ _1295_ _1296_ _0741_ VGND VGND VPWR VPWR _1297_ sky130_fd_sc_hd__a22oi_1
XFILLER_0_42_377 VGND VGND VPWR VPWR sky130_fd_sc_hd__decap_8
XFILLER_0_42_333 VGND VGND VPWR VPWR sky130_fd_sc_hd__decap_8
X_2636_ _1228_ _1229_ _1230_ _1128_ _1140_ VGND VGND VPWR VPWR _1231_ sky130_fd_sc_hd__o221ai_4
X_2498_ reg_file.registers\[11\]\[9\] _0770_ _0771_ reg_file.registers\[10\]\[9\]
+ VGND VGND VPWR VPWR _1095_ sky130_fd_sc_hd__a22o_1
XFILLER_0_57_3 VPWR VGND VPWR VGND sky130_ef_sc_hd__decap_12
X_2567_ reg_file.registers\[11\]\[8\] _0790_ _0791_ reg_file.registers\[10\]\[8\]
+ VGND VGND VPWR VPWR _1163_ sky130_fd_sc_hd__a22o_1
XFILLER_0_65_81 VPWR VGND VPWR VGND sky130_ef_sc_hd__decap_12
X_3119_ _1107_ _1617_ VGND VGND VPWR VPWR _1618_ sky130_fd_sc_hd__and2_1
XPHY_EDGE_ROW_67_Left_139 VGND VGND VPWR VPWR sky130_fd_sc_hd__decap_3
XTAP_TAPCELL_ROW_53_578 VGND VPWR sky130_fd_sc_hd__tapvpwrvgnd_1
XFILLER_0_37_116 VGND VGND VPWR VPWR sky130_fd_sc_hd__fill_1
XFILLER_0_56_447 VGND VGND VPWR VPWR sky130_fd_sc_hd__fill_1
XFILLER_0_28_105 VGND VGND VPWR VPWR sky130_fd_sc_hd__fill_1
XFILLER_0_71_417 VGND VGND VPWR VPWR sky130_fd_sc_hd__decap_3
XFILLER_0_51_163 VGND VGND VPWR VPWR sky130_fd_sc_hd__decap_4
XFILLER_0_43_108 VGND VGND VPWR VPWR sky130_fd_sc_hd__decap_4
XFILLER_0_24_388 VPWR VGND VPWR VGND sky130_ef_sc_hd__decap_12
XFILLER_0_24_377 VGND VGND VPWR VPWR sky130_fd_sc_hd__fill_2
XFILLER_0_3_249 VPWR VGND VPWR VGND sky130_ef_sc_hd__decap_12
XFILLER_0_3_205 VPWR VGND VPWR VGND sky130_ef_sc_hd__decap_12
X_3470_ clknet_leaf_6_clk _0239_ _0050_ VGND VGND VPWR VPWR imem.address\[25\] sky130_fd_sc_hd__dfrtp_1
X_2421_ _1018_ VGND VGND VPWR VPWR _1019_ sky130_fd_sc_hd__clkbuf_4
X_2283_ _0879_ _0880_ VGND VGND VPWR VPWR _0881_ sky130_fd_sc_hd__xor2_1
XFILLER_0_10_65 VPWR VGND VPWR VGND sky130_ef_sc_hd__decap_12
X_2352_ _0678_ _0581_ VGND VGND VPWR VPWR _0950_ sky130_fd_sc_hd__xor2_1
XFILLER_0_19_74 VGND VGND VPWR VPWR sky130_fd_sc_hd__decap_6
XFILLER_0_59_285 VGND VGND VPWR VPWR sky130_fd_sc_hd__fill_1
XTAP_TAPCELL_ROW_50_559 VGND VPWR sky130_fd_sc_hd__tapvpwrvgnd_1
XFILLER_0_47_447 VGND VGND VPWR VPWR sky130_fd_sc_hd__fill_1
XFILLER_0_34_108 VGND VGND VPWR VPWR sky130_fd_sc_hd__decap_4
XFILLER_0_19_105 VGND VGND VPWR VPWR sky130_fd_sc_hd__fill_1
X_3668_ clknet_leaf_11_clk _0410_ VGND VGND VPWR VPWR net4 sky130_fd_sc_hd__dfxtp_1
X_1998_ reg_file.registers\[5\]\[2\] _0561_ _0566_ reg_file.registers\[15\]\[2\] _0595_
+ VGND VGND VPWR VPWR _0596_ sky130_fd_sc_hd__a221o_1
X_2619_ _0597_ _1017_ _1213_ VGND VGND VPWR VPWR _1214_ sky130_fd_sc_hd__and3_1
XFILLER_0_42_130 VGND VGND VPWR VPWR sky130_fd_sc_hd__fill_1
X_3599_ clknet_leaf_1_clk _0361_ _0172_ VGND VGND VPWR VPWR reg_file.registers\[5\]\[19\]
+ sky130_fd_sc_hd__dfrtp_1
XFILLER_0_30_358 VGND VGND VPWR VPWR sky130_fd_sc_hd__decap_6
XFILLER_0_15_333 VGND VGND VPWR VPWR sky130_fd_sc_hd__decap_3
XFILLER_0_15_344 VPWR VGND VPWR VGND sky130_ef_sc_hd__decap_12
XTAP_TAPCELL_ROW_7_215 VGND VPWR sky130_fd_sc_hd__tapvpwrvgnd_1
XTAP_TAPCELL_ROW_66_681 VGND VPWR sky130_fd_sc_hd__tapvpwrvgnd_1
XFILLER_0_71_225 VPWR VGND VPWR VGND sky130_ef_sc_hd__decap_12
XFILLER_0_56_288 VPWR VGND VPWR VGND sky130_ef_sc_hd__decap_12
X_2970_ reg_file.registers\[15\]\[6\] _1483_ VGND VGND VPWR VPWR _1511_ sky130_fd_sc_hd__and2_1
X_1921_ reg_file.registers\[10\]\[16\] _0528_ VGND VGND VPWR VPWR _0536_ sky130_fd_sc_hd__and2_1
X_1852_ _0499_ VGND VGND VPWR VPWR _0359_ sky130_fd_sc_hd__clkbuf_1
XFILLER_0_16_108 VGND VGND VPWR VPWR sky130_fd_sc_hd__fill_1
X_3453_ clknet_leaf_9_clk _0222_ _0033_ VGND VGND VPWR VPWR imem.address\[8\] sky130_fd_sc_hd__dfrtp_1
X_1783_ reg_file.registers\[2\]\[0\] VGND VGND VPWR VPWR _0446_ sky130_fd_sc_hd__clkbuf_1
X_3522_ clknet_leaf_11_clk _0284_ _0095_ VGND VGND VPWR VPWR reg_file.registers\[11\]\[6\]
+ sky130_fd_sc_hd__dfrtp_2
XFILLER_0_52_450 VGND VGND VPWR VPWR sky130_fd_sc_hd__fill_1
XTAP_TAPCELL_ROW_12_250 VGND VPWR sky130_fd_sc_hd__tapvpwrvgnd_1
X_2404_ net45 VGND VGND VPWR VPWR _1002_ sky130_fd_sc_hd__clkbuf_4
X_3384_ _1712_ VGND VGND VPWR VPWR _0167_ sky130_fd_sc_hd__inv_2
X_2266_ reg_file.registers\[11\]\[23\] _0862_ _0863_ reg_file.registers\[10\]\[23\]
+ VGND VGND VPWR VPWR _0864_ sky130_fd_sc_hd__a22oi_4
X_2335_ _0677_ _0587_ VGND VGND VPWR VPWR _0933_ sky130_fd_sc_hd__xnor2_2
XFILLER_0_20_391 VPWR VGND VPWR VGND sky130_ef_sc_hd__decap_12
XTAP_TAPCELL_ROW_63_662 VGND VPWR sky130_fd_sc_hd__tapvpwrvgnd_1
X_2197_ reg_file.registers\[11\]\[14\] _0692_ _0697_ reg_file.registers\[10\]\[14\]
+ VGND VGND VPWR VPWR _0795_ sky130_fd_sc_hd__a22o_1
XFILLER_0_62_236 VGND VGND VPWR VPWR sky130_fd_sc_hd__fill_2
XFILLER_0_30_177 VGND VGND VPWR VPWR sky130_fd_sc_hd__decap_4
XFILLER_0_30_122 VGND VGND VPWR VPWR sky130_fd_sc_hd__fill_2
XFILLER_0_53_214 VGND VGND VPWR VPWR sky130_fd_sc_hd__decap_8
XFILLER_0_38_277 VGND VGND VPWR VPWR sky130_fd_sc_hd__fill_2
XTAP_TAPCELL_ROW_26_364 VGND VPWR sky130_fd_sc_hd__tapvpwrvgnd_1
XFILLER_0_21_100 VGND VGND VPWR VPWR sky130_fd_sc_hd__decap_6
X_2120_ net44 _0717_ VGND VGND VPWR VPWR _0718_ sky130_fd_sc_hd__nor2_2
Xrebuffer19 _0606_ VGND VGND VPWR VPWR net35 sky130_fd_sc_hd__dlygate4sd1_1
X_2051_ reg_file.registers\[2\]\[19\] _0558_ VGND VGND VPWR VPWR _0649_ sky130_fd_sc_hd__and2_1
XFILLER_0_69_391 VGND VGND VPWR VPWR sky130_fd_sc_hd__fill_1
X_2884_ _0749_ _0758_ VGND VGND VPWR VPWR _1456_ sky130_fd_sc_hd__nor2_1
XTAP_TAPCELL_ROW_60_632 VGND VPWR sky130_fd_sc_hd__tapvpwrvgnd_1
XFILLER_0_44_236 VPWR VGND VPWR VGND sky130_ef_sc_hd__decap_12
X_2953_ _1502_ VGND VGND VPWR VPWR _0261_ sky130_fd_sc_hd__clkbuf_1
XFILLER_0_32_85 VGND VGND VPWR VPWR sky130_fd_sc_hd__fill_2
XFILLER_0_32_63 VPWR VGND VPWR VGND sky130_ef_sc_hd__decap_12
XFILLER_0_4_333 VPWR VGND VPWR VGND sky130_ef_sc_hd__decap_12
X_1904_ reg_file.registers\[10\]\[24\] _0519_ VGND VGND VPWR VPWR _0527_ sky130_fd_sc_hd__and2_1
X_1835_ _0490_ VGND VGND VPWR VPWR _0367_ sky130_fd_sc_hd__clkbuf_1
XFILLER_0_17_428 VGND VGND VPWR VPWR sky130_fd_sc_hd__decap_3
X_1766_ _0437_ VGND VGND VPWR VPWR _0383_ sky130_fd_sc_hd__clkbuf_1
X_3505_ clknet_leaf_1_clk _0267_ _0078_ VGND VGND VPWR VPWR reg_file.registers\[15\]\[21\]
+ sky130_fd_sc_hd__dfrtp_1
XFILLER_0_4_377 VPWR VGND VPWR VGND sky130_ef_sc_hd__decap_12
X_3436_ _1719_ VGND VGND VPWR VPWR _0212_ sky130_fd_sc_hd__inv_2
XFILLER_0_12_177 VPWR VGND VPWR VGND sky130_ef_sc_hd__decap_12
X_3298_ _1702_ VGND VGND VPWR VPWR _0091_ sky130_fd_sc_hd__inv_2
XFILLER_0_57_82 VGND VGND VPWR VPWR sky130_fd_sc_hd__decap_6
X_2249_ reg_file.registers\[11\]\[13\] _0692_ _0846_ VGND VGND VPWR VPWR _0847_ sky130_fd_sc_hd__a21oi_2
X_3367_ _1691_ VGND VGND VPWR VPWR _1710_ sky130_fd_sc_hd__buf_1
X_2318_ _0903_ _0906_ _0913_ _0915_ VGND VGND VPWR VPWR _0916_ sky130_fd_sc_hd__a31oi_1
XFILLER_0_35_214 VGND VGND VPWR VPWR sky130_fd_sc_hd__fill_1
XFILLER_0_35_225 VPWR VGND VPWR VGND sky130_ef_sc_hd__decap_12
XFILLER_0_7_193 VPWR VGND VPWR VGND sky130_ef_sc_hd__decap_12
Xoutput9 net9 VGND VGND VPWR VPWR an[7] sky130_fd_sc_hd__buf_1
Xoutput11 net11 VGND VGND VPWR VPWR seg[1] sky130_fd_sc_hd__buf_1
XFILLER_0_9_3 VPWR VGND VPWR VGND sky130_ef_sc_hd__decap_12
XFILLER_0_66_361 VGND VGND VPWR VPWR sky130_fd_sc_hd__decap_3
XFILLER_0_26_269 VGND VGND VPWR VPWR sky130_fd_sc_hd__decap_4
X_3083_ _1578_ display.digit_sel\[2\] display.digit_sel\[0\] VGND VGND VPWR VPWR _1585_
+ sky130_fd_sc_hd__or3_1
XFILLER_0_27_96 VGND VGND VPWR VPWR sky130_fd_sc_hd__decap_8
XFILLER_0_27_41 VPWR VGND VPWR VGND sky130_ef_sc_hd__decap_12
X_3152_ _1615_ _1609_ VGND VGND VPWR VPWR _1649_ sky130_fd_sc_hd__and2_4
X_3221_ display.counter\[0\] VGND VGND VPWR VPWR _0007_ sky130_fd_sc_hd__inv_2
X_2103_ _0679_ _0683_ VGND VGND VPWR VPWR _0701_ sky130_fd_sc_hd__xor2_2
XFILLER_0_64_309 VPWR VGND VPWR VGND sky130_ef_sc_hd__decap_12
X_2034_ reg_file.registers\[5\]\[8\] _0562_ _0566_ reg_file.registers\[15\]\[8\] _0631_
+ VGND VGND VPWR VPWR _0632_ sky130_fd_sc_hd__a221o_1
XFILLER_0_43_62 VPWR VGND VPWR VGND sky130_ef_sc_hd__decap_12
XTAP_TAPCELL_ROW_37_448 VGND VPWR sky130_fd_sc_hd__tapvpwrvgnd_1
XFILLER_0_9_403 VGND VGND VPWR VPWR sky130_fd_sc_hd__fill_1
X_1818_ _0477_ _0479_ VGND VGND VPWR VPWR _0480_ sky130_fd_sc_hd__or2_1
X_2867_ _1442_ VGND VGND VPWR VPWR _0287_ sky130_fd_sc_hd__clkbuf_1
X_2798_ _1064_ _1378_ _1379_ _1381_ _1382_ VGND VGND VPWR VPWR _1383_ sky130_fd_sc_hd__a32o_1
X_2936_ _1493_ VGND VGND VPWR VPWR _0269_ sky130_fd_sc_hd__clkbuf_1
XFILLER_0_4_141 VPWR VGND VPWR VGND sky130_ef_sc_hd__decap_12
XFILLER_0_17_247 VGND VGND VPWR VPWR sky130_fd_sc_hd__decap_6
XTAP_TAPCELL_ROW_20_315 VGND VPWR sky130_fd_sc_hd__tapvpwrvgnd_1
XFILLER_0_68_92 VGND VGND VPWR VPWR sky130_fd_sc_hd__fill_1
X_3419_ _1717_ VGND VGND VPWR VPWR _0197_ sky130_fd_sc_hd__inv_2
X_1749_ reg_file.registers\[2\]\[18\] VGND VGND VPWR VPWR _0429_ sky130_fd_sc_hd__clkbuf_1
XFILLER_0_7_51 VGND VGND VPWR VPWR sky130_fd_sc_hd__decap_4
XTAP_TAPCELL_ROW_71_727 VGND VPWR sky130_fd_sc_hd__tapvpwrvgnd_1
XFILLER_0_67_169 VGND VGND VPWR VPWR sky130_fd_sc_hd__fill_1
XFILLER_0_67_136 VGND VGND VPWR VPWR sky130_fd_sc_hd__decap_4
XFILLER_0_48_29 VPWR VGND VPWR VGND sky130_ef_sc_hd__decap_12
XFILLER_0_46_309 VPWR VGND VPWR VGND sky130_ef_sc_hd__decap_12
XTAP_TAPCELL_ROW_34_429 VGND VPWR sky130_fd_sc_hd__tapvpwrvgnd_1
XFILLER_0_54_386 VGND VGND VPWR VPWR sky130_fd_sc_hd__fill_1
X_2721_ _1019_ _1213_ _1295_ _1311_ _1107_ VGND VGND VPWR VPWR _1312_ sky130_fd_sc_hd__a32o_1
XTAP_TAPCELL_ROW_42_495 VGND VPWR sky130_fd_sc_hd__tapvpwrvgnd_1
X_2652_ _0990_ _1025_ _1005_ _1244_ _1245_ VGND VGND VPWR VPWR _1246_ sky130_fd_sc_hd__o311a_1
XFILLER_0_13_98 VPWR VGND VPWR VGND sky130_ef_sc_hd__decap_12
X_2583_ reg_file.registers\[11\]\[0\] _0862_ _0863_ reg_file.registers\[10\]\[0\]
+ _1152_ VGND VGND VPWR VPWR _1179_ sky130_fd_sc_hd__a221o_1
XFILLER_0_1_111 VGND VGND VPWR VPWR sky130_fd_sc_hd__fill_1
X_3204_ display.counter\[13\] display.counter\[14\] _1678_ VGND VGND VPWR VPWR _1680_
+ sky130_fd_sc_hd__and3_1
X_2017_ reg_file.registers\[5\]\[6\] _0562_ _0566_ reg_file.registers\[15\]\[6\] VGND
+ VGND VPWR VPWR _0615_ sky130_fd_sc_hd__a22o_1
X_3066_ _1108_ _1568_ VGND VGND VPWR VPWR _1569_ sky130_fd_sc_hd__nor2_1
X_3135_ _1476_ _0408_ _1633_ _1627_ VGND VGND VPWR VPWR _1634_ sky130_fd_sc_hd__o22a_4
XFILLER_0_64_139 VGND VGND VPWR VPWR sky130_fd_sc_hd__fill_1
XFILLER_0_49_169 VGND VGND VPWR VPWR sky130_fd_sc_hd__decap_3
X_2919_ reg_file.registers\[15\]\[31\] _1484_ VGND VGND VPWR VPWR _1485_ sky130_fd_sc_hd__and2_1
XFILLER_0_45_375 VPWR VGND VPWR VGND sky130_ef_sc_hd__decap_12
XFILLER_0_13_272 VGND VGND VPWR VPWR sky130_fd_sc_hd__decap_3
XFILLER_0_68_445 VGND VGND VPWR VPWR sky130_fd_sc_hd__decap_6
XFILLER_0_55_106 VGND VGND VPWR VPWR sky130_fd_sc_hd__decap_6
XTAP_TAPCELL_ROW_5_198 VGND VPWR sky130_fd_sc_hd__tapvpwrvgnd_1
XFILLER_0_50_19 VGND VGND VPWR VPWR sky130_fd_sc_hd__fill_1
XTAP_TAPCELL_ROW_47_532 VGND VPWR sky130_fd_sc_hd__tapvpwrvgnd_1
X_2704_ _1169_ _1178_ _0597_ VGND VGND VPWR VPWR _1296_ sky130_fd_sc_hd__mux2_1
X_2635_ _1125_ _1131_ _1019_ VGND VGND VPWR VPWR _1230_ sky130_fd_sc_hd__mux2_1
X_2497_ reg_file.registers\[11\]\[10\] _1070_ _1072_ reg_file.registers\[10\]\[10\]
+ VGND VGND VPWR VPWR _1094_ sky130_fd_sc_hd__a22oi_1
X_2566_ _1161_ VGND VGND VPWR VPWR _1162_ sky130_fd_sc_hd__inv_2
XFILLER_0_49_94 VGND VGND VPWR VPWR sky130_fd_sc_hd__fill_1
XFILLER_0_4_85 VPWR VGND VPWR VGND sky130_ef_sc_hd__decap_12
XFILLER_0_4_41 VPWR VGND VPWR VGND sky130_ef_sc_hd__decap_12
XFILLER_0_10_253 VPWR VGND VPWR VGND sky130_ef_sc_hd__decap_12
XFILLER_0_10_297 VGND VGND VPWR VPWR sky130_fd_sc_hd__fill_2
X_3049_ _0455_ _1482_ VGND VGND VPWR VPWR _0218_ sky130_fd_sc_hd__xor2_1
XFILLER_0_65_93 VGND VGND VPWR VPWR sky130_fd_sc_hd__fill_1
X_3118_ _1352_ _1356_ _1013_ VGND VGND VPWR VPWR _1617_ sky130_fd_sc_hd__mux2_1
XFILLER_0_37_106 VGND VGND VPWR VPWR sky130_fd_sc_hd__fill_1
XTAP_TAPCELL_ROW_2_168 VGND VPWR sky130_fd_sc_hd__tapvpwrvgnd_1
XTAP_TAPCELL_ROW_53_579 VGND VPWR sky130_fd_sc_hd__tapvpwrvgnd_1
XFILLER_0_45_194 VPWR VGND VPWR VGND sky130_ef_sc_hd__decap_12
XFILLER_0_61_18 VGND VGND VPWR VPWR sky130_fd_sc_hd__decap_8
X_2420_ _1017_ VGND VGND VPWR VPWR _1018_ sky130_fd_sc_hd__clkbuf_4
XFILLER_0_24_356 VGND VGND VPWR VPWR sky130_fd_sc_hd__decap_8
XFILLER_0_24_334 VGND VGND VPWR VPWR sky130_fd_sc_hd__fill_1
XFILLER_0_24_323 VGND VGND VPWR VPWR sky130_fd_sc_hd__fill_1
XFILLER_0_3_217 VGND VGND VPWR VPWR sky130_fd_sc_hd__decap_6
XFILLER_0_10_77 VGND VGND VPWR VPWR sky130_fd_sc_hd__decap_6
X_2282_ reg_file.registers\[11\]\[21\] _0862_ _0863_ reg_file.registers\[10\]\[21\]
+ VGND VGND VPWR VPWR _0880_ sky130_fd_sc_hd__a22o_1
X_2351_ _0945_ _0948_ VGND VGND VPWR VPWR _0949_ sky130_fd_sc_hd__nor2_1
XFILLER_0_59_253 VGND VGND VPWR VPWR sky130_fd_sc_hd__fill_1
XFILLER_0_35_52 VGND VGND VPWR VPWR sky130_fd_sc_hd__decap_4
X_1997_ reg_file.registers\[2\]\[2\] net40 _0466_ reg_file.registers\[10\]\[2\] VGND
+ VGND VPWR VPWR _0595_ sky130_fd_sc_hd__a22o_1
XFILLER_0_51_51 VGND VGND VPWR VPWR sky130_fd_sc_hd__decap_4
XFILLER_0_27_150 VGND VGND VPWR VPWR sky130_fd_sc_hd__fill_1
XFILLER_0_15_301 VPWR VGND VPWR VGND sky130_ef_sc_hd__decap_12
X_3667_ clknet_leaf_11_clk _0409_ VGND VGND VPWR VPWR net3 sky130_fd_sc_hd__dfxtp_1
X_2618_ _1069_ _1074_ VGND VGND VPWR VPWR _1213_ sky130_fd_sc_hd__nor2_1
XFILLER_0_42_175 VGND VGND VPWR VPWR sky130_fd_sc_hd__fill_2
X_3598_ clknet_leaf_0_clk _0360_ _0171_ VGND VGND VPWR VPWR reg_file.registers\[5\]\[18\]
+ sky130_fd_sc_hd__dfrtp_1
X_2549_ _1019_ _1144_ _0718_ _1145_ VGND VGND VPWR VPWR _1146_ sky130_fd_sc_hd__a211o_1
XFILLER_0_15_356 VPWR VGND VPWR VGND sky130_ef_sc_hd__decap_12
XTAP_TAPCELL_ROW_58_616 VGND VPWR sky130_fd_sc_hd__tapvpwrvgnd_1
XTAP_TAPCELL_ROW_66_682 VGND VPWR sky130_fd_sc_hd__tapvpwrvgnd_1
XFILLER_0_65_223 VGND VGND VPWR VPWR sky130_fd_sc_hd__fill_1
XFILLER_0_33_164 VGND VGND VPWR VPWR sky130_fd_sc_hd__decap_4
XFILLER_0_0_209 VPWR VGND VPWR VGND sky130_ef_sc_hd__decap_12
XFILLER_0_21_337 VPWR VGND VPWR VGND sky130_ef_sc_hd__decap_12
XTAP_TAPCELL_ROW_29_384 VGND VPWR sky130_fd_sc_hd__tapvpwrvgnd_1
XFILLER_0_71_237 VPWR VGND VPWR VGND sky130_ef_sc_hd__decap_12
X_1851_ reg_file.registers\[5\]\[17\] _0493_ VGND VGND VPWR VPWR _0499_ sky130_fd_sc_hd__and2_1
X_1920_ _0535_ VGND VGND VPWR VPWR _0327_ sky130_fd_sc_hd__clkbuf_1
XFILLER_0_8_309 VGND VGND VPWR VPWR sky130_fd_sc_hd__fill_2
XTAP_TAPCELL_ROW_12_251 VGND VPWR sky130_fd_sc_hd__tapvpwrvgnd_1
X_3452_ clknet_leaf_9_clk _0221_ _0032_ VGND VGND VPWR VPWR imem.address\[7\] sky130_fd_sc_hd__dfrtp_2
X_1782_ _0445_ VGND VGND VPWR VPWR _0375_ sky130_fd_sc_hd__clkbuf_1
X_3521_ clknet_leaf_11_clk _0283_ _0094_ VGND VGND VPWR VPWR reg_file.registers\[11\]\[5\]
+ sky130_fd_sc_hd__dfrtp_1
X_3383_ _1712_ VGND VGND VPWR VPWR _0166_ sky130_fd_sc_hd__inv_2
X_2403_ _0998_ _1000_ _0995_ VGND VGND VPWR VPWR _1001_ sky130_fd_sc_hd__mux2_1
X_2265_ _0791_ VGND VGND VPWR VPWR _0863_ sky130_fd_sc_hd__clkbuf_4
X_2196_ _0642_ _0783_ VGND VGND VPWR VPWR _0794_ sky130_fd_sc_hd__xnor2_1
X_2334_ _0882_ _0920_ _0925_ _0926_ _0931_ VGND VGND VPWR VPWR _0932_ sky130_fd_sc_hd__o221a_1
XTAP_TAPCELL_ROW_63_663 VGND VPWR sky130_fd_sc_hd__tapvpwrvgnd_1
XFILLER_0_47_256 VGND VGND VPWR VPWR sky130_fd_sc_hd__decap_8
XFILLER_0_47_223 VGND VGND VPWR VPWR sky130_fd_sc_hd__fill_1
XFILLER_0_62_259 VGND VGND VPWR VPWR sky130_fd_sc_hd__fill_1
XFILLER_0_47_289 VPWR VGND VPWR VGND sky130_ef_sc_hd__decap_12
XFILLER_0_53_237 VPWR VGND VPWR VGND sky130_ef_sc_hd__decap_12
XTAP_TAPCELL_ROW_26_365 VGND VPWR sky130_fd_sc_hd__tapvpwrvgnd_1
XFILLER_0_67_17 VPWR VGND VPWR VGND sky130_ef_sc_hd__decap_12
X_2050_ _0574_ _0644_ _0647_ VGND VGND VPWR VPWR _0648_ sky130_fd_sc_hd__a21bo_1
X_2952_ reg_file.registers\[15\]\[15\] _1495_ VGND VGND VPWR VPWR _1502_ sky130_fd_sc_hd__and2_1
XFILLER_0_32_20 VGND VGND VPWR VPWR sky130_fd_sc_hd__fill_1
XFILLER_0_29_245 VGND VGND VPWR VPWR sky130_fd_sc_hd__decap_4
X_2883_ _1455_ VGND VGND VPWR VPWR _0284_ sky130_fd_sc_hd__clkbuf_1
XTAP_TAPCELL_ROW_60_633 VGND VPWR sky130_fd_sc_hd__tapvpwrvgnd_1
XFILLER_0_44_259 VGND VGND VPWR VPWR sky130_fd_sc_hd__fill_1
XFILLER_0_44_248 VGND VGND VPWR VPWR sky130_fd_sc_hd__decap_4
X_1765_ reg_file.registers\[2\]\[10\] VGND VGND VPWR VPWR _0437_ sky130_fd_sc_hd__clkbuf_1
XFILLER_0_40_421 VGND VGND VPWR VPWR sky130_fd_sc_hd__decap_4
XFILLER_0_32_75 VGND VGND VPWR VPWR sky130_fd_sc_hd__fill_2
XFILLER_0_29_267 VPWR VGND VPWR VGND sky130_ef_sc_hd__decap_12
XFILLER_0_4_345 VPWR VGND VPWR VGND sky130_ef_sc_hd__decap_12
XFILLER_0_4_301 VGND VGND VPWR VPWR sky130_fd_sc_hd__decap_6
XFILLER_0_8_139 VGND VGND VPWR VPWR sky130_fd_sc_hd__fill_1
X_1903_ _0526_ VGND VGND VPWR VPWR _0335_ sky130_fd_sc_hd__clkbuf_1
X_1834_ reg_file.registers\[5\]\[25\] _0483_ VGND VGND VPWR VPWR _0490_ sky130_fd_sc_hd__and2_1
X_3504_ clknet_leaf_0_clk _0266_ _0077_ VGND VGND VPWR VPWR reg_file.registers\[15\]\[20\]
+ sky130_fd_sc_hd__dfrtp_1
XFILLER_0_4_389 VPWR VGND VPWR VGND sky130_ef_sc_hd__decap_12
X_3366_ _1709_ VGND VGND VPWR VPWR _0152_ sky130_fd_sc_hd__inv_2
XFILLER_0_12_123 VPWR VGND VPWR VGND sky130_ef_sc_hd__decap_12
XFILLER_0_12_189 VGND VGND VPWR VPWR sky130_fd_sc_hd__decap_6
X_3435_ _1719_ VGND VGND VPWR VPWR _0211_ sky130_fd_sc_hd__inv_2
XTAP_TAPCELL_ROW_68_700 VGND VPWR sky130_fd_sc_hd__tapvpwrvgnd_1
X_3297_ _1700_ VGND VGND VPWR VPWR _1702_ sky130_fd_sc_hd__buf_4
X_2248_ reg_file.registers\[10\]\[13\] _0785_ _0786_ VGND VGND VPWR VPWR _0846_ sky130_fd_sc_hd__and3_1
X_2179_ reg_file.registers\[15\]\[14\] _0599_ _0715_ reg_file.registers\[5\]\[14\]
+ _0643_ VGND VGND VPWR VPWR _0777_ sky130_fd_sc_hd__a221o_1
X_2317_ _0900_ _0914_ VGND VGND VPWR VPWR _0915_ sky130_fd_sc_hd__and2b_1
XFILLER_0_32_3 VPWR VGND VPWR VGND sky130_ef_sc_hd__decap_12
XFILLER_0_35_237 VPWR VGND VPWR VGND sky130_ef_sc_hd__decap_12
XFILLER_0_43_292 VGND VGND VPWR VPWR sky130_fd_sc_hd__decap_6
XFILLER_0_31_432 VGND VGND VPWR VPWR sky130_fd_sc_hd__fill_2
XFILLER_0_7_161 VGND VGND VPWR VPWR sky130_fd_sc_hd__decap_6
Xoutput12 net12 VGND VGND VPWR VPWR seg[2] sky130_fd_sc_hd__buf_1
XFILLER_0_58_307 VGND VGND VPWR VPWR sky130_fd_sc_hd__fill_1
XFILLER_0_66_373 VPWR VGND VPWR VGND sky130_ef_sc_hd__decap_12
XFILLER_0_34_270 VGND VGND VPWR VPWR sky130_fd_sc_hd__fill_1
XFILLER_0_26_259 VGND VGND VPWR VPWR sky130_fd_sc_hd__decap_3
XFILLER_0_26_237 VGND VGND VPWR VPWR sky130_fd_sc_hd__fill_2
XFILLER_0_26_215 VGND VGND VPWR VPWR sky130_fd_sc_hd__fill_1
XFILLER_0_1_337 VPWR VGND VPWR VGND sky130_ef_sc_hd__decap_12
X_3220_ _1690_ VGND VGND VPWR VPWR _0017_ sky130_fd_sc_hd__clkbuf_1
X_2033_ reg_file.registers\[2\]\[8\] _0557_ VGND VGND VPWR VPWR _0631_ sky130_fd_sc_hd__and2_1
X_3082_ display.digit_sel\[0\] VGND VGND VPWR VPWR _1584_ sky130_fd_sc_hd__inv_2
XFILLER_0_27_53 VGND VGND VPWR VPWR sky130_fd_sc_hd__decap_3
X_3151_ _1593_ _1607_ _1468_ _0408_ VGND VGND VPWR VPWR _1648_ sky130_fd_sc_hd__o2bb2a_2
X_2102_ _0689_ _0699_ VGND VGND VPWR VPWR _0700_ sky130_fd_sc_hd__or2_1
XFILLER_0_49_329 VGND VGND VPWR VPWR sky130_fd_sc_hd__decap_6
XTAP_TAPCELL_ROW_37_449 VGND VPWR sky130_fd_sc_hd__tapvpwrvgnd_1
X_2935_ reg_file.registers\[15\]\[23\] _1484_ VGND VGND VPWR VPWR _1493_ sky130_fd_sc_hd__and2_1
XFILLER_0_9_415 VGND VGND VPWR VPWR sky130_fd_sc_hd__decap_8
X_1817_ net1 _0478_ VGND VGND VPWR VPWR _0479_ sky130_fd_sc_hd__nand2_1
X_2866_ _1441_ reg_file.registers\[11\]\[9\] _1207_ VGND VGND VPWR VPWR _1442_ sky130_fd_sc_hd__mux2_1
X_2797_ _0680_ _1016_ _1254_ _1244_ VGND VGND VPWR VPWR _1382_ sky130_fd_sc_hd__a31o_1
XFILLER_0_40_251 VGND VGND VPWR VPWR sky130_fd_sc_hd__fill_1
X_1748_ _0428_ VGND VGND VPWR VPWR _0392_ sky130_fd_sc_hd__clkbuf_1
XFILLER_0_25_281 VPWR VGND VPWR VGND sky130_ef_sc_hd__decap_12
XFILLER_0_25_270 VGND VGND VPWR VPWR sky130_fd_sc_hd__decap_4
XFILLER_0_4_197 VPWR VGND VPWR VGND sky130_ef_sc_hd__decap_12
XFILLER_0_4_153 VPWR VGND VPWR VGND sky130_ef_sc_hd__decap_12
XFILLER_0_13_421 VGND VGND VPWR VPWR sky130_fd_sc_hd__decap_8
XTAP_TAPCELL_ROW_20_316 VGND VPWR sky130_fd_sc_hd__tapvpwrvgnd_1
X_3418_ _1717_ VGND VGND VPWR VPWR _0196_ sky130_fd_sc_hd__inv_2
XFILLER_0_40_273 VGND VGND VPWR VPWR sky130_fd_sc_hd__fill_1
X_3349_ _1707_ VGND VGND VPWR VPWR _0137_ sky130_fd_sc_hd__inv_2
XTAP_TAPCELL_ROW_71_728 VGND VPWR sky130_fd_sc_hd__tapvpwrvgnd_1
XFILLER_0_63_321 VGND VGND VPWR VPWR sky130_fd_sc_hd__fill_1
XFILLER_0_64_18 VGND VGND VPWR VPWR sky130_fd_sc_hd__fill_1
XFILLER_0_13_55 VGND VGND VPWR VPWR sky130_fd_sc_hd__fill_1
XFILLER_0_54_365 VGND VGND VPWR VPWR sky130_fd_sc_hd__fill_2
X_2582_ _1002_ _1173_ _1177_ VGND VGND VPWR VPWR _1178_ sky130_fd_sc_hd__a21oi_1
X_2720_ _1212_ _1310_ _0742_ VGND VGND VPWR VPWR _1311_ sky130_fd_sc_hd__mux2_1
X_2651_ _1016_ _1031_ VGND VGND VPWR VPWR _1245_ sky130_fd_sc_hd__nand2_1
XFILLER_0_22_262 VGND VGND VPWR VPWR sky130_fd_sc_hd__fill_1
XFILLER_0_1_167 VGND VGND VPWR VPWR sky130_fd_sc_hd__fill_1
X_3203_ display.counter\[13\] _1678_ VGND VGND VPWR VPWR _0011_ sky130_fd_sc_hd__xor2_1
X_2016_ _0613_ _0610_ _0606_ VGND VGND VPWR VPWR _0614_ sky130_fd_sc_hd__or3_4
XFILLER_0_49_126 VGND VGND VPWR VPWR sky130_fd_sc_hd__fill_2
X_3065_ _1565_ _1567_ _1014_ VGND VGND VPWR VPWR _1568_ sky130_fd_sc_hd__mux2_1
X_3134_ _1631_ _1630_ _1632_ VGND VGND VPWR VPWR _1633_ sky130_fd_sc_hd__a21boi_1
XFILLER_0_45_387 VGND VGND VPWR VPWR sky130_fd_sc_hd__decap_4
XFILLER_0_45_321 VGND VGND VPWR VPWR sky130_fd_sc_hd__decap_6
X_2918_ _1483_ VGND VGND VPWR VPWR _1484_ sky130_fd_sc_hd__clkbuf_2
XFILLER_0_9_223 VGND VGND VPWR VPWR sky130_fd_sc_hd__fill_1
XFILLER_0_45_398 VPWR VGND VPWR VGND sky130_ef_sc_hd__decap_12
X_2849_ _0988_ _1401_ _1427_ VGND VGND VPWR VPWR _1428_ sky130_fd_sc_hd__or3b_1
XTAP_TAPCELL_ROW_5_199 VGND VPWR sky130_fd_sc_hd__tapvpwrvgnd_1
XFILLER_0_51_335 VGND VGND VPWR VPWR sky130_fd_sc_hd__fill_1
Xclkbuf_leaf_21_clk clknet_1_0__leaf_clk VGND VGND VPWR VPWR clknet_leaf_21_clk sky130_fd_sc_hd__clkbuf_8
XTAP_TAPCELL_ROW_47_533 VGND VPWR sky130_fd_sc_hd__tapvpwrvgnd_1
XFILLER_0_24_32 VGND VGND VPWR VPWR sky130_fd_sc_hd__decap_4
Xclkbuf_leaf_12_clk clknet_1_1__leaf_clk VGND VGND VPWR VPWR clknet_leaf_12_clk sky130_fd_sc_hd__clkbuf_8
XFILLER_0_42_302 VGND VGND VPWR VPWR sky130_fd_sc_hd__decap_6
X_2703_ _0741_ _0597_ VGND VGND VPWR VPWR _1295_ sky130_fd_sc_hd__nor2_1
X_2565_ _1157_ _1160_ _1003_ VGND VGND VPWR VPWR _1161_ sky130_fd_sc_hd__mux2_1
X_2634_ _1022_ _1134_ VGND VGND VPWR VPWR _1229_ sky130_fd_sc_hd__and2_1
XFILLER_0_2_421 VPWR VGND VPWR VGND sky130_ef_sc_hd__decap_12
XFILLER_0_10_221 VPWR VGND VPWR VGND sky130_ef_sc_hd__decap_12
XFILLER_0_65_50 VGND VGND VPWR VPWR sky130_fd_sc_hd__fill_2
X_2496_ _1091_ _1092_ _1068_ VGND VGND VPWR VPWR _1093_ sky130_fd_sc_hd__mux2_1
XFILLER_0_49_84 VGND VGND VPWR VPWR sky130_fd_sc_hd__fill_1
X_3117_ _1615_ _1609_ VGND VGND VPWR VPWR _1616_ sky130_fd_sc_hd__nand2_4
XFILLER_0_4_97 VPWR VGND VPWR VGND sky130_ef_sc_hd__decap_12
XFILLER_0_4_53 VPWR VGND VPWR VGND sky130_ef_sc_hd__decap_12
XFILLER_0_10_265 VPWR VGND VPWR VGND sky130_ef_sc_hd__decap_12
X_3048_ _1519_ _1555_ VGND VGND VPWR VPWR _0219_ sky130_fd_sc_hd__nor2_1
XFILLER_0_65_449 VGND VGND VPWR VPWR sky130_fd_sc_hd__fill_2
XFILLER_0_65_405 VPWR VGND VPWR VGND sky130_ef_sc_hd__decap_12
XTAP_TAPCELL_ROW_2_169 VGND VPWR sky130_fd_sc_hd__tapvpwrvgnd_1
XFILLER_0_60_121 VGND VGND VPWR VPWR sky130_fd_sc_hd__fill_2
XFILLER_0_45_151 VGND VGND VPWR VPWR sky130_fd_sc_hd__decap_8
XFILLER_0_33_346 VGND VGND VPWR VPWR sky130_fd_sc_hd__decap_8
XFILLER_0_33_335 VGND VGND VPWR VPWR sky130_fd_sc_hd__fill_1
XFILLER_0_5_281 VPWR VGND VPWR VGND sky130_ef_sc_hd__decap_12
XFILLER_0_18_365 VGND VGND VPWR VPWR sky130_fd_sc_hd__decap_4
Xclkbuf_leaf_1_clk clknet_1_0__leaf_clk VGND VGND VPWR VPWR clknet_leaf_1_clk sky130_fd_sc_hd__clkbuf_8
X_2281_ _0868_ _0878_ VGND VGND VPWR VPWR _0879_ sky130_fd_sc_hd__nand2_1
X_2350_ _0679_ _0943_ _0947_ VGND VGND VPWR VPWR _0948_ sky130_fd_sc_hd__a21oi_1
XFILLER_0_47_416 VGND VGND VPWR VPWR sky130_fd_sc_hd__decap_8
XFILLER_0_35_75 VGND VGND VPWR VPWR sky130_fd_sc_hd__fill_1
XFILLER_0_62_419 VGND VGND VPWR VPWR sky130_fd_sc_hd__fill_1
X_1996_ _0593_ VGND VGND VPWR VPWR _0594_ sky130_fd_sc_hd__buf_8
XFILLER_0_51_74 VGND VGND VPWR VPWR sky130_fd_sc_hd__fill_2
XFILLER_0_51_63 VGND VGND VPWR VPWR sky130_fd_sc_hd__fill_1
XFILLER_0_47_449 VGND VGND VPWR VPWR sky130_fd_sc_hd__fill_2
XFILLER_0_15_313 VPWR VGND VPWR VGND sky130_ef_sc_hd__decap_12
XFILLER_0_15_368 VGND VGND VPWR VPWR sky130_fd_sc_hd__decap_4
X_3666_ clknet_leaf_11_clk _0408_ VGND VGND VPWR VPWR net2 sky130_fd_sc_hd__dfxtp_1
X_2548_ _0594_ _0597_ VGND VGND VPWR VPWR _1145_ sky130_fd_sc_hd__or2_4
X_2617_ _1078_ _1211_ _1017_ VGND VGND VPWR VPWR _1212_ sky130_fd_sc_hd__mux2_1
XFILLER_0_42_187 VGND VGND VPWR VPWR sky130_fd_sc_hd__decap_8
XFILLER_0_42_165 VGND VGND VPWR VPWR sky130_fd_sc_hd__fill_1
X_3597_ clknet_leaf_4_clk _0359_ _0170_ VGND VGND VPWR VPWR reg_file.registers\[5\]\[17\]
+ sky130_fd_sc_hd__dfrtp_1
XFILLER_0_2_251 VGND VGND VPWR VPWR sky130_fd_sc_hd__fill_1
X_2479_ reg_file.registers\[11\]\[2\] _1071_ _1073_ reg_file.registers\[10\]\[2\]
+ VGND VGND VPWR VPWR _1076_ sky130_fd_sc_hd__a22o_1
XTAP_TAPCELL_ROW_58_617 VGND VPWR sky130_fd_sc_hd__tapvpwrvgnd_1
XTAP_TAPCELL_ROW_66_683 VGND VPWR sky130_fd_sc_hd__tapvpwrvgnd_1
XFILLER_0_65_268 VPWR VGND VPWR VGND sky130_ef_sc_hd__decap_12
XFILLER_0_61_441 VGND VGND VPWR VPWR sky130_fd_sc_hd__decap_4
Xclkload0 clknet_1_1__leaf_clk VGND VGND VPWR VPWR clkload0/Y sky130_fd_sc_hd__clkinvlp_4
XFILLER_0_21_349 VGND VGND VPWR VPWR sky130_fd_sc_hd__decap_3
XFILLER_0_29_405 VGND VGND VPWR VPWR sky130_fd_sc_hd__decap_4
XTAP_TAPCELL_ROW_29_385 VGND VPWR sky130_fd_sc_hd__tapvpwrvgnd_1
XFILLER_0_71_249 VGND VGND VPWR VPWR sky130_fd_sc_hd__decap_3
X_1781_ reg_file.registers\[2\]\[2\] VGND VGND VPWR VPWR _0445_ sky130_fd_sc_hd__clkbuf_1
X_3520_ clknet_leaf_11_clk _0282_ _0093_ VGND VGND VPWR VPWR reg_file.registers\[11\]\[4\]
+ sky130_fd_sc_hd__dfrtp_2
XFILLER_0_56_235 VGND VGND VPWR VPWR sky130_fd_sc_hd__fill_2
XFILLER_0_56_224 VGND VGND VPWR VPWR sky130_fd_sc_hd__fill_1
XFILLER_0_44_419 VGND VGND VPWR VPWR sky130_fd_sc_hd__fill_1
X_1850_ _0498_ VGND VGND VPWR VPWR _0360_ sky130_fd_sc_hd__clkbuf_1
XFILLER_0_29_449 VGND VGND VPWR VPWR sky130_fd_sc_hd__fill_2
XTAP_TAPCELL_ROW_12_252 VGND VPWR sky130_fd_sc_hd__tapvpwrvgnd_1
XFILLER_0_21_55 VGND VGND VPWR VPWR sky130_fd_sc_hd__fill_1
XFILLER_0_21_88 VPWR VGND VPWR VGND sky130_ef_sc_hd__decap_12
X_3451_ clknet_leaf_9_clk _0220_ _0031_ VGND VGND VPWR VPWR imem.address\[6\] sky130_fd_sc_hd__dfrtp_1
X_3382_ _1712_ VGND VGND VPWR VPWR _0165_ sky130_fd_sc_hd__inv_2
X_2402_ reg_file.registers\[11\]\[21\] _0694_ _0999_ VGND VGND VPWR VPWR _1000_ sky130_fd_sc_hd__a21o_1
X_2333_ _0866_ _0930_ VGND VGND VPWR VPWR _0931_ sky130_fd_sc_hd__nor2_1
XFILLER_0_12_349 VPWR VGND VPWR VGND sky130_ef_sc_hd__decap_12
X_2264_ _0790_ VGND VGND VPWR VPWR _0862_ sky130_fd_sc_hd__clkbuf_4
XFILLER_0_46_85 VGND VGND VPWR VPWR sky130_fd_sc_hd__decap_8
X_2195_ _0781_ _0784_ _0792_ VGND VGND VPWR VPWR _0793_ sky130_fd_sc_hd__a21bo_1
XFILLER_0_62_62 VGND VGND VPWR VPWR sky130_fd_sc_hd__fill_2
XFILLER_0_47_279 VGND VGND VPWR VPWR sky130_fd_sc_hd__fill_1
XFILLER_0_35_408 VPWR VGND VPWR VGND sky130_ef_sc_hd__decap_12
XFILLER_0_70_293 VGND VGND VPWR VPWR sky130_fd_sc_hd__fill_1
XFILLER_0_62_216 VPWR VGND VPWR VGND sky130_ef_sc_hd__decap_12
XFILLER_0_7_343 VGND VGND VPWR VPWR sky130_fd_sc_hd__fill_1
XFILLER_0_7_387 VGND VGND VPWR VPWR sky130_fd_sc_hd__decap_4
X_3649_ clknet_leaf_17_clk _0020_ VGND VGND VPWR VPWR display.counter\[3\] sky130_fd_sc_hd__dfxtp_1
XFILLER_0_15_165 VGND VGND VPWR VPWR sky130_fd_sc_hd__decap_3
X_1979_ reg_file.registers\[5\]\[26\] _0564_ _0568_ reg_file.registers\[15\]\[26\]
+ _0576_ VGND VGND VPWR VPWR _0577_ sky130_fd_sc_hd__a221o_1
XFILLER_0_11_393 VGND VGND VPWR VPWR sky130_fd_sc_hd__decap_4
XFILLER_0_53_249 VGND VGND VPWR VPWR sky130_fd_sc_hd__fill_1
XTAP_TAPCELL_ROW_26_366 VGND VPWR sky130_fd_sc_hd__tapvpwrvgnd_1
XFILLER_0_61_293 VGND VGND VPWR VPWR sky130_fd_sc_hd__fill_1
XFILLER_0_21_113 VGND VGND VPWR VPWR sky130_fd_sc_hd__fill_1
XFILLER_0_21_124 VPWR VGND VPWR VGND sky130_ef_sc_hd__decap_12
XFILLER_0_21_157 VGND VGND VPWR VPWR sky130_fd_sc_hd__decap_8
XFILLER_0_69_393 VPWR VGND VPWR VGND sky130_ef_sc_hd__decap_12
XTAP_TAPCELL_ROW_60_634 VGND VPWR sky130_fd_sc_hd__tapvpwrvgnd_1
X_2951_ _1501_ VGND VGND VPWR VPWR _0262_ sky130_fd_sc_hd__clkbuf_1
XFILLER_0_29_279 VGND VGND VPWR VPWR sky130_fd_sc_hd__fill_1
X_1902_ reg_file.registers\[10\]\[25\] _0519_ VGND VGND VPWR VPWR _0526_ sky130_fd_sc_hd__and2_1
XFILLER_0_16_66 VGND VGND VPWR VPWR sky130_fd_sc_hd__decap_8
X_2882_ reg_file.registers\[11\]\[6\] _1454_ _1058_ VGND VGND VPWR VPWR _1455_ sky130_fd_sc_hd__mux2_1
X_1764_ _0436_ VGND VGND VPWR VPWR _0384_ sky130_fd_sc_hd__clkbuf_1
XFILLER_0_40_433 VGND VGND VPWR VPWR sky130_fd_sc_hd__decap_4
X_3503_ clknet_leaf_0_clk _0265_ _0076_ VGND VGND VPWR VPWR reg_file.registers\[15\]\[19\]
+ sky130_fd_sc_hd__dfrtp_1
XFILLER_0_25_430 VPWR VGND VPWR VGND sky130_ef_sc_hd__decap_12
XFILLER_0_4_357 VGND VGND VPWR VPWR sky130_fd_sc_hd__decap_6
XFILLER_0_12_135 VGND VGND VPWR VPWR sky130_fd_sc_hd__decap_4
X_1833_ _0489_ VGND VGND VPWR VPWR _0368_ sky130_fd_sc_hd__clkbuf_1
XTAP_TAPCELL_ROW_68_701 VGND VPWR sky130_fd_sc_hd__tapvpwrvgnd_1
X_3296_ _1701_ VGND VGND VPWR VPWR _0090_ sky130_fd_sc_hd__inv_2
X_2316_ reg_file.registers\[11\]\[17\] _0862_ _0863_ reg_file.registers\[10\]\[17\]
+ VGND VGND VPWR VPWR _0914_ sky130_fd_sc_hd__a22o_1
X_3434_ _1719_ VGND VGND VPWR VPWR _0210_ sky130_fd_sc_hd__inv_2
X_3365_ _1709_ VGND VGND VPWR VPWR _0151_ sky130_fd_sc_hd__inv_2
XFILLER_0_67_319 VGND VGND VPWR VPWR sky130_fd_sc_hd__fill_1
X_2247_ _0816_ _0821_ _0840_ _0843_ _0844_ VGND VGND VPWR VPWR _0845_ sky130_fd_sc_hd__a32o_1
X_2178_ _0641_ _0635_ net29 VGND VGND VPWR VPWR _0776_ sky130_fd_sc_hd__nor3_4
XFILLER_0_25_3 VPWR VGND VPWR VGND sky130_ef_sc_hd__decap_12
XFILLER_0_35_249 VPWR VGND VPWR VGND sky130_ef_sc_hd__decap_12
XFILLER_0_28_290 VPWR VGND VPWR VGND sky130_ef_sc_hd__decap_12
XTAP_TAPCELL_ROW_23_336 VGND VPWR sky130_fd_sc_hd__tapvpwrvgnd_1
XFILLER_0_16_430 VGND VGND VPWR VPWR sky130_fd_sc_hd__fill_1
Xoutput13 net13 VGND VGND VPWR VPWR seg[3] sky130_fd_sc_hd__buf_1
XPHY_EDGE_ROW_19_Right_19 VGND VGND VPWR VPWR sky130_fd_sc_hd__decap_3
XFILLER_0_66_385 VPWR VGND VPWR VGND sky130_ef_sc_hd__decap_12
XFILLER_0_22_444 VGND VGND VPWR VPWR sky130_fd_sc_hd__decap_6
XFILLER_0_1_305 VPWR VGND VPWR VGND sky130_ef_sc_hd__decap_12
XPHY_EDGE_ROW_28_Right_28 VGND VGND VPWR VPWR sky130_fd_sc_hd__decap_3
X_3150_ _1616_ _1645_ _1646_ VGND VGND VPWR VPWR _1647_ sky130_fd_sc_hd__a21o_1
XFILLER_0_1_349 VPWR VGND VPWR VGND sky130_ef_sc_hd__decap_12
X_2032_ reg_file.registers\[5\]\[9\] _0563_ _0566_ reg_file.registers\[15\]\[9\] _0629_
+ VGND VGND VPWR VPWR _0630_ sky130_fd_sc_hd__a221o_1
XPHY_EDGE_ROW_37_Right_37 VGND VGND VPWR VPWR sky130_fd_sc_hd__decap_3
X_3081_ _0477_ _0414_ VGND VGND VPWR VPWR _1583_ sky130_fd_sc_hd__nor2_1
XFILLER_0_27_76 VGND VGND VPWR VPWR sky130_fd_sc_hd__decap_6
X_2101_ reg_file.registers\[11\]\[29\] _0694_ _0698_ reg_file.registers\[10\]\[29\]
+ VGND VGND VPWR VPWR _0699_ sky130_fd_sc_hd__a22o_1
X_2865_ _1063_ _1439_ _1440_ _1200_ _1298_ VGND VGND VPWR VPWR _1441_ sky130_fd_sc_hd__a32o_1
XFILLER_0_9_449 VGND VGND VPWR VPWR sky130_fd_sc_hd__fill_2
X_2934_ _1492_ VGND VGND VPWR VPWR _0270_ sky130_fd_sc_hd__clkbuf_1
XTAP_TAPCELL_ROW_20_317 VGND VPWR sky130_fd_sc_hd__tapvpwrvgnd_1
X_1816_ prev_control VGND VGND VPWR VPWR _0478_ sky130_fd_sc_hd__inv_2
XPHY_EDGE_ROW_46_Right_46 VGND VGND VPWR VPWR sky130_fd_sc_hd__decap_3
X_2796_ _0752_ _1380_ VGND VGND VPWR VPWR _1381_ sky130_fd_sc_hd__nand2_1
X_1747_ reg_file.registers\[2\]\[19\] VGND VGND VPWR VPWR _0428_ sky130_fd_sc_hd__clkbuf_1
XFILLER_0_25_293 VPWR VGND VPWR VGND sky130_ef_sc_hd__decap_12
XFILLER_0_4_165 VPWR VGND VPWR VGND sky130_ef_sc_hd__decap_12
XFILLER_0_4_121 VPWR VGND VPWR VGND sky130_ef_sc_hd__decap_12
XPHY_EDGE_ROW_15_Left_87 VGND VGND VPWR VPWR sky130_fd_sc_hd__decap_3
XPHY_EDGE_ROW_55_Right_55 VGND VGND VPWR VPWR sky130_fd_sc_hd__decap_3
X_3417_ _1717_ VGND VGND VPWR VPWR _0195_ sky130_fd_sc_hd__inv_2
X_3348_ _1707_ VGND VGND VPWR VPWR _0136_ sky130_fd_sc_hd__inv_2
X_3279_ _1692_ VGND VGND VPWR VPWR _1698_ sky130_fd_sc_hd__buf_4
XFILLER_0_0_393 VPWR VGND VPWR VGND sky130_ef_sc_hd__decap_12
XTAP_TAPCELL_ROW_71_729 VGND VPWR sky130_fd_sc_hd__tapvpwrvgnd_1
XPHY_EDGE_ROW_64_Right_64 VGND VGND VPWR VPWR sky130_fd_sc_hd__decap_3
XFILLER_0_63_399 VGND VGND VPWR VPWR sky130_fd_sc_hd__fill_2
XFILLER_0_54_333 VGND VGND VPWR VPWR sky130_fd_sc_hd__decap_4
XFILLER_0_6_419 VGND VGND VPWR VPWR sky130_fd_sc_hd__fill_1
X_2650_ _0680_ _0752_ VGND VGND VPWR VPWR _1244_ sky130_fd_sc_hd__and2_2
X_2581_ _1017_ _1176_ VGND VGND VPWR VPWR _1177_ sky130_fd_sc_hd__and2_1
XFILLER_0_1_113 VPWR VGND VPWR VGND sky130_ef_sc_hd__decap_12
X_3133_ _0477_ _0415_ VGND VGND VPWR VPWR _1632_ sky130_fd_sc_hd__nor2_1
X_3202_ _1678_ _1679_ VGND VGND VPWR VPWR _0010_ sky130_fd_sc_hd__nor2_1
XFILLER_0_10_447 VGND VGND VPWR VPWR sky130_fd_sc_hd__fill_1
X_2015_ net47 _0612_ VGND VGND VPWR VPWR _0613_ sky130_fd_sc_hd__nor2_1
XFILLER_0_54_85 VGND VGND VPWR VPWR sky130_fd_sc_hd__decap_8
X_3064_ _1160_ _1566_ _1004_ VGND VGND VPWR VPWR _1567_ sky130_fd_sc_hd__mux2_1
XTAP_TAPCELL_ROW_33_420 VGND VPWR sky130_fd_sc_hd__tapvpwrvgnd_1
XFILLER_0_70_62 VPWR VGND VPWR VGND sky130_ef_sc_hd__decap_12
XFILLER_0_60_336 VGND VGND VPWR VPWR sky130_fd_sc_hd__decap_8
X_2917_ _0470_ _0481_ VGND VGND VPWR VPWR _1483_ sky130_fd_sc_hd__or2_4
XFILLER_0_45_344 VGND VGND VPWR VPWR sky130_fd_sc_hd__decap_3
X_2848_ _0804_ _0845_ _1400_ VGND VGND VPWR VPWR _1427_ sky130_fd_sc_hd__or3_1
XFILLER_0_9_279 VGND VGND VPWR VPWR sky130_fd_sc_hd__fill_1
X_2779_ _1362_ _1364_ _1365_ VGND VGND VPWR VPWR _1366_ sky130_fd_sc_hd__or3b_1
XFILLER_0_36_399 VGND VGND VPWR VPWR sky130_fd_sc_hd__fill_1
XFILLER_0_59_447 VGND VGND VPWR VPWR sky130_fd_sc_hd__fill_1
XTAP_TAPCELL_ROW_47_534 VGND VPWR sky130_fd_sc_hd__tapvpwrvgnd_1
XFILLER_0_24_88 VGND VGND VPWR VPWR sky130_fd_sc_hd__fill_1
X_2702_ _1293_ _0942_ VGND VGND VPWR VPWR _1294_ sky130_fd_sc_hd__xnor2_1
X_2495_ _0772_ VGND VGND VPWR VPWR _1092_ sky130_fd_sc_hd__inv_2
X_2564_ _1153_ _1158_ _1159_ VGND VGND VPWR VPWR _1160_ sky130_fd_sc_hd__o21ai_1
XFILLER_0_49_52 VGND VGND VPWR VPWR sky130_fd_sc_hd__decap_4
XFILLER_0_49_41 VGND VGND VPWR VPWR sky130_fd_sc_hd__fill_2
X_2633_ _1019_ _1143_ _1145_ VGND VGND VPWR VPWR _1228_ sky130_fd_sc_hd__a21o_1
XFILLER_0_2_433 VPWR VGND VPWR VGND sky130_ef_sc_hd__decap_12
XFILLER_0_10_233 VPWR VGND VPWR VGND sky130_ef_sc_hd__decap_12
XFILLER_0_10_277 VPWR VGND VPWR VGND sky130_ef_sc_hd__decap_12
X_3116_ _1150_ _1557_ display.digit_sel\[0\] display.digit_sel\[1\] _1614_ VGND VGND
+ VPWR VPWR _1615_ sky130_fd_sc_hd__a41o_1
XFILLER_0_4_65 VPWR VGND VPWR VGND sky130_ef_sc_hd__decap_12
X_3047_ _0455_ _1482_ imem.address\[5\] VGND VGND VPWR VPWR _1555_ sky130_fd_sc_hd__a21oi_1
XFILLER_0_65_417 VPWR VGND VPWR VGND sky130_ef_sc_hd__decap_12
XFILLER_0_18_344 VGND VGND VPWR VPWR sky130_fd_sc_hd__fill_1
XFILLER_0_45_174 VGND VGND VPWR VPWR sky130_fd_sc_hd__fill_1
XPHY_EDGE_ROW_36_Left_108 VGND VGND VPWR VPWR sky130_fd_sc_hd__decap_3
XFILLER_0_5_293 VPWR VGND VPWR VGND sky130_ef_sc_hd__decap_12
XPHY_EDGE_ROW_45_Left_117 VGND VGND VPWR VPWR sky130_fd_sc_hd__decap_3
XFILLER_0_41_391 VGND VGND VPWR VPWR sky130_fd_sc_hd__fill_1
XPHY_EDGE_ROW_18_Left_90 VGND VGND VPWR VPWR sky130_fd_sc_hd__decap_3
XTAP_TAPCELL_ROW_44_504 VGND VPWR sky130_fd_sc_hd__tapvpwrvgnd_1
XFILLER_0_68_299 VGND VGND VPWR VPWR sky130_fd_sc_hd__decap_8
XFILLER_0_68_288 VGND VGND VPWR VPWR sky130_fd_sc_hd__decap_3
XPHY_EDGE_ROW_54_Left_126 VGND VGND VPWR VPWR sky130_fd_sc_hd__decap_3
XTAP_TAPCELL_ROW_52_570 VGND VPWR sky130_fd_sc_hd__tapvpwrvgnd_1
XFILLER_0_36_141 VPWR VGND VPWR VGND sky130_ef_sc_hd__decap_12
XFILLER_0_51_177 VGND VGND VPWR VPWR sky130_fd_sc_hd__fill_2
XFILLER_0_51_144 VGND VGND VPWR VPWR sky130_fd_sc_hd__fill_1
XPHY_EDGE_ROW_63_Left_135 VGND VGND VPWR VPWR sky130_fd_sc_hd__decap_3
X_2280_ _0662_ _0667_ _0877_ VGND VGND VPWR VPWR _0878_ sky130_fd_sc_hd__o21ai_1
XFILLER_0_59_277 VGND VGND VPWR VPWR sky130_fd_sc_hd__decap_3
XFILLER_0_51_42 VGND VGND VPWR VPWR sky130_fd_sc_hd__fill_1
XFILLER_0_35_98 VPWR VGND VPWR VGND sky130_ef_sc_hd__decap_12
X_1995_ _0592_ _0555_ _0463_ VGND VGND VPWR VPWR _0593_ sky130_fd_sc_hd__o21ba_4
X_2616_ _1084_ VGND VGND VPWR VPWR _1211_ sky130_fd_sc_hd__inv_2
XFILLER_0_42_122 VGND VGND VPWR VPWR sky130_fd_sc_hd__decap_8
XTAP_TAPCELL_ROW_15_272 VGND VPWR sky130_fd_sc_hd__tapvpwrvgnd_1
XFILLER_0_15_325 VGND VGND VPWR VPWR sky130_fd_sc_hd__decap_8
X_3665_ clknet_leaf_16_clk _0017_ VGND VGND VPWR VPWR display.counter\[19\] sky130_fd_sc_hd__dfxtp_1
XFILLER_0_55_3 VGND VGND VPWR VPWR sky130_fd_sc_hd__decap_4
X_2478_ _1069_ _1074_ VGND VGND VPWR VPWR _1075_ sky130_fd_sc_hd__or2_1
X_3596_ clknet_leaf_0_clk _0358_ _0169_ VGND VGND VPWR VPWR reg_file.registers\[5\]\[16\]
+ sky130_fd_sc_hd__dfrtp_1
XFILLER_0_23_391 VGND VGND VPWR VPWR sky130_fd_sc_hd__fill_1
X_2547_ reg_file.registers\[11\]\[29\] _1114_ _1115_ reg_file.registers\[10\]\[29\]
+ VGND VGND VPWR VPWR _1144_ sky130_fd_sc_hd__a22o_1
XTAP_TAPCELL_ROW_66_684 VGND VPWR sky130_fd_sc_hd__tapvpwrvgnd_1
XTAP_TAPCELL_ROW_58_618 VGND VPWR sky130_fd_sc_hd__tapvpwrvgnd_1
XFILLER_0_65_225 VPWR VGND VPWR VGND sky130_ef_sc_hd__decap_12
Xclkload1 clknet_leaf_0_clk VGND VGND VPWR VPWR clkload1/Y sky130_fd_sc_hd__bufinv_16
XFILLER_0_18_141 VGND VGND VPWR VPWR sky130_fd_sc_hd__decap_4
XFILLER_0_33_133 VGND VGND VPWR VPWR sky130_fd_sc_hd__decap_3
XPHY_EDGE_ROW_3_Left_75 VGND VGND VPWR VPWR sky130_fd_sc_hd__decap_3
XTAP_TAPCELL_ROW_29_386 VGND VPWR sky130_fd_sc_hd__tapvpwrvgnd_1
X_1780_ _0444_ VGND VGND VPWR VPWR _0376_ sky130_fd_sc_hd__clkbuf_1
XFILLER_0_24_155 VGND VGND VPWR VPWR sky130_fd_sc_hd__fill_1
XTAP_TAPCELL_ROW_12_253 VGND VPWR sky130_fd_sc_hd__tapvpwrvgnd_1
X_3450_ clknet_leaf_9_clk _0219_ _0030_ VGND VGND VPWR VPWR imem.address\[5\] sky130_fd_sc_hd__dfrtp_2
X_3381_ _1712_ VGND VGND VPWR VPWR _0164_ sky130_fd_sc_hd__inv_2
X_2401_ reg_file.registers\[10\]\[21\] _0785_ _0786_ VGND VGND VPWR VPWR _0999_ sky130_fd_sc_hd__and3_1
X_2332_ _0865_ _0869_ _0929_ VGND VGND VPWR VPWR _0930_ sky130_fd_sc_hd__nor3_1
X_2194_ reg_file.registers\[11\]\[15\] _0790_ _0791_ reg_file.registers\[10\]\[15\]
+ VGND VGND VPWR VPWR _0792_ sky130_fd_sc_hd__a22o_1
X_2263_ _0859_ _0668_ _0675_ _0860_ VGND VGND VPWR VPWR _0861_ sky130_fd_sc_hd__a31o_1
XFILLER_0_1_55 VGND VGND VPWR VPWR sky130_fd_sc_hd__fill_1
XFILLER_0_62_228 VGND VGND VPWR VPWR sky130_fd_sc_hd__decap_8
XFILLER_0_62_85 VGND VGND VPWR VPWR sky130_fd_sc_hd__decap_3
XFILLER_0_62_41 VGND VGND VPWR VPWR sky130_fd_sc_hd__decap_8
XFILLER_0_47_225 VPWR VGND VPWR VGND sky130_ef_sc_hd__decap_12
XFILLER_0_47_214 VGND VGND VPWR VPWR sky130_fd_sc_hd__fill_1
XFILLER_0_15_111 VGND VGND VPWR VPWR sky130_fd_sc_hd__fill_1
XFILLER_0_43_431 VGND VGND VPWR VPWR sky130_fd_sc_hd__fill_1
X_3648_ clknet_leaf_17_clk _0019_ VGND VGND VPWR VPWR display.counter\[2\] sky130_fd_sc_hd__dfxtp_1
X_3579_ clknet_leaf_18_clk _0341_ _0152_ VGND VGND VPWR VPWR reg_file.registers\[10\]\[31\]
+ sky130_fd_sc_hd__dfrtp_1
X_1978_ reg_file.registers\[2\]\[26\] _0559_ VGND VGND VPWR VPWR _0576_ sky130_fd_sc_hd__and2_1
XTAP_TAPCELL_ROW_26_367 VGND VPWR sky130_fd_sc_hd__tapvpwrvgnd_1
XFILLER_0_21_136 VGND VGND VPWR VPWR sky130_fd_sc_hd__fill_1
XFILLER_0_21_169 VPWR VGND VPWR VGND sky130_ef_sc_hd__decap_12
XTAP_TAPCELL_ROW_60_635 VGND VPWR sky130_fd_sc_hd__tapvpwrvgnd_1
X_2881_ _1244_ _1451_ _1453_ _1063_ VGND VGND VPWR VPWR _1454_ sky130_fd_sc_hd__a22o_1
X_2950_ reg_file.registers\[15\]\[16\] _1495_ VGND VGND VPWR VPWR _1501_ sky130_fd_sc_hd__and2_1
XFILLER_0_29_225 VGND VGND VPWR VPWR sky130_fd_sc_hd__fill_1
X_1901_ _0525_ VGND VGND VPWR VPWR _0336_ sky130_fd_sc_hd__clkbuf_1
X_1832_ reg_file.registers\[5\]\[26\] _0483_ VGND VGND VPWR VPWR _0489_ sky130_fd_sc_hd__and2_1
X_1763_ reg_file.registers\[2\]\[11\] VGND VGND VPWR VPWR _0436_ sky130_fd_sc_hd__clkbuf_1
X_3502_ clknet_leaf_0_clk _0264_ _0075_ VGND VGND VPWR VPWR reg_file.registers\[15\]\[18\]
+ sky130_fd_sc_hd__dfrtp_1
XFILLER_0_25_442 VGND VGND VPWR VPWR sky130_fd_sc_hd__decap_6
XFILLER_0_25_420 VGND VGND VPWR VPWR sky130_fd_sc_hd__decap_3
X_3433_ _1719_ VGND VGND VPWR VPWR _0209_ sky130_fd_sc_hd__inv_2
XTAP_TAPCELL_ROW_68_702 VGND VPWR sky130_fd_sc_hd__tapvpwrvgnd_1
X_3295_ _1701_ VGND VGND VPWR VPWR _0089_ sky130_fd_sc_hd__inv_2
X_2246_ _0814_ _0815_ VGND VGND VPWR VPWR _0844_ sky130_fd_sc_hd__or2_1
X_2315_ reg_file.registers\[11\]\[16\] _0862_ _0863_ reg_file.registers\[10\]\[16\]
+ VGND VGND VPWR VPWR _0913_ sky130_fd_sc_hd__a22o_1
X_3364_ _1704_ VGND VGND VPWR VPWR _1709_ sky130_fd_sc_hd__buf_1
XFILLER_0_20_180 VPWR VGND VPWR VGND sky130_ef_sc_hd__decap_12
X_2177_ _0708_ _0774_ VGND VGND VPWR VPWR _0775_ sky130_fd_sc_hd__or2_1
XFILLER_0_18_3 VPWR VGND VPWR VGND sky130_ef_sc_hd__decap_12
XFILLER_0_43_261 VPWR VGND VPWR VGND sky130_ef_sc_hd__decap_12
XTAP_TAPCELL_ROW_23_337 VGND VPWR sky130_fd_sc_hd__tapvpwrvgnd_1
XFILLER_0_31_412 VGND VGND VPWR VPWR sky130_fd_sc_hd__decap_4
XFILLER_0_3_391 VGND VGND VPWR VPWR sky130_fd_sc_hd__fill_1
Xoutput14 net14 VGND VGND VPWR VPWR seg[4] sky130_fd_sc_hd__buf_1
XTAP_TAPCELL_ROW_39_470 VGND VPWR sky130_fd_sc_hd__tapvpwrvgnd_1
XFILLER_0_66_397 VPWR VGND VPWR VGND sky130_ef_sc_hd__decap_12
XFILLER_0_66_353 VGND VGND VPWR VPWR sky130_fd_sc_hd__decap_8
XFILLER_0_1_317 VPWR VGND VPWR VGND sky130_ef_sc_hd__decap_12
X_2100_ _0697_ VGND VGND VPWR VPWR _0698_ sky130_fd_sc_hd__buf_4
X_3080_ _1582_ VGND VGND VPWR VPWR _0414_ sky130_fd_sc_hd__clkbuf_1
X_2031_ reg_file.registers\[2\]\[9\] _0557_ VGND VGND VPWR VPWR _0629_ sky130_fd_sc_hd__and2_1
X_1815_ _0476_ VGND VGND VPWR VPWR _0477_ sky130_fd_sc_hd__clkbuf_4
X_2864_ _0827_ _1399_ _0837_ VGND VGND VPWR VPWR _1440_ sky130_fd_sc_hd__a21o_1
X_2795_ _1287_ _1265_ _0990_ VGND VGND VPWR VPWR _1380_ sky130_fd_sc_hd__mux2_1
XFILLER_0_4_133 VGND VGND VPWR VPWR sky130_fd_sc_hd__decap_6
X_2933_ reg_file.registers\[15\]\[24\] _1484_ VGND VGND VPWR VPWR _1492_ sky130_fd_sc_hd__and2_1
XTAP_TAPCELL_ROW_20_318 VGND VPWR sky130_fd_sc_hd__tapvpwrvgnd_1
X_3416_ _1717_ VGND VGND VPWR VPWR _0194_ sky130_fd_sc_hd__inv_2
XFILLER_0_40_253 VGND VGND VPWR VPWR sky130_fd_sc_hd__decap_3
X_1746_ _0427_ VGND VGND VPWR VPWR _0393_ sky130_fd_sc_hd__clkbuf_1
XFILLER_0_4_177 VPWR VGND VPWR VGND sky130_ef_sc_hd__decap_12
XFILLER_0_0_361 VGND VGND VPWR VPWR sky130_fd_sc_hd__decap_3
X_2229_ _0824_ _0825_ VGND VGND VPWR VPWR _0827_ sky130_fd_sc_hd__or2_1
X_3347_ _1707_ VGND VGND VPWR VPWR _0135_ sky130_fd_sc_hd__inv_2
X_3278_ _1697_ VGND VGND VPWR VPWR _0076_ sky130_fd_sc_hd__inv_2
XFILLER_0_67_106 VGND VGND VPWR VPWR sky130_fd_sc_hd__decap_6
XFILLER_0_63_312 VGND VGND VPWR VPWR sky130_fd_sc_hd__decap_3
XTAP_TAPCELL_ROW_36_440 VGND VPWR sky130_fd_sc_hd__tapvpwrvgnd_1
XFILLER_0_8_450 VGND VGND VPWR VPWR sky130_fd_sc_hd__fill_1
XFILLER_0_31_297 VGND VGND VPWR VPWR sky130_fd_sc_hd__decap_4
XFILLER_0_31_264 VPWR VGND VPWR VGND sky130_ef_sc_hd__decap_12
XFILLER_0_7_3 VPWR VGND VPWR VGND sky130_ef_sc_hd__decap_12
XFILLER_0_39_364 VPWR VGND VPWR VGND sky130_ef_sc_hd__decap_12
XFILLER_0_13_57 VPWR VGND VPWR VGND sky130_ef_sc_hd__decap_12
XFILLER_0_14_209 VPWR VGND VPWR VGND sky130_ef_sc_hd__decap_12
X_2580_ _1152_ _1174_ _1175_ VGND VGND VPWR VPWR _1176_ sky130_fd_sc_hd__o21ai_1
XFILLER_0_1_125 VPWR VGND VPWR VGND sky130_ef_sc_hd__decap_12
XFILLER_0_1_169 VPWR VGND VPWR VGND sky130_ef_sc_hd__decap_12
XFILLER_0_10_426 VGND VGND VPWR VPWR sky130_fd_sc_hd__decap_8
X_3063_ _1165_ VGND VGND VPWR VPWR _1566_ sky130_fd_sc_hd__inv_2
X_3132_ _1204_ _1203_ _0988_ _1423_ _1239_ VGND VGND VPWR VPWR _1631_ sky130_fd_sc_hd__o32a_1
X_3201_ display.counter\[12\] _1676_ VGND VGND VPWR VPWR _1679_ sky130_fd_sc_hd__nor2_1
X_2014_ reg_file.registers\[2\]\[5\] _0557_ _0611_ VGND VGND VPWR VPWR _0612_ sky130_fd_sc_hd__a21oi_1
XTAP_TAPCELL_ROW_33_421 VGND VPWR sky130_fd_sc_hd__tapvpwrvgnd_1
XFILLER_0_9_225 VPWR VGND VPWR VGND sky130_ef_sc_hd__decap_12
XFILLER_0_70_74 VGND VGND VPWR VPWR sky130_fd_sc_hd__decap_3
X_2916_ _0459_ _0479_ VGND VGND VPWR VPWR _1482_ sky130_fd_sc_hd__nor2_1
X_2847_ _1426_ VGND VGND VPWR VPWR _0291_ sky130_fd_sc_hd__clkbuf_1
X_2778_ _0875_ _0919_ _1324_ _1325_ _0988_ VGND VGND VPWR VPWR _1365_ sky130_fd_sc_hd__a311o_1
X_1729_ reg_file.registers\[2\]\[28\] VGND VGND VPWR VPWR _0419_ sky130_fd_sc_hd__clkbuf_1
XFILLER_0_13_264 VGND VGND VPWR VPWR sky130_fd_sc_hd__decap_8
XTAP_TAPCELL_ROW_47_535 VGND VPWR sky130_fd_sc_hd__tapvpwrvgnd_1
XTAP_TAPCELL_ROW_4_190 VGND VPWR sky130_fd_sc_hd__tapvpwrvgnd_1
X_2632_ _0991_ _1224_ _1226_ VGND VGND VPWR VPWR _1227_ sky130_fd_sc_hd__and3_1
X_2701_ _0933_ _0934_ _0936_ VGND VGND VPWR VPWR _1293_ sky130_fd_sc_hd__a21oi_1
XFILLER_0_2_401 VPWR VGND VPWR VGND sky130_ef_sc_hd__decap_12
X_2494_ reg_file.registers\[11\]\[8\] _1070_ _1072_ reg_file.registers\[10\]\[8\]
+ VGND VGND VPWR VPWR _1091_ sky130_fd_sc_hd__a22oi_1
X_2563_ _1155_ _0815_ VGND VGND VPWR VPWR _1159_ sky130_fd_sc_hd__or2_1
XFILLER_0_2_445 VGND VGND VPWR VPWR sky130_fd_sc_hd__decap_6
XFILLER_0_10_245 VGND VGND VPWR VPWR sky130_fd_sc_hd__decap_6
XFILLER_0_10_289 VGND VGND VPWR VPWR sky130_fd_sc_hd__decap_8
X_3046_ _1520_ _1554_ VGND VGND VPWR VPWR _0220_ sky130_fd_sc_hd__nor2_1
X_3115_ _1345_ _1579_ _1612_ _1613_ VGND VGND VPWR VPWR _1614_ sky130_fd_sc_hd__a211o_1
XFILLER_0_4_77 VGND VGND VPWR VPWR sky130_fd_sc_hd__decap_6
XFILLER_0_65_429 VGND VGND VPWR VPWR sky130_fd_sc_hd__decap_3
XFILLER_0_45_131 VGND VGND VPWR VPWR sky130_fd_sc_hd__fill_1
XFILLER_0_45_164 VGND VGND VPWR VPWR sky130_fd_sc_hd__decap_4
XFILLER_0_5_261 VPWR VGND VPWR VGND sky130_ef_sc_hd__decap_12
XFILLER_0_68_256 VPWR VGND VPWR VGND sky130_ef_sc_hd__decap_12
XTAP_TAPCELL_ROW_44_505 VGND VPWR sky130_fd_sc_hd__tapvpwrvgnd_1
XTAP_TAPCELL_ROW_1_160 VGND VPWR sky130_fd_sc_hd__tapvpwrvgnd_1
XTAP_TAPCELL_ROW_52_571 VGND VPWR sky130_fd_sc_hd__tapvpwrvgnd_1
XFILLER_0_51_156 VGND VGND VPWR VPWR sky130_fd_sc_hd__decap_3
XFILLER_0_51_101 VGND VGND VPWR VPWR sky130_fd_sc_hd__fill_2
XFILLER_0_36_153 VPWR VGND VPWR VGND sky130_ef_sc_hd__decap_12
XFILLER_0_51_167 VGND VGND VPWR VPWR sky130_fd_sc_hd__fill_1
XFILLER_0_32_370 VPWR VGND VPWR VGND sky130_ef_sc_hd__decap_12
XFILLER_0_35_11 VGND VGND VPWR VPWR sky130_fd_sc_hd__fill_1
XFILLER_0_59_223 VGND VGND VPWR VPWR sky130_fd_sc_hd__fill_1
X_1994_ reg_file.registers\[15\]\[3\] _0588_ _0590_ reg_file.registers\[5\]\[3\] _0591_
+ VGND VGND VPWR VPWR _0592_ sky130_fd_sc_hd__a221o_1
XTAP_TAPCELL_ROW_15_273 VGND VPWR sky130_fd_sc_hd__tapvpwrvgnd_1
XFILLER_0_70_421 VPWR VGND VPWR VGND sky130_ef_sc_hd__decap_12
X_3595_ clknet_leaf_3_clk _0357_ _0168_ VGND VGND VPWR VPWR reg_file.registers\[5\]\[15\]
+ sky130_fd_sc_hd__dfrtp_1
XFILLER_0_30_307 VGND VGND VPWR VPWR sky130_fd_sc_hd__fill_1
XFILLER_0_2_253 VPWR VGND VPWR VGND sky130_ef_sc_hd__decap_12
XFILLER_0_15_337 VGND VGND VPWR VPWR sky130_fd_sc_hd__fill_2
X_3664_ clknet_leaf_16_clk _0016_ VGND VGND VPWR VPWR display.counter\[18\] sky130_fd_sc_hd__dfxtp_1
X_2615_ _0961_ _0703_ VGND VGND VPWR VPWR _1210_ sky130_fd_sc_hd__nand2_1
X_2477_ reg_file.registers\[11\]\[0\] _1071_ _1073_ reg_file.registers\[10\]\[0\]
+ VGND VGND VPWR VPWR _1074_ sky130_fd_sc_hd__a22oi_4
XTAP_TAPCELL_ROW_58_619 VGND VPWR sky130_fd_sc_hd__tapvpwrvgnd_1
XFILLER_0_48_3 VGND VGND VPWR VPWR sky130_fd_sc_hd__decap_8
XTAP_TAPCELL_ROW_7_208 VGND VPWR sky130_fd_sc_hd__tapvpwrvgnd_1
X_2546_ _1141_ _1142_ _1069_ VGND VGND VPWR VPWR _1143_ sky130_fd_sc_hd__mux2_1
X_3029_ imem.address\[16\] _1526_ VGND VGND VPWR VPWR _0230_ sky130_fd_sc_hd__xor2_1
XTAP_TAPCELL_ROW_66_685 VGND VPWR sky130_fd_sc_hd__tapvpwrvgnd_1
XFILLER_0_38_407 VGND VGND VPWR VPWR sky130_fd_sc_hd__fill_2
XFILLER_0_65_237 VPWR VGND VPWR VGND sky130_ef_sc_hd__decap_12
Xclkload2 clknet_leaf_1_clk VGND VGND VPWR VPWR clkload2/Y sky130_fd_sc_hd__inv_6
XFILLER_0_18_175 VGND VGND VPWR VPWR sky130_fd_sc_hd__fill_1
XFILLER_0_18_197 VGND VGND VPWR VPWR sky130_fd_sc_hd__decap_6
XFILLER_0_56_204 VGND VGND VPWR VPWR sky130_fd_sc_hd__fill_1
XTAP_TAPCELL_ROW_29_387 VGND VPWR sky130_fd_sc_hd__tapvpwrvgnd_1
X_2400_ _0874_ VGND VGND VPWR VPWR _0998_ sky130_fd_sc_hd__inv_2
XFILLER_0_12_307 VGND VGND VPWR VPWR sky130_fd_sc_hd__fill_1
XTAP_TAPCELL_ROW_12_254 VGND VPWR sky130_fd_sc_hd__tapvpwrvgnd_1
X_3380_ _1712_ VGND VGND VPWR VPWR _0163_ sky130_fd_sc_hd__inv_2
X_2262_ _0580_ _0672_ VGND VGND VPWR VPWR _0860_ sky130_fd_sc_hd__nor2_1
X_2331_ reg_file.registers\[11\]\[22\] _0927_ _0928_ reg_file.registers\[10\]\[22\]
+ VGND VGND VPWR VPWR _0929_ sky130_fd_sc_hd__a22oi_2
XFILLER_0_20_362 VGND VGND VPWR VPWR sky130_fd_sc_hd__fill_2
X_2193_ _0726_ VGND VGND VPWR VPWR _0791_ sky130_fd_sc_hd__buf_2
XFILLER_0_55_281 VPWR VGND VPWR VGND sky130_ef_sc_hd__decap_12
XFILLER_0_47_237 VPWR VGND VPWR VGND sky130_ef_sc_hd__decap_12
XFILLER_0_43_410 VGND VGND VPWR VPWR sky130_fd_sc_hd__fill_1
X_1977_ _0574_ VGND VGND VPWR VPWR _0575_ sky130_fd_sc_hd__clkbuf_4
X_2529_ _1122_ _1125_ _1018_ VGND VGND VPWR VPWR _1126_ sky130_fd_sc_hd__mux2_1
X_3647_ clknet_leaf_18_clk _0018_ VGND VGND VPWR VPWR display.counter\[1\] sky130_fd_sc_hd__dfxtp_1
X_3578_ clknet_leaf_18_clk _0340_ _0151_ VGND VGND VPWR VPWR reg_file.registers\[10\]\[30\]
+ sky130_fd_sc_hd__dfrtp_1
XFILLER_0_38_237 VGND VGND VPWR VPWR sky130_fd_sc_hd__decap_4
XFILLER_0_61_240 VGND VGND VPWR VPWR sky130_fd_sc_hd__decap_4
XFILLER_0_69_340 VGND VGND VPWR VPWR sky130_fd_sc_hd__fill_2
XFILLER_0_69_373 VPWR VGND VPWR VGND sky130_ef_sc_hd__decap_12
XTAP_TAPCELL_ROW_60_636 VGND VPWR sky130_fd_sc_hd__tapvpwrvgnd_1
X_2880_ _0768_ _1452_ VGND VGND VPWR VPWR _1453_ sky130_fd_sc_hd__xnor2_1
XFILLER_0_37_292 VPWR VGND VPWR VGND sky130_ef_sc_hd__decap_12
XFILLER_0_37_281 VGND VGND VPWR VPWR sky130_fd_sc_hd__fill_2
XFILLER_0_8_109 VPWR VGND VPWR VGND sky130_ef_sc_hd__decap_12
X_1900_ reg_file.registers\[10\]\[26\] _0519_ VGND VGND VPWR VPWR _0525_ sky130_fd_sc_hd__and2_1
X_1831_ _0488_ VGND VGND VPWR VPWR _0369_ sky130_fd_sc_hd__clkbuf_1
X_1762_ _0435_ VGND VGND VPWR VPWR _0385_ sky130_fd_sc_hd__clkbuf_1
X_3501_ clknet_leaf_0_clk _0263_ _0074_ VGND VGND VPWR VPWR reg_file.registers\[15\]\[17\]
+ sky130_fd_sc_hd__dfrtp_1
X_3363_ _1708_ VGND VGND VPWR VPWR _0150_ sky130_fd_sc_hd__inv_2
XFILLER_0_12_115 VGND VGND VPWR VPWR sky130_fd_sc_hd__fill_1
X_3432_ _1719_ VGND VGND VPWR VPWR _0208_ sky130_fd_sc_hd__inv_2
XTAP_TAPCELL_ROW_68_703 VGND VPWR sky130_fd_sc_hd__tapvpwrvgnd_1
X_3294_ _1700_ VGND VGND VPWR VPWR _1701_ sky130_fd_sc_hd__buf_1
X_2176_ _0712_ _0768_ _0769_ _0773_ VGND VGND VPWR VPWR _0774_ sky130_fd_sc_hd__o211a_1
X_2245_ _0814_ _0842_ _0818_ _0819_ VGND VGND VPWR VPWR _0843_ sky130_fd_sc_hd__a22o_1
X_2314_ _0857_ _0911_ _0896_ _0882_ VGND VGND VPWR VPWR _0912_ sky130_fd_sc_hd__or4_4
XFILLER_0_20_192 VGND VGND VPWR VPWR sky130_fd_sc_hd__decap_4
XTAP_TAPCELL_ROW_23_338 VGND VPWR sky130_fd_sc_hd__tapvpwrvgnd_1
XFILLER_0_43_273 VGND VGND VPWR VPWR sky130_fd_sc_hd__decap_6
XFILLER_0_35_218 VGND VGND VPWR VPWR sky130_fd_sc_hd__decap_6
XPHY_EDGE_ROW_1_Right_1 VGND VGND VPWR VPWR sky130_fd_sc_hd__decap_3
Xoutput15 net15 VGND VGND VPWR VPWR seg[5] sky130_fd_sc_hd__buf_1
XFILLER_0_11_181 VPWR VGND VPWR VGND sky130_ef_sc_hd__decap_12
XTAP_TAPCELL_ROW_39_471 VGND VPWR sky130_fd_sc_hd__tapvpwrvgnd_1
XFILLER_0_26_229 VGND VGND VPWR VPWR sky130_fd_sc_hd__decap_8
XFILLER_0_19_281 VGND VGND VPWR VPWR sky130_fd_sc_hd__fill_1
XFILLER_0_34_295 VPWR VGND VPWR VGND sky130_ef_sc_hd__decap_12
XFILLER_0_34_262 VGND VGND VPWR VPWR sky130_fd_sc_hd__decap_8
XFILLER_0_22_413 VGND VGND VPWR VPWR sky130_fd_sc_hd__fill_1
XFILLER_0_1_329 VGND VGND VPWR VPWR sky130_fd_sc_hd__decap_6
X_2030_ _0573_ _0627_ _0578_ VGND VGND VPWR VPWR _0628_ sky130_fd_sc_hd__a21oi_2
XFILLER_0_57_343 VGND VGND VPWR VPWR sky130_fd_sc_hd__decap_6
XFILLER_0_43_44 VPWR VGND VPWR VGND sky130_ef_sc_hd__decap_12
XFILLER_0_43_11 VGND VGND VPWR VPWR sky130_fd_sc_hd__fill_2
X_2932_ _1491_ VGND VGND VPWR VPWR _0271_ sky130_fd_sc_hd__clkbuf_1
X_1814_ _0467_ _0475_ VGND VGND VPWR VPWR _0476_ sky130_fd_sc_hd__and2_1
X_2863_ _0827_ _0837_ _1399_ VGND VGND VPWR VPWR _1439_ sky130_fd_sc_hd__nand3_1
X_2794_ net31 _1322_ _1323_ VGND VGND VPWR VPWR _1379_ sky130_fd_sc_hd__or3_1
X_1745_ reg_file.registers\[2\]\[20\] VGND VGND VPWR VPWR _0427_ sky130_fd_sc_hd__clkbuf_1
XTAP_TAPCELL_ROW_20_319 VGND VPWR sky130_fd_sc_hd__tapvpwrvgnd_1
XFILLER_0_68_85 VGND VGND VPWR VPWR sky130_fd_sc_hd__fill_2
X_3415_ _1717_ VGND VGND VPWR VPWR _0193_ sky130_fd_sc_hd__inv_2
X_3346_ _1707_ VGND VGND VPWR VPWR _0134_ sky130_fd_sc_hd__inv_2
XFILLER_0_40_298 VGND VGND VPWR VPWR sky130_fd_sc_hd__decap_8
XFILLER_0_40_265 VGND VGND VPWR VPWR sky130_fd_sc_hd__decap_8
XFILLER_0_7_55 VGND VGND VPWR VPWR sky130_fd_sc_hd__fill_1
XFILLER_0_4_189 VGND VGND VPWR VPWR sky130_fd_sc_hd__decap_6
X_2159_ _0753_ _0755_ VGND VGND VPWR VPWR _0757_ sky130_fd_sc_hd__nor2_1
X_2228_ _0824_ _0825_ VGND VGND VPWR VPWR _0826_ sky130_fd_sc_hd__nand2_1
X_3277_ _1697_ VGND VGND VPWR VPWR _0075_ sky130_fd_sc_hd__inv_2
XFILLER_0_30_3 VPWR VGND VPWR VGND sky130_ef_sc_hd__decap_12
XFILLER_0_63_346 VPWR VGND VPWR VGND sky130_ef_sc_hd__decap_12
XFILLER_0_48_365 VPWR VGND VPWR VGND sky130_ef_sc_hd__decap_12
XFILLER_0_48_343 VGND VGND VPWR VPWR sky130_fd_sc_hd__decap_4
XTAP_TAPCELL_ROW_36_441 VGND VPWR sky130_fd_sc_hd__tapvpwrvgnd_1
XFILLER_0_31_276 VGND VGND VPWR VPWR sky130_fd_sc_hd__decap_4
XFILLER_0_58_107 VGND VGND VPWR VPWR sky130_fd_sc_hd__decap_4
XFILLER_0_39_321 VGND VGND VPWR VPWR sky130_fd_sc_hd__decap_3
XTAP_TAPCELL_ROW_42_488 VGND VPWR sky130_fd_sc_hd__tapvpwrvgnd_1
XFILLER_0_39_376 VGND VGND VPWR VPWR sky130_fd_sc_hd__decap_3
XFILLER_0_13_69 VGND VGND VPWR VPWR sky130_fd_sc_hd__fill_2
XFILLER_0_62_390 VGND VGND VPWR VPWR sky130_fd_sc_hd__decap_6
XFILLER_0_1_137 VPWR VGND VPWR VGND sky130_ef_sc_hd__decap_12
X_3200_ display.counter\[12\] _1676_ VGND VGND VPWR VPWR _1678_ sky130_fd_sc_hd__and2_1
XFILLER_0_10_416 VGND VGND VPWR VPWR sky130_fd_sc_hd__decap_4
X_2013_ reg_file.registers\[5\]\[5\] _0562_ _0566_ reg_file.registers\[15\]\[5\] VGND
+ VGND VPWR VPWR _0611_ sky130_fd_sc_hd__a22o_1
XFILLER_0_54_21 VGND VGND VPWR VPWR sky130_fd_sc_hd__decap_6
X_3062_ _1302_ _1157_ _1022_ VGND VGND VPWR VPWR _1565_ sky130_fd_sc_hd__mux2_1
X_3131_ _1108_ _1189_ _1197_ _1629_ _1332_ VGND VGND VPWR VPWR _1630_ sky130_fd_sc_hd__o2111ai_2
X_2915_ _1481_ VGND VGND VPWR VPWR _0278_ sky130_fd_sc_hd__clkbuf_1
XFILLER_0_49_118 VGND VGND VPWR VPWR sky130_fd_sc_hd__decap_8
XTAP_TAPCELL_ROW_33_422 VGND VPWR sky130_fd_sc_hd__tapvpwrvgnd_1
Xclkbuf_leaf_15_clk clknet_1_1__leaf_clk VGND VGND VPWR VPWR clknet_leaf_15_clk sky130_fd_sc_hd__clkbuf_8
XFILLER_0_9_237 VPWR VGND VPWR VGND sky130_ef_sc_hd__decap_12
X_2846_ reg_file.registers\[11\]\[13\] _1425_ _1376_ VGND VGND VPWR VPWR _1426_ sky130_fd_sc_hd__mux2_1
X_2777_ _1224_ _1226_ _1363_ VGND VGND VPWR VPWR _1364_ sky130_fd_sc_hd__a21oi_1
XFILLER_0_5_421 VGND VGND VPWR VPWR sky130_fd_sc_hd__fill_2
X_1728_ _0418_ VGND VGND VPWR VPWR _0402_ sky130_fd_sc_hd__clkbuf_1
XFILLER_0_0_181 VPWR VGND VPWR VGND sky130_ef_sc_hd__decap_12
X_3329_ _1705_ VGND VGND VPWR VPWR _0119_ sky130_fd_sc_hd__inv_2
XFILLER_0_63_165 VGND VGND VPWR VPWR sky130_fd_sc_hd__decap_3
XFILLER_0_51_305 VPWR VGND VPWR VGND sky130_ef_sc_hd__decap_12
XTAP_TAPCELL_ROW_4_191 VGND VPWR sky130_fd_sc_hd__tapvpwrvgnd_1
XFILLER_0_59_449 VGND VGND VPWR VPWR sky130_fd_sc_hd__fill_2
XFILLER_0_39_184 VPWR VGND VPWR VGND sky130_ef_sc_hd__decap_12
XFILLER_0_39_140 VGND VGND VPWR VPWR sky130_fd_sc_hd__fill_2
X_2562_ reg_file.registers\[11\]\[10\] _0862_ _0863_ reg_file.registers\[10\]\[10\]
+ VGND VGND VPWR VPWR _1158_ sky130_fd_sc_hd__a22o_1
XFILLER_0_42_316 VGND VGND VPWR VPWR sky130_fd_sc_hd__decap_8
X_2631_ _1025_ _1225_ VGND VGND VPWR VPWR _1226_ sky130_fd_sc_hd__nand2_1
XFILLER_0_40_34 VGND VGND VPWR VPWR sky130_fd_sc_hd__fill_1
XFILLER_0_27_346 VPWR VGND VPWR VGND sky130_ef_sc_hd__decap_12
XFILLER_0_2_413 VGND VGND VPWR VPWR sky130_fd_sc_hd__decap_6
X_2700_ _1292_ VGND VGND VPWR VPWR _0304_ sky130_fd_sc_hd__clkbuf_1
XFILLER_0_49_98 VGND VGND VPWR VPWR sky130_fd_sc_hd__fill_1
X_2493_ _1080_ _1089_ _1025_ VGND VGND VPWR VPWR _1090_ sky130_fd_sc_hd__mux2_1
Xclkbuf_leaf_4_clk clknet_1_0__leaf_clk VGND VGND VPWR VPWR clknet_leaf_4_clk sky130_fd_sc_hd__clkbuf_8
X_3045_ imem.address\[6\] _1519_ VGND VGND VPWR VPWR _1554_ sky130_fd_sc_hd__nor2_1
X_3114_ _1557_ _1383_ _1558_ _1291_ _1583_ VGND VGND VPWR VPWR _1613_ sky130_fd_sc_hd__a32o_1
XFILLER_0_33_305 VPWR VGND VPWR VGND sky130_ef_sc_hd__decap_12
X_2829_ _1409_ VGND VGND VPWR VPWR _1410_ sky130_fd_sc_hd__inv_2
XFILLER_0_41_393 VGND VGND VPWR VPWR sky130_fd_sc_hd__decap_6
XFILLER_0_26_390 VGND VGND VPWR VPWR sky130_fd_sc_hd__decap_4
XFILLER_0_5_273 VGND VGND VPWR VPWR sky130_fd_sc_hd__decap_6
XFILLER_0_68_268 VPWR VGND VPWR VGND sky130_ef_sc_hd__decap_12
XFILLER_0_56_419 VGND VGND VPWR VPWR sky130_fd_sc_hd__fill_1
XTAP_TAPCELL_ROW_44_506 VGND VPWR sky130_fd_sc_hd__tapvpwrvgnd_1
XTAP_TAPCELL_ROW_1_161 VGND VPWR sky130_fd_sc_hd__tapvpwrvgnd_1
XTAP_TAPCELL_ROW_52_572 VGND VPWR sky130_fd_sc_hd__tapvpwrvgnd_1
XFILLER_0_24_327 VGND VGND VPWR VPWR sky130_fd_sc_hd__decap_3
XFILLER_0_10_15 VPWR VGND VPWR VGND sky130_ef_sc_hd__decap_12
XFILLER_0_32_382 VGND VGND VPWR VPWR sky130_fd_sc_hd__decap_6
XFILLER_0_19_35 VGND VGND VPWR VPWR sky130_fd_sc_hd__fill_1
X_1993_ reg_file.registers\[2\]\[3\] net38 net60 reg_file.registers\[10\]\[3\] VGND
+ VGND VPWR VPWR _0591_ sky130_fd_sc_hd__a22o_1
XFILLER_0_51_55 VGND VGND VPWR VPWR sky130_fd_sc_hd__fill_1
XTAP_TAPCELL_ROW_15_274 VGND VPWR sky130_fd_sc_hd__tapvpwrvgnd_1
XFILLER_0_70_433 VPWR VGND VPWR VGND sky130_ef_sc_hd__decap_12
X_3594_ clknet_leaf_3_clk _0356_ _0167_ VGND VGND VPWR VPWR reg_file.registers\[5\]\[14\]
+ sky130_fd_sc_hd__dfrtp_1
XFILLER_0_23_393 VGND VGND VPWR VPWR sky130_fd_sc_hd__decap_8
XFILLER_0_23_371 VGND VGND VPWR VPWR sky130_fd_sc_hd__decap_4
XFILLER_0_2_265 VPWR VGND VPWR VGND sky130_ef_sc_hd__decap_12
XFILLER_0_2_221 VPWR VGND VPWR VGND sky130_ef_sc_hd__decap_12
XTAP_TAPCELL_ROW_7_209 VGND VPWR sky130_fd_sc_hd__tapvpwrvgnd_1
X_3663_ clknet_leaf_17_clk _0015_ VGND VGND VPWR VPWR display.counter\[17\] sky130_fd_sc_hd__dfxtp_1
Xclkload20 clknet_leaf_19_clk VGND VGND VPWR VPWR clkload20/Y sky130_fd_sc_hd__clkinv_8
X_2545_ reg_file.registers\[11\]\[27\] _1114_ _1115_ reg_file.registers\[10\]\[27\]
+ VGND VGND VPWR VPWR _1142_ sky130_fd_sc_hd__a22o_1
X_2614_ _0961_ _0703_ VGND VGND VPWR VPWR _1209_ sky130_fd_sc_hd__or2_1
X_2476_ _1072_ VGND VGND VPWR VPWR _1073_ sky130_fd_sc_hd__clkbuf_4
XTAP_TAPCELL_ROW_66_686 VGND VPWR sky130_fd_sc_hd__tapvpwrvgnd_1
X_3028_ _1527_ _1547_ VGND VGND VPWR VPWR _0231_ sky130_fd_sc_hd__nor2_1
XFILLER_0_65_249 VPWR VGND VPWR VGND sky130_ef_sc_hd__decap_12
XFILLER_0_61_411 VGND VGND VPWR VPWR sky130_fd_sc_hd__fill_1
XFILLER_0_58_290 VGND VGND VPWR VPWR sky130_fd_sc_hd__fill_1
XFILLER_0_33_179 VGND VGND VPWR VPWR sky130_fd_sc_hd__fill_2
Xclkload3 clknet_leaf_2_clk VGND VGND VPWR VPWR clkload3/Y sky130_fd_sc_hd__clkinv_8
XFILLER_0_21_319 VPWR VGND VPWR VGND sky130_ef_sc_hd__decap_12
XTAP_TAPCELL_ROW_29_388 VGND VPWR sky130_fd_sc_hd__tapvpwrvgnd_1
XFILLER_0_56_249 VGND VGND VPWR VPWR sky130_fd_sc_hd__decap_3
XFILLER_0_52_411 VGND VGND VPWR VPWR sky130_fd_sc_hd__decap_8
XFILLER_0_24_124 VPWR VGND VPWR VGND sky130_ef_sc_hd__decap_12
XTAP_TAPCELL_ROW_12_255 VGND VPWR sky130_fd_sc_hd__tapvpwrvgnd_1
XFILLER_0_21_47 VGND VGND VPWR VPWR sky130_fd_sc_hd__fill_1
X_2192_ _0725_ VGND VGND VPWR VPWR _0790_ sky130_fd_sc_hd__buf_2
XFILLER_0_46_22 VGND VGND VPWR VPWR sky130_fd_sc_hd__decap_6
X_2261_ _0642_ _0648_ _0661_ VGND VGND VPWR VPWR _0859_ sky130_fd_sc_hd__nor3_2
X_2330_ _0863_ VGND VGND VPWR VPWR _0928_ sky130_fd_sc_hd__clkbuf_4
XTAP_TAPCELL_ROW_63_656 VGND VPWR sky130_fd_sc_hd__tapvpwrvgnd_1
XFILLER_0_1_57 VPWR VGND VPWR VGND sky130_ef_sc_hd__decap_12
XFILLER_0_55_293 VGND VGND VPWR VPWR sky130_fd_sc_hd__decap_4
XFILLER_0_47_249 VGND VGND VPWR VPWR sky130_fd_sc_hd__decap_4
X_1976_ _0573_ VGND VGND VPWR VPWR _0574_ sky130_fd_sc_hd__buf_2
XFILLER_0_43_422 VGND VGND VPWR VPWR sky130_fd_sc_hd__fill_1
XFILLER_0_28_430 VGND VGND VPWR VPWR sky130_fd_sc_hd__decap_4
XFILLER_0_7_335 VGND VGND VPWR VPWR sky130_fd_sc_hd__fill_1
XFILLER_0_15_102 VGND VGND VPWR VPWR sky130_fd_sc_hd__decap_6
XFILLER_0_15_135 VGND VGND VPWR VPWR sky130_fd_sc_hd__fill_2
XFILLER_0_15_157 VGND VGND VPWR VPWR sky130_fd_sc_hd__decap_8
XFILLER_0_60_3 VGND VGND VPWR VPWR sky130_fd_sc_hd__decap_8
X_2528_ _1123_ _1124_ _1069_ VGND VGND VPWR VPWR _1125_ sky130_fd_sc_hd__mux2_1
X_3646_ clknet_leaf_18_clk _0007_ VGND VGND VPWR VPWR display.counter\[0\] sky130_fd_sc_hd__dfxtp_1
X_3577_ clknet_leaf_18_clk _0339_ _0150_ VGND VGND VPWR VPWR reg_file.registers\[10\]\[29\]
+ sky130_fd_sc_hd__dfrtp_1
X_2459_ _0989_ _1036_ _1056_ VGND VGND VPWR VPWR _1057_ sky130_fd_sc_hd__nand3_1
XFILLER_0_61_285 VGND VGND VPWR VPWR sky130_fd_sc_hd__decap_8
XFILLER_0_61_263 VGND VGND VPWR VPWR sky130_fd_sc_hd__decap_6
XFILLER_0_46_271 VGND VGND VPWR VPWR sky130_fd_sc_hd__fill_1
XFILLER_0_69_385 VGND VGND VPWR VPWR sky130_fd_sc_hd__decap_6
XTAP_TAPCELL_ROW_60_637 VGND VPWR sky130_fd_sc_hd__tapvpwrvgnd_1
X_1761_ reg_file.registers\[2\]\[12\] VGND VGND VPWR VPWR _0435_ sky130_fd_sc_hd__clkbuf_1
XFILLER_0_40_403 VGND VGND VPWR VPWR sky130_fd_sc_hd__decap_4
X_3500_ clknet_leaf_1_clk _0262_ _0073_ VGND VGND VPWR VPWR reg_file.registers\[15\]\[16\]
+ sky130_fd_sc_hd__dfrtp_1
XFILLER_0_32_24 VGND VGND VPWR VPWR sky130_fd_sc_hd__decap_4
X_1830_ reg_file.registers\[5\]\[27\] _0483_ VGND VGND VPWR VPWR _0488_ sky130_fd_sc_hd__and2_1
XFILLER_0_40_447 VGND VGND VPWR VPWR sky130_fd_sc_hd__fill_1
XFILLER_0_40_414 VGND VGND VPWR VPWR sky130_fd_sc_hd__decap_6
X_2313_ _0905_ _0910_ VGND VGND VPWR VPWR _0911_ sky130_fd_sc_hd__or2_1
X_3431_ _1714_ VGND VGND VPWR VPWR _1719_ sky130_fd_sc_hd__clkbuf_4
X_3362_ _1708_ VGND VGND VPWR VPWR _0149_ sky130_fd_sc_hd__inv_2
XPHY_EDGE_ROW_69_Left_141 VGND VGND VPWR VPWR sky130_fd_sc_hd__decap_3
X_2175_ _0706_ _0772_ VGND VGND VPWR VPWR _0773_ sky130_fd_sc_hd__nand2_1
X_2244_ reg_file.registers\[11\]\[11\] _0692_ _0841_ VGND VGND VPWR VPWR _0842_ sky130_fd_sc_hd__a21o_1
X_3293_ _1691_ VGND VGND VPWR VPWR _1700_ sky130_fd_sc_hd__clkbuf_2
XFILLER_0_35_208 VGND VGND VPWR VPWR sky130_fd_sc_hd__decap_6
XTAP_TAPCELL_ROW_23_339 VGND VPWR sky130_fd_sc_hd__tapvpwrvgnd_1
XFILLER_0_16_400 VGND VGND VPWR VPWR sky130_fd_sc_hd__decap_4
X_1959_ net41 VGND VGND VPWR VPWR _0557_ sky130_fd_sc_hd__buf_2
X_3629_ clknet_leaf_0_clk _0391_ _0202_ VGND VGND VPWR VPWR reg_file.registers\[2\]\[18\]
+ sky130_fd_sc_hd__dfrtp_1
XFILLER_0_31_447 VGND VGND VPWR VPWR sky130_fd_sc_hd__fill_1
XFILLER_0_28_271 VGND VGND VPWR VPWR sky130_fd_sc_hd__decap_6
XFILLER_0_3_393 VPWR VGND VPWR VGND sky130_ef_sc_hd__decap_12
Xoutput16 net16 VGND VGND VPWR VPWR seg[6] sky130_fd_sc_hd__buf_1
XFILLER_0_11_193 VPWR VGND VPWR VGND sky130_ef_sc_hd__decap_12
XFILLER_0_66_344 VGND VGND VPWR VPWR sky130_fd_sc_hd__decap_6
XFILLER_0_27_57 VPWR VGND VPWR VGND sky130_ef_sc_hd__decap_12
XFILLER_0_43_23 VGND VGND VPWR VPWR sky130_fd_sc_hd__decap_6
Xclkbuf_0_clk clk VGND VGND VPWR VPWR clknet_0_clk sky130_fd_sc_hd__clkbuf_16
XFILLER_0_17_208 VGND VGND VPWR VPWR sky130_fd_sc_hd__fill_1
X_2931_ reg_file.registers\[15\]\[25\] _1484_ VGND VGND VPWR VPWR _1491_ sky130_fd_sc_hd__and2_1
X_1813_ _0468_ _0469_ _0474_ VGND VGND VPWR VPWR _0475_ sky130_fd_sc_hd__nand3_1
X_2862_ _1438_ VGND VGND VPWR VPWR _0288_ sky130_fd_sc_hd__clkbuf_1
XFILLER_0_40_233 VPWR VGND VPWR VGND sky130_ef_sc_hd__decap_12
X_2793_ _1369_ VGND VGND VPWR VPWR _1378_ sky130_fd_sc_hd__inv_2
X_1744_ _0426_ VGND VGND VPWR VPWR _0394_ sky130_fd_sc_hd__clkbuf_1
XFILLER_0_13_447 VGND VGND VPWR VPWR sky130_fd_sc_hd__fill_1
XFILLER_0_68_75 VGND VGND VPWR VPWR sky130_fd_sc_hd__fill_2
X_3414_ _1717_ VGND VGND VPWR VPWR _0192_ sky130_fd_sc_hd__inv_2
X_3345_ _1707_ VGND VGND VPWR VPWR _0133_ sky130_fd_sc_hd__inv_2
X_3276_ _1697_ VGND VGND VPWR VPWR _0074_ sky130_fd_sc_hd__inv_2
XPHY_EDGE_ROW_15_Right_15 VGND VGND VPWR VPWR sky130_fd_sc_hd__decap_3
X_2158_ _0753_ _0755_ VGND VGND VPWR VPWR _0756_ sky130_fd_sc_hd__and2_1
X_2227_ reg_file.registers\[11\]\[8\] _0692_ _0697_ reg_file.registers\[10\]\[8\]
+ VGND VGND VPWR VPWR _0825_ sky130_fd_sc_hd__a22oi_4
XTAP_TAPCELL_ROW_36_442 VGND VPWR sky130_fd_sc_hd__tapvpwrvgnd_1
XPHY_EDGE_ROW_24_Right_24 VGND VGND VPWR VPWR sky130_fd_sc_hd__decap_3
XFILLER_0_23_3 VPWR VGND VPWR VGND sky130_ef_sc_hd__decap_12
X_2089_ _0679_ _0683_ _0686_ VGND VGND VPWR VPWR _0687_ sky130_fd_sc_hd__or3_1
XFILLER_0_63_358 VPWR VGND VPWR VGND sky130_ef_sc_hd__decap_12
XFILLER_0_48_377 VGND VGND VPWR VPWR sky130_fd_sc_hd__decap_6
XPHY_EDGE_ROW_33_Right_33 VGND VGND VPWR VPWR sky130_fd_sc_hd__decap_3
XFILLER_0_31_211 VPWR VGND VPWR VGND sky130_ef_sc_hd__decap_12
XPHY_EDGE_ROW_42_Right_42 VGND VGND VPWR VPWR sky130_fd_sc_hd__decap_3
XFILLER_0_39_333 VGND VGND VPWR VPWR sky130_fd_sc_hd__decap_3
XFILLER_0_13_15 VPWR VGND VPWR VGND sky130_ef_sc_hd__decap_12
XPHY_EDGE_ROW_51_Right_51 VGND VGND VPWR VPWR sky130_fd_sc_hd__decap_3
XTAP_TAPCELL_ROW_42_489 VGND VPWR sky130_fd_sc_hd__tapvpwrvgnd_1
XFILLER_0_39_388 VGND VGND VPWR VPWR sky130_fd_sc_hd__fill_1
XFILLER_0_22_211 VGND VGND VPWR VPWR sky130_fd_sc_hd__decap_4
XFILLER_0_1_105 VGND VGND VPWR VPWR sky130_fd_sc_hd__decap_6
X_3130_ _1022_ _0997_ _1128_ _1628_ VGND VGND VPWR VPWR _1629_ sky130_fd_sc_hd__a211o_1
XFILLER_0_22_266 VGND VGND VPWR VPWR sky130_fd_sc_hd__decap_6
XFILLER_0_1_149 VPWR VGND VPWR VGND sky130_ef_sc_hd__decap_12
XFILLER_0_10_439 VGND VGND VPWR VPWR sky130_fd_sc_hd__decap_8
XPHY_EDGE_ROW_60_Right_60 VGND VGND VPWR VPWR sky130_fd_sc_hd__decap_3
XFILLER_0_54_33 VGND VGND VPWR VPWR sky130_fd_sc_hd__fill_1
XFILLER_0_54_11 VGND VGND VPWR VPWR sky130_fd_sc_hd__fill_2
X_2012_ _0572_ _0609_ net20 VGND VGND VPWR VPWR _0610_ sky130_fd_sc_hd__a21o_2
X_3061_ _1561_ _1563_ _1014_ VGND VGND VPWR VPWR _1564_ sky130_fd_sc_hd__mux2_1
X_2914_ reg_file.registers\[11\]\[0\] _1480_ _1058_ VGND VGND VPWR VPWR _1481_ sky130_fd_sc_hd__mux2_1
XFILLER_0_57_152 VGND VGND VPWR VPWR sky130_fd_sc_hd__decap_3
X_2845_ _1065_ _1420_ _1421_ _1332_ _1424_ VGND VGND VPWR VPWR _1425_ sky130_fd_sc_hd__a32o_1
XTAP_TAPCELL_ROW_33_423 VGND VPWR sky130_fd_sc_hd__tapvpwrvgnd_1
XFILLER_0_9_205 VPWR VGND VPWR VGND sky130_ef_sc_hd__decap_12
XFILLER_0_9_249 VPWR VGND VPWR VGND sky130_ef_sc_hd__decap_12
XFILLER_0_60_328 VGND VGND VPWR VPWR sky130_fd_sc_hd__decap_3
XFILLER_0_60_306 VGND VGND VPWR VPWR sky130_fd_sc_hd__fill_2
X_2776_ _0741_ _1140_ VGND VGND VPWR VPWR _1363_ sky130_fd_sc_hd__nand2_1
X_1727_ reg_file.registers\[2\]\[29\] VGND VGND VPWR VPWR _0418_ sky130_fd_sc_hd__clkbuf_1
X_3259_ _1696_ VGND VGND VPWR VPWR _0058_ sky130_fd_sc_hd__inv_2
XFILLER_0_0_193 VGND VGND VPWR VPWR sky130_fd_sc_hd__decap_3
X_3328_ _1705_ VGND VGND VPWR VPWR _0118_ sky130_fd_sc_hd__inv_2
XFILLER_0_63_144 VGND VGND VPWR VPWR sky130_fd_sc_hd__decap_4
XFILLER_0_51_317 VPWR VGND VPWR VGND sky130_ef_sc_hd__decap_12
XFILLER_0_48_163 VGND VGND VPWR VPWR sky130_fd_sc_hd__decap_3
XTAP_TAPCELL_ROW_55_592 VGND VPWR sky130_fd_sc_hd__tapvpwrvgnd_1
XFILLER_0_54_100 VGND VGND VPWR VPWR sky130_fd_sc_hd__decap_6
XFILLER_0_39_196 VGND VGND VPWR VPWR sky130_fd_sc_hd__fill_2
XFILLER_0_27_358 VPWR VGND VPWR VGND sky130_ef_sc_hd__decap_12
XFILLER_0_24_36 VGND VGND VPWR VPWR sky130_fd_sc_hd__fill_1
X_2492_ _1084_ _1088_ _1018_ VGND VGND VPWR VPWR _1089_ sky130_fd_sc_hd__mux2_1
XFILLER_0_49_11 VGND VGND VPWR VPWR sky130_fd_sc_hd__decap_3
X_2561_ _1153_ _1154_ _1156_ VGND VGND VPWR VPWR _1157_ sky130_fd_sc_hd__o21ai_1
X_2630_ _1118_ _1122_ _1018_ VGND VGND VPWR VPWR _1225_ sky130_fd_sc_hd__mux2_1
XFILLER_0_49_88 VGND VGND VPWR VPWR sky130_fd_sc_hd__decap_6
X_3113_ _1415_ _1581_ _1611_ VGND VGND VPWR VPWR _1612_ sky130_fd_sc_hd__a21o_1
X_3044_ imem.address\[7\] _1520_ VGND VGND VPWR VPWR _0221_ sky130_fd_sc_hd__xor2_1
X_2828_ _1285_ _1259_ _1013_ VGND VGND VPWR VPWR _1409_ sky130_fd_sc_hd__mux2_1
XFILLER_0_33_317 VPWR VGND VPWR VGND sky130_ef_sc_hd__decap_12
XFILLER_0_18_336 VGND VGND VPWR VPWR sky130_fd_sc_hd__decap_8
X_2759_ _0923_ _1325_ _0881_ VGND VGND VPWR VPWR _1347_ sky130_fd_sc_hd__o21ai_1
XTAP_TAPCELL_ROW_52_573 VGND VPWR sky130_fd_sc_hd__tapvpwrvgnd_1
XTAP_TAPCELL_ROW_44_507 VGND VPWR sky130_fd_sc_hd__tapvpwrvgnd_1
XFILLER_0_36_133 VGND VGND VPWR VPWR sky130_fd_sc_hd__decap_6
XFILLER_0_36_111 VPWR VGND VPWR VGND sky130_ef_sc_hd__decap_12
XTAP_TAPCELL_ROW_1_162 VGND VPWR sky130_fd_sc_hd__tapvpwrvgnd_1
XFILLER_0_51_169 VGND VGND VPWR VPWR sky130_fd_sc_hd__decap_8
XFILLER_0_51_136 VGND VGND VPWR VPWR sky130_fd_sc_hd__decap_8
XFILLER_0_24_306 VGND VGND VPWR VPWR sky130_fd_sc_hd__fill_2
XFILLER_0_10_27 VGND VGND VPWR VPWR sky130_fd_sc_hd__fill_1
XFILLER_0_59_225 VGND VGND VPWR VPWR sky130_fd_sc_hd__decap_3
XFILLER_0_59_214 VGND VGND VPWR VPWR sky130_fd_sc_hd__decap_4
XFILLER_0_35_79 VPWR VGND VPWR VGND sky130_ef_sc_hd__decap_12
XFILLER_0_35_57 VPWR VGND VPWR VGND sky130_ef_sc_hd__decap_12
XFILLER_0_35_35 VGND VGND VPWR VPWR sky130_fd_sc_hd__fill_1
XPHY_EDGE_ROW_32_Left_104 VGND VGND VPWR VPWR sky130_fd_sc_hd__decap_3
XFILLER_0_70_445 VGND VGND VPWR VPWR sky130_fd_sc_hd__decap_6
XFILLER_0_70_401 VPWR VGND VPWR VGND sky130_ef_sc_hd__decap_12
X_1992_ _0589_ VGND VGND VPWR VPWR _0590_ sky130_fd_sc_hd__clkbuf_4
XPHY_EDGE_ROW_41_Left_113 VGND VGND VPWR VPWR sky130_fd_sc_hd__decap_3
XFILLER_0_27_177 VGND VGND VPWR VPWR sky130_fd_sc_hd__fill_1
X_3662_ clknet_leaf_17_clk _0014_ VGND VGND VPWR VPWR display.counter\[16\] sky130_fd_sc_hd__dfxtp_1
XTAP_TAPCELL_ROW_15_275 VGND VPWR sky130_fd_sc_hd__tapvpwrvgnd_1
Xclkload10 clknet_leaf_20_clk VGND VGND VPWR VPWR clkload10/Y sky130_fd_sc_hd__clkinv_4
X_2475_ _0771_ VGND VGND VPWR VPWR _1072_ sky130_fd_sc_hd__buf_2
X_3593_ clknet_leaf_4_clk _0355_ _0166_ VGND VGND VPWR VPWR reg_file.registers\[5\]\[13\]
+ sky130_fd_sc_hd__dfrtp_1
XFILLER_0_30_309 VPWR VGND VPWR VGND sky130_ef_sc_hd__decap_12
XFILLER_0_2_277 VPWR VGND VPWR VGND sky130_ef_sc_hd__decap_12
XFILLER_0_2_233 VPWR VGND VPWR VGND sky130_ef_sc_hd__decap_12
X_2613_ _1208_ VGND VGND VPWR VPWR _0307_ sky130_fd_sc_hd__clkbuf_1
X_2544_ reg_file.registers\[11\]\[28\] _1114_ _1115_ reg_file.registers\[10\]\[28\]
+ VGND VGND VPWR VPWR _1141_ sky130_fd_sc_hd__a22o_1
XPHY_EDGE_ROW_50_Left_122 VGND VGND VPWR VPWR sky130_fd_sc_hd__decap_3
X_3027_ imem.address\[16\] _1526_ imem.address\[17\] VGND VGND VPWR VPWR _1547_ sky130_fd_sc_hd__a21oi_1
XTAP_TAPCELL_ROW_66_687 VGND VPWR sky130_fd_sc_hd__tapvpwrvgnd_1
Xclkload4 clknet_leaf_3_clk VGND VGND VPWR VPWR clkload4/Y sky130_fd_sc_hd__clkinv_4
XTAP_TAPCELL_ROW_57_610 VGND VPWR sky130_fd_sc_hd__tapvpwrvgnd_1
XFILLER_0_29_409 VGND VGND VPWR VPWR sky130_fd_sc_hd__fill_1
XTAP_TAPCELL_ROW_29_389 VGND VPWR sky130_fd_sc_hd__tapvpwrvgnd_1
XFILLER_0_71_209 VPWR VGND VPWR VGND sky130_ef_sc_hd__decap_12
XFILLER_0_52_401 VGND VGND VPWR VPWR sky130_fd_sc_hd__fill_1
XFILLER_0_24_136 VGND VGND VPWR VPWR sky130_fd_sc_hd__decap_4
XFILLER_0_21_15 VPWR VGND VPWR VGND sky130_ef_sc_hd__decap_12
XFILLER_0_12_309 VGND VGND VPWR VPWR sky130_fd_sc_hd__decap_4
XFILLER_0_20_342 VPWR VGND VPWR VGND sky130_ef_sc_hd__decap_12
X_2191_ _0781_ _0784_ _0788_ VGND VGND VPWR VPWR _0789_ sky130_fd_sc_hd__nand3_2
X_2260_ _0676_ _0669_ _0662_ VGND VGND VPWR VPWR _0858_ sky130_fd_sc_hd__or3_4
XTAP_TAPCELL_ROW_63_657 VGND VPWR sky130_fd_sc_hd__tapvpwrvgnd_1
XFILLER_0_47_206 VGND VGND VPWR VPWR sky130_fd_sc_hd__decap_8
XFILLER_0_1_69 VPWR VGND VPWR VGND sky130_ef_sc_hd__decap_12
XFILLER_0_70_297 VGND VGND VPWR VPWR sky130_fd_sc_hd__decap_8
XFILLER_0_70_253 VPWR VGND VPWR VGND sky130_ef_sc_hd__decap_12
X_1975_ _0572_ VGND VGND VPWR VPWR _0573_ sky130_fd_sc_hd__buf_2
X_3645_ clknet_leaf_15_clk _0407_ VGND VGND VPWR VPWR display.digit_sel\[2\] sky130_fd_sc_hd__dfxtp_1
XFILLER_0_11_81 VPWR VGND VPWR VGND sky130_ef_sc_hd__decap_12
XFILLER_0_15_169 VPWR VGND VPWR VGND sky130_ef_sc_hd__decap_12
XFILLER_0_53_3 VPWR VGND VPWR VGND sky130_ef_sc_hd__decap_12
X_2527_ reg_file.registers\[11\]\[21\] _1071_ _1073_ reg_file.registers\[10\]\[21\]
+ VGND VGND VPWR VPWR _1124_ sky130_fd_sc_hd__a22o_1
X_2458_ _0750_ _1055_ VGND VGND VPWR VPWR _1056_ sky130_fd_sc_hd__nand2_1
X_3576_ clknet_leaf_18_clk _0338_ _0149_ VGND VGND VPWR VPWR reg_file.registers\[10\]\[28\]
+ sky130_fd_sc_hd__dfrtp_2
XFILLER_0_11_364 VPWR VGND VPWR VGND sky130_ef_sc_hd__decap_12
XFILLER_0_11_397 VGND VGND VPWR VPWR sky130_fd_sc_hd__fill_1
X_2389_ _0560_ _0477_ VGND VGND VPWR VPWR _0987_ sky130_fd_sc_hd__or2_1
XFILLER_0_46_283 VPWR VGND VPWR VGND sky130_ef_sc_hd__decap_12
XPHY_EDGE_ROW_7_Left_79 VGND VGND VPWR VPWR sky130_fd_sc_hd__decap_3
XFILLER_0_16_15 VPWR VGND VPWR VGND sky130_ef_sc_hd__decap_12
XFILLER_0_69_320 VGND VGND VPWR VPWR sky130_fd_sc_hd__decap_6
XTAP_TAPCELL_ROW_60_638 VGND VPWR sky130_fd_sc_hd__tapvpwrvgnd_1
XFILLER_0_29_206 VPWR VGND VPWR VGND sky130_ef_sc_hd__decap_12
XFILLER_0_52_286 VGND VGND VPWR VPWR sky130_fd_sc_hd__decap_4
XFILLER_0_52_253 VGND VGND VPWR VPWR sky130_fd_sc_hd__decap_6
XFILLER_0_44_209 VGND VGND VPWR VPWR sky130_fd_sc_hd__decap_3
X_1760_ _0434_ VGND VGND VPWR VPWR _0386_ sky130_fd_sc_hd__clkbuf_1
XFILLER_0_57_33 VGND VGND VPWR VPWR sky130_fd_sc_hd__decap_3
XFILLER_0_40_437 VGND VGND VPWR VPWR sky130_fd_sc_hd__fill_1
X_2312_ _0908_ _0909_ VGND VGND VPWR VPWR _0910_ sky130_fd_sc_hd__or2_1
X_3292_ _1699_ VGND VGND VPWR VPWR _0088_ sky130_fd_sc_hd__inv_2
X_3430_ _1718_ VGND VGND VPWR VPWR _0207_ sky130_fd_sc_hd__inv_2
X_3361_ _1708_ VGND VGND VPWR VPWR _0148_ sky130_fd_sc_hd__inv_2
XFILLER_0_12_139 VGND VGND VPWR VPWR sky130_fd_sc_hd__fill_1
X_2174_ reg_file.registers\[11\]\[7\] _0770_ _0771_ reg_file.registers\[10\]\[7\]
+ VGND VGND VPWR VPWR _0772_ sky130_fd_sc_hd__a22o_1
X_2243_ reg_file.registers\[10\]\[11\] _0785_ _0786_ VGND VGND VPWR VPWR _0841_ sky130_fd_sc_hd__and3_1
XFILLER_0_7_111 VGND VGND VPWR VPWR sky130_fd_sc_hd__fill_1
X_1889_ _0518_ VGND VGND VPWR VPWR _0519_ sky130_fd_sc_hd__buf_2
X_1958_ _0555_ VGND VGND VPWR VPWR _0556_ sky130_fd_sc_hd__buf_8
X_3628_ clknet_leaf_4_clk _0390_ _0201_ VGND VGND VPWR VPWR reg_file.registers\[2\]\[17\]
+ sky130_fd_sc_hd__dfrtp_1
XFILLER_0_3_361 VPWR VGND VPWR VGND sky130_ef_sc_hd__decap_12
X_3559_ clknet_leaf_12_clk _0321_ _0132_ VGND VGND VPWR VPWR reg_file.registers\[10\]\[11\]
+ sky130_fd_sc_hd__dfrtp_1
XFILLER_0_11_161 VGND VGND VPWR VPWR sky130_fd_sc_hd__decap_6
XFILLER_0_34_220 VGND VGND VPWR VPWR sky130_fd_sc_hd__decap_8
XFILLER_0_57_378 VPWR VGND VPWR VGND sky130_ef_sc_hd__decap_12
XFILLER_0_57_323 VGND VGND VPWR VPWR sky130_fd_sc_hd__fill_1
X_2861_ reg_file.registers\[11\]\[10\] _1437_ _1376_ VGND VGND VPWR VPWR _1438_ sky130_fd_sc_hd__mux2_1
XFILLER_0_43_57 VGND VGND VPWR VPWR sky130_fd_sc_hd__fill_2
X_2930_ _1490_ VGND VGND VPWR VPWR _0272_ sky130_fd_sc_hd__clkbuf_1
X_1812_ _0470_ _0473_ VGND VGND VPWR VPWR _0474_ sky130_fd_sc_hd__nand2_1
X_3413_ _1717_ VGND VGND VPWR VPWR _0191_ sky130_fd_sc_hd__inv_2
XFILLER_0_40_245 VGND VGND VPWR VPWR sky130_fd_sc_hd__decap_6
XFILLER_0_40_223 VGND VGND VPWR VPWR sky130_fd_sc_hd__fill_2
X_2792_ _1377_ VGND VGND VPWR VPWR _0297_ sky130_fd_sc_hd__clkbuf_1
X_1743_ reg_file.registers\[2\]\[21\] VGND VGND VPWR VPWR _0426_ sky130_fd_sc_hd__clkbuf_1
XFILLER_0_7_57 VPWR VGND VPWR VGND sky130_ef_sc_hd__decap_12
XFILLER_0_68_54 VGND VGND VPWR VPWR sky130_fd_sc_hd__fill_1
X_3344_ _1707_ VGND VGND VPWR VPWR _0132_ sky130_fd_sc_hd__inv_2
X_2226_ _0811_ _0823_ VGND VGND VPWR VPWR _0824_ sky130_fd_sc_hd__xnor2_1
X_3275_ _1697_ VGND VGND VPWR VPWR _0073_ sky130_fd_sc_hd__inv_2
X_2157_ reg_file.registers\[11\]\[4\] _0691_ _0754_ VGND VGND VPWR VPWR _0755_ sky130_fd_sc_hd__a21oi_2
XTAP_TAPCELL_ROW_36_443 VGND VPWR sky130_fd_sc_hd__tapvpwrvgnd_1
XFILLER_0_16_3 VPWR VGND VPWR VGND sky130_ef_sc_hd__decap_12
X_2088_ net52 _0685_ VGND VGND VPWR VPWR _0686_ sky130_fd_sc_hd__nor2_1
XFILLER_0_48_356 VGND VGND VPWR VPWR sky130_fd_sc_hd__decap_8
XFILLER_0_16_253 VGND VGND VPWR VPWR sky130_fd_sc_hd__decap_4
XFILLER_0_16_275 VGND VGND VPWR VPWR sky130_fd_sc_hd__fill_1
XFILLER_0_31_234 VPWR VGND VPWR VGND sky130_ef_sc_hd__decap_12
XFILLER_0_31_223 VGND VGND VPWR VPWR sky130_fd_sc_hd__fill_1
XFILLER_0_54_337 VGND VGND VPWR VPWR sky130_fd_sc_hd__fill_1
XFILLER_0_13_27 VPWR VGND VPWR VGND sky130_ef_sc_hd__decap_12
XFILLER_0_10_407 VGND VGND VPWR VPWR sky130_fd_sc_hd__decap_6
X_3060_ _1562_ _1299_ _1022_ VGND VGND VPWR VPWR _1563_ sky130_fd_sc_hd__mux2_1
X_2011_ reg_file.registers\[15\]\[4\] _0588_ _0607_ _0608_ VGND VGND VPWR VPWR _0609_
+ sky130_fd_sc_hd__a211o_1
X_2913_ _1016_ _0718_ _0734_ _1332_ _1479_ VGND VGND VPWR VPWR _1480_ sky130_fd_sc_hd__a41o_1
X_2844_ _1423_ VGND VGND VPWR VPWR _1424_ sky130_fd_sc_hd__inv_2
XFILLER_0_9_217 VGND VGND VPWR VPWR sky130_fd_sc_hd__decap_6
X_2775_ _1215_ _1339_ _1341_ _1219_ VGND VGND VPWR VPWR _1362_ sky130_fd_sc_hd__a2bb2o_1
X_1726_ _0417_ VGND VGND VPWR VPWR _0403_ sky130_fd_sc_hd__clkbuf_1
XFILLER_0_13_223 VGND VGND VPWR VPWR sky130_fd_sc_hd__fill_1
XFILLER_0_13_278 VGND VGND VPWR VPWR sky130_fd_sc_hd__fill_2
X_3258_ _1696_ VGND VGND VPWR VPWR _0057_ sky130_fd_sc_hd__inv_2
X_2209_ _0776_ _0805_ _0806_ VGND VGND VPWR VPWR _0807_ sky130_fd_sc_hd__or3_4
X_3189_ display.counter\[7\] _1670_ VGND VGND VPWR VPWR _0024_ sky130_fd_sc_hd__xor2_1
X_3327_ _1705_ VGND VGND VPWR VPWR _0117_ sky130_fd_sc_hd__inv_2
XFILLER_0_68_407 VPWR VGND VPWR VGND sky130_ef_sc_hd__decap_12
XFILLER_0_63_101 VGND VGND VPWR VPWR sky130_fd_sc_hd__fill_2
XFILLER_0_36_326 VGND VGND VPWR VPWR sky130_fd_sc_hd__decap_4
XFILLER_0_51_329 VGND VGND VPWR VPWR sky130_fd_sc_hd__decap_6
XFILLER_0_36_337 VPWR VGND VPWR VGND sky130_ef_sc_hd__decap_12
XFILLER_0_5_3 VPWR VGND VPWR VGND sky130_ef_sc_hd__decap_12
XFILLER_0_24_15 VPWR VGND VPWR VGND sky130_ef_sc_hd__decap_12
XTAP_TAPCELL_ROW_55_593 VGND VPWR sky130_fd_sc_hd__tapvpwrvgnd_1
XFILLER_0_54_167 VGND VGND VPWR VPWR sky130_fd_sc_hd__fill_1
XFILLER_0_54_156 VGND VGND VPWR VPWR sky130_fd_sc_hd__fill_1
XFILLER_0_6_209 VPWR VGND VPWR VGND sky130_ef_sc_hd__decap_12
X_2491_ _1069_ _1085_ _1087_ VGND VGND VPWR VPWR _1088_ sky130_fd_sc_hd__a21oi_1
XFILLER_0_50_351 VPWR VGND VPWR VGND sky130_ef_sc_hd__decap_12
XFILLER_0_50_340 VGND VGND VPWR VPWR sky130_fd_sc_hd__fill_2
XFILLER_0_49_34 VGND VGND VPWR VPWR sky130_fd_sc_hd__fill_2
X_2560_ _1155_ _0806_ VGND VGND VPWR VPWR _1156_ sky130_fd_sc_hd__or2_1
X_3043_ _1521_ _1553_ VGND VGND VPWR VPWR _0222_ sky130_fd_sc_hd__nor2_1
XFILLER_0_65_55 VGND VGND VPWR VPWR sky130_fd_sc_hd__fill_1
X_3112_ _1437_ _1586_ _1610_ _1559_ VGND VGND VPWR VPWR _1611_ sky130_fd_sc_hd__a211o_1
XFILLER_0_60_148 VGND VGND VPWR VPWR sky130_fd_sc_hd__decap_6
XFILLER_0_45_178 VGND VGND VPWR VPWR sky130_fd_sc_hd__decap_8
X_2827_ _1408_ VGND VGND VPWR VPWR _0293_ sky130_fd_sc_hd__clkbuf_1
XFILLER_0_33_329 VGND VGND VPWR VPWR sky130_fd_sc_hd__decap_6
X_2758_ _1346_ VGND VGND VPWR VPWR _0300_ sky130_fd_sc_hd__clkbuf_1
X_2689_ _1278_ _1281_ _1003_ VGND VGND VPWR VPWR _1282_ sky130_fd_sc_hd__mux2_1
XTAP_TAPCELL_ROW_44_508 VGND VPWR sky130_fd_sc_hd__tapvpwrvgnd_1
XTAP_TAPCELL_ROW_1_163 VGND VPWR sky130_fd_sc_hd__tapvpwrvgnd_1
XFILLER_0_64_421 VPWR VGND VPWR VGND sky130_ef_sc_hd__decap_12
XTAP_TAPCELL_ROW_52_574 VGND VPWR sky130_fd_sc_hd__tapvpwrvgnd_1
XFILLER_0_36_178 VGND VGND VPWR VPWR sky130_fd_sc_hd__decap_4
XFILLER_0_36_123 VGND VGND VPWR VPWR sky130_fd_sc_hd__decap_6
XFILLER_0_51_148 VGND VGND VPWR VPWR sky130_fd_sc_hd__decap_8
XTAP_TAPCELL_ROW_9_230 VGND VPWR sky130_fd_sc_hd__tapvpwrvgnd_1
XFILLER_0_19_15 VPWR VGND VPWR VGND sky130_ef_sc_hd__decap_12
XFILLER_0_59_237 VPWR VGND VPWR VGND sky130_ef_sc_hd__decap_12
XFILLER_0_35_69 VGND VGND VPWR VPWR sky130_fd_sc_hd__decap_3
XFILLER_0_70_413 VGND VGND VPWR VPWR sky130_fd_sc_hd__decap_6
XFILLER_0_67_281 VPWR VGND VPWR VGND sky130_ef_sc_hd__decap_12
X_1991_ _0468_ _0469_ _0560_ VGND VGND VPWR VPWR _0589_ sky130_fd_sc_hd__and3_1
XFILLER_0_51_79 VPWR VGND VPWR VGND sky130_ef_sc_hd__decap_12
XFILLER_0_51_57 VGND VGND VPWR VPWR sky130_fd_sc_hd__decap_6
XFILLER_0_42_137 VGND VGND VPWR VPWR sky130_fd_sc_hd__decap_3
X_3592_ clknet_leaf_3_clk _0354_ _0165_ VGND VGND VPWR VPWR reg_file.registers\[5\]\[12\]
+ sky130_fd_sc_hd__dfrtp_1
X_3661_ clknet_leaf_17_clk _0013_ VGND VGND VPWR VPWR display.counter\[15\] sky130_fd_sc_hd__dfxtp_1
XTAP_TAPCELL_ROW_15_276 VGND VPWR sky130_fd_sc_hd__tapvpwrvgnd_1
X_2612_ _1206_ reg_file.registers\[11\]\[29\] _1207_ VGND VGND VPWR VPWR _1208_ sky130_fd_sc_hd__mux2_1
Xclkload11 clknet_leaf_21_clk VGND VGND VPWR VPWR clkload11/Y sky130_fd_sc_hd__clkinv_1
X_2474_ _1070_ VGND VGND VPWR VPWR _1071_ sky130_fd_sc_hd__clkbuf_4
X_2543_ _0715_ _1139_ VGND VGND VPWR VPWR _1140_ sky130_fd_sc_hd__and2_2
XFILLER_0_2_289 VPWR VGND VPWR VGND sky130_ef_sc_hd__decap_12
XFILLER_0_2_245 VGND VGND VPWR VPWR sky130_fd_sc_hd__decap_6
X_3026_ _1528_ _1546_ VGND VGND VPWR VPWR _0232_ sky130_fd_sc_hd__nor2_1
XFILLER_0_46_421 VGND VGND VPWR VPWR sky130_fd_sc_hd__fill_1
Xclkload5 clknet_leaf_4_clk VGND VGND VPWR VPWR clkload5/Y sky130_fd_sc_hd__clkinv_1
XFILLER_0_25_80 VPWR VGND VPWR VGND sky130_ef_sc_hd__decap_12
XFILLER_0_41_181 VPWR VGND VPWR VGND sky130_ef_sc_hd__decap_12
XTAP_TAPCELL_ROW_57_611 VGND VPWR sky130_fd_sc_hd__tapvpwrvgnd_1
XTAP_TAPCELL_ROW_6_200 VGND VPWR sky130_fd_sc_hd__tapvpwrvgnd_1
XFILLER_0_52_424 VGND VGND VPWR VPWR sky130_fd_sc_hd__decap_6
XFILLER_0_49_281 VGND VGND VPWR VPWR sky130_fd_sc_hd__decap_6
XFILLER_0_24_115 VGND VGND VPWR VPWR sky130_fd_sc_hd__fill_1
XFILLER_0_21_27 VPWR VGND VPWR VGND sky130_ef_sc_hd__decap_12
XFILLER_0_20_321 VGND VGND VPWR VPWR sky130_fd_sc_hd__decap_4
XFILLER_0_20_354 VGND VGND VPWR VPWR sky130_fd_sc_hd__decap_8
XFILLER_0_20_365 VGND VGND VPWR VPWR sky130_fd_sc_hd__decap_4
X_2190_ reg_file.registers\[11\]\[15\] _0693_ _0787_ VGND VGND VPWR VPWR _0788_ sky130_fd_sc_hd__a21oi_2
XFILLER_0_1_15 VPWR VGND VPWR VGND sky130_ef_sc_hd__decap_12
XTAP_TAPCELL_ROW_63_658 VGND VPWR sky130_fd_sc_hd__tapvpwrvgnd_1
X_1974_ _0467_ _0475_ _0554_ VGND VGND VPWR VPWR _0572_ sky130_fd_sc_hd__a21o_2
XFILLER_0_43_402 VGND VGND VPWR VPWR sky130_fd_sc_hd__decap_4
XFILLER_0_28_421 VGND VGND VPWR VPWR sky130_fd_sc_hd__decap_3
XPHY_EDGE_ROW_23_Left_95 VGND VGND VPWR VPWR sky130_fd_sc_hd__decap_3
XFILLER_0_7_337 VGND VGND VPWR VPWR sky130_fd_sc_hd__decap_6
XFILLER_0_70_265 VPWR VGND VPWR VGND sky130_ef_sc_hd__decap_12
XFILLER_0_70_232 VPWR VGND VPWR VGND sky130_ef_sc_hd__decap_12
X_3644_ clknet_leaf_15_clk _0406_ VGND VGND VPWR VPWR display.digit_sel\[1\] sky130_fd_sc_hd__dfxtp_1
XFILLER_0_11_93 VPWR VGND VPWR VGND sky130_ef_sc_hd__decap_12
XFILLER_0_11_310 VGND VGND VPWR VPWR sky130_fd_sc_hd__decap_8
X_3575_ clknet_leaf_18_clk _0337_ _0148_ VGND VGND VPWR VPWR reg_file.registers\[10\]\[27\]
+ sky130_fd_sc_hd__dfrtp_1
XFILLER_0_46_3 VPWR VGND VPWR VGND sky130_ef_sc_hd__decap_12
X_2457_ _1045_ _1054_ _0991_ VGND VGND VPWR VPWR _1055_ sky130_fd_sc_hd__mux2_1
X_2526_ reg_file.registers\[11\]\[22\] _1071_ _1073_ reg_file.registers\[10\]\[22\]
+ VGND VGND VPWR VPWR _1123_ sky130_fd_sc_hd__a22o_1
X_2388_ _0964_ _0973_ _0976_ _0984_ VGND VGND VPWR VPWR _0986_ sky130_fd_sc_hd__o211a_1
XFILLER_0_11_376 VPWR VGND VPWR VGND sky130_ef_sc_hd__decap_12
X_3009_ imem.address\[28\] _1534_ VGND VGND VPWR VPWR _0242_ sky130_fd_sc_hd__xor2_1
XFILLER_0_46_295 VPWR VGND VPWR VGND sky130_ef_sc_hd__decap_12
XFILLER_0_46_251 VGND VGND VPWR VPWR sky130_fd_sc_hd__fill_1
XFILLER_0_16_27 VGND VGND VPWR VPWR sky130_fd_sc_hd__fill_1
XTAP_TAPCELL_ROW_60_639 VGND VPWR sky130_fd_sc_hd__tapvpwrvgnd_1
XFILLER_0_37_240 VPWR VGND VPWR VGND sky130_ef_sc_hd__decap_12
XFILLER_0_32_15 VGND VGND VPWR VPWR sky130_fd_sc_hd__fill_2
XFILLER_0_29_218 VGND VGND VPWR VPWR sky130_fd_sc_hd__decap_6
XFILLER_0_52_265 VPWR VGND VPWR VGND sky130_ef_sc_hd__decap_12
XFILLER_0_37_273 VGND VGND VPWR VPWR sky130_fd_sc_hd__decap_6
XFILLER_0_4_307 VGND VGND VPWR VPWR sky130_fd_sc_hd__fill_1
X_2242_ _0839_ _0835_ _0836_ VGND VGND VPWR VPWR _0840_ sky130_fd_sc_hd__a21bo_1
X_2311_ _0906_ _0907_ VGND VGND VPWR VPWR _0909_ sky130_fd_sc_hd__and2_1
X_3291_ _1699_ VGND VGND VPWR VPWR _0087_ sky130_fd_sc_hd__inv_2
X_3360_ _1708_ VGND VGND VPWR VPWR _0147_ sky130_fd_sc_hd__inv_2
XFILLER_0_20_151 VPWR VGND VPWR VGND sky130_ef_sc_hd__decap_12
X_2173_ _0473_ _0770_ net26 _0469_ VGND VGND VPWR VPWR _0771_ sky130_fd_sc_hd__and4bb_1
X_1957_ _0467_ _0475_ _0554_ VGND VGND VPWR VPWR _0555_ sky130_fd_sc_hd__a21oi_4
XFILLER_0_22_92 VPWR VGND VPWR VGND sky130_ef_sc_hd__decap_12
XFILLER_0_7_167 VGND VGND VPWR VPWR sky130_fd_sc_hd__fill_1
X_1888_ _0464_ _0481_ VGND VGND VPWR VPWR _0518_ sky130_fd_sc_hd__or2_1
X_3558_ clknet_leaf_12_clk _0320_ _0131_ VGND VGND VPWR VPWR reg_file.registers\[10\]\[10\]
+ sky130_fd_sc_hd__dfrtp_1
X_2509_ _1098_ _1105_ _0742_ VGND VGND VPWR VPWR _1106_ sky130_fd_sc_hd__mux2_1
X_3627_ clknet_leaf_0_clk _0389_ _0200_ VGND VGND VPWR VPWR reg_file.registers\[2\]\[16\]
+ sky130_fd_sc_hd__dfrtp_1
XFILLER_0_31_449 VGND VGND VPWR VPWR sky130_fd_sc_hd__fill_2
XFILLER_0_3_373 VPWR VGND VPWR VGND sky130_ef_sc_hd__decap_12
X_3489_ clknet_leaf_5_clk _0251_ _0062_ VGND VGND VPWR VPWR reg_file.registers\[15\]\[5\]
+ sky130_fd_sc_hd__dfrtp_1
XFILLER_0_34_276 VPWR VGND VPWR VGND sky130_ef_sc_hd__decap_12
XTAP_TAPCELL_ROW_22_330 VGND VPWR sky130_fd_sc_hd__tapvpwrvgnd_1
XFILLER_0_27_15 VGND VGND VPWR VPWR sky130_fd_sc_hd__decap_3
X_1811_ _0471_ _0472_ VGND VGND VPWR VPWR _0473_ sky130_fd_sc_hd__and2_1
XFILLER_0_65_390 VGND VGND VPWR VPWR sky130_fd_sc_hd__fill_2
XFILLER_0_57_335 VGND VGND VPWR VPWR sky130_fd_sc_hd__fill_1
X_2860_ _1332_ _1267_ _1436_ _1064_ VGND VGND VPWR VPWR _1437_ sky130_fd_sc_hd__a22o_1
X_2791_ reg_file.registers\[11\]\[19\] _1375_ _1376_ VGND VGND VPWR VPWR _1377_ sky130_fd_sc_hd__mux2_1
X_3412_ _1717_ VGND VGND VPWR VPWR _0190_ sky130_fd_sc_hd__inv_2
XFILLER_0_40_279 VPWR VGND VPWR VGND sky130_ef_sc_hd__decap_12
XFILLER_0_25_254 VGND VGND VPWR VPWR sky130_fd_sc_hd__fill_1
X_1742_ _0425_ VGND VGND VPWR VPWR _0395_ sky130_fd_sc_hd__clkbuf_1
XFILLER_0_7_69 VPWR VGND VPWR VGND sky130_ef_sc_hd__decap_12
XFILLER_0_0_321 VPWR VGND VPWR VGND sky130_ef_sc_hd__decap_12
XFILLER_0_13_449 VGND VGND VPWR VPWR sky130_fd_sc_hd__fill_2
X_3343_ _1707_ VGND VGND VPWR VPWR _0131_ sky130_fd_sc_hd__inv_2
X_2225_ _0578_ _0633_ VGND VGND VPWR VPWR _0823_ sky130_fd_sc_hd__or2_1
X_3274_ _1697_ VGND VGND VPWR VPWR _0072_ sky130_fd_sc_hd__inv_2
XFILLER_0_0_365 VPWR VGND VPWR VGND sky130_ef_sc_hd__decap_12
X_2156_ reg_file.registers\[10\]\[4\] net17 _0732_ VGND VGND VPWR VPWR _0754_ sky130_fd_sc_hd__and3_1
XTAP_TAPCELL_ROW_36_444 VGND VPWR sky130_fd_sc_hd__tapvpwrvgnd_1
XPHY_EDGE_ROW_5_Right_5 VGND VGND VPWR VPWR sky130_fd_sc_hd__decap_3
XFILLER_0_8_410 VGND VGND VPWR VPWR sky130_fd_sc_hd__decap_8
XFILLER_0_8_421 VPWR VGND VPWR VGND sky130_ef_sc_hd__decap_12
Xclkbuf_leaf_18_clk clknet_1_1__leaf_clk VGND VGND VPWR VPWR clknet_leaf_18_clk sky130_fd_sc_hd__clkbuf_8
X_2087_ reg_file.registers\[2\]\[29\] _0559_ _0684_ VGND VGND VPWR VPWR _0685_ sky130_fd_sc_hd__a21oi_1
XFILLER_0_71_393 VPWR VGND VPWR VGND sky130_ef_sc_hd__decap_12
X_2989_ imem.address\[11\] imem.address\[10\] _1522_ VGND VGND VPWR VPWR _1523_ sky130_fd_sc_hd__and3_1
XFILLER_0_31_246 VPWR VGND VPWR VGND sky130_ef_sc_hd__decap_12
XFILLER_0_3_181 VPWR VGND VPWR VGND sky130_ef_sc_hd__decap_12
XPHY_EDGE_ROW_10_Left_82 VGND VGND VPWR VPWR sky130_fd_sc_hd__decap_3
XTAP_TAPCELL_ROW_70_712 VGND VPWR sky130_fd_sc_hd__tapvpwrvgnd_1
XFILLER_0_66_154 VGND VGND VPWR VPWR sky130_fd_sc_hd__decap_3
XFILLER_0_66_121 VPWR VGND VPWR VGND sky130_ef_sc_hd__decap_12
XFILLER_0_54_305 VGND VGND VPWR VPWR sky130_fd_sc_hd__decap_3
XFILLER_0_39_346 VPWR VGND VPWR VGND sky130_ef_sc_hd__decap_12
XFILLER_0_13_39 VPWR VGND VPWR VGND sky130_ef_sc_hd__decap_12
X_2010_ reg_file.registers\[5\]\[4\] _0590_ VGND VGND VPWR VPWR _0608_ sky130_fd_sc_hd__and2_2
X_2912_ _0735_ _1478_ _1065_ VGND VGND VPWR VPWR _1479_ sky130_fd_sc_hd__o21a_1
XFILLER_0_57_143 VGND VGND VPWR VPWR sky130_fd_sc_hd__fill_1
XFILLER_0_54_57 VGND VGND VPWR VPWR sky130_fd_sc_hd__fill_2
XFILLER_0_53_393 VPWR VGND VPWR VGND sky130_ef_sc_hd__decap_12
XFILLER_0_53_360 VPWR VGND VPWR VGND sky130_ef_sc_hd__decap_12
XFILLER_0_45_305 VGND VGND VPWR VPWR sky130_fd_sc_hd__decap_8
X_2843_ _1108_ _1353_ _1422_ VGND VGND VPWR VPWR _1423_ sky130_fd_sc_hd__a21oi_1
XTAP_TAPCELL_ROW_41_480 VGND VPWR sky130_fd_sc_hd__tapvpwrvgnd_1
X_2774_ _1361_ VGND VGND VPWR VPWR _0299_ sky130_fd_sc_hd__clkbuf_1
X_1725_ reg_file.registers\[2\]\[30\] VGND VGND VPWR VPWR _0417_ sky130_fd_sc_hd__clkbuf_1
XFILLER_0_5_446 VGND VGND VPWR VPWR sky130_fd_sc_hd__fill_2
Xclkbuf_leaf_7_clk clknet_1_0__leaf_clk VGND VGND VPWR VPWR clknet_leaf_7_clk sky130_fd_sc_hd__clkbuf_8
X_3326_ _1705_ VGND VGND VPWR VPWR _0116_ sky130_fd_sc_hd__inv_2
XFILLER_0_68_419 VGND VGND VPWR VPWR sky130_fd_sc_hd__fill_1
X_2139_ reg_file.registers\[11\]\[1\] _0691_ _0736_ VGND VGND VPWR VPWR _0737_ sky130_fd_sc_hd__a21oi_1
X_3257_ _1692_ VGND VGND VPWR VPWR _1696_ sky130_fd_sc_hd__buf_4
X_2208_ reg_file.registers\[11\]\[13\] _0725_ _0726_ reg_file.registers\[10\]\[13\]
+ VGND VGND VPWR VPWR _0806_ sky130_fd_sc_hd__a22o_1
X_3188_ _1670_ _1671_ VGND VGND VPWR VPWR _0023_ sky130_fd_sc_hd__nor2_1
XFILLER_0_36_305 VGND VGND VPWR VPWR sky130_fd_sc_hd__decap_3
XFILLER_0_29_390 VGND VGND VPWR VPWR sky130_fd_sc_hd__fill_2
XFILLER_0_8_251 VGND VGND VPWR VPWR sky130_fd_sc_hd__fill_1
XFILLER_0_67_441 VGND VGND VPWR VPWR sky130_fd_sc_hd__decap_6
XTAP_TAPCELL_ROW_55_594 VGND VPWR sky130_fd_sc_hd__tapvpwrvgnd_1
XTAP_TAPCELL_ROW_47_528 VGND VPWR sky130_fd_sc_hd__tapvpwrvgnd_1
XFILLER_0_24_27 VGND VGND VPWR VPWR sky130_fd_sc_hd__fill_1
XFILLER_0_54_135 VGND VGND VPWR VPWR sky130_fd_sc_hd__decap_4
XFILLER_0_40_15 VPWR VGND VPWR VGND sky130_ef_sc_hd__decap_12
XFILLER_0_35_371 VGND VGND VPWR VPWR sky130_fd_sc_hd__fill_1
X_2490_ _1068_ _1086_ VGND VGND VPWR VPWR _1087_ sky130_fd_sc_hd__and2b_1
XFILLER_0_50_363 VGND VGND VPWR VPWR sky130_fd_sc_hd__fill_1
XFILLER_0_49_57 VGND VGND VPWR VPWR sky130_fd_sc_hd__fill_1
XFILLER_0_49_46 VGND VGND VPWR VPWR sky130_fd_sc_hd__fill_1
XFILLER_0_4_15 VPWR VGND VPWR VGND sky130_ef_sc_hd__decap_12
X_3042_ imem.address\[7\] _1520_ imem.address\[8\] VGND VGND VPWR VPWR _1553_ sky130_fd_sc_hd__a21oi_1
X_3111_ _0409_ _1454_ VGND VGND VPWR VPWR _1610_ sky130_fd_sc_hd__and2b_1
XTAP_TAPCELL_ROW_18_296 VGND VPWR sky130_fd_sc_hd__tapvpwrvgnd_1
XFILLER_0_53_190 VPWR VGND VPWR VGND sky130_ef_sc_hd__decap_12
X_2826_ reg_file.registers\[11\]\[15\] _1407_ _1376_ VGND VGND VPWR VPWR _1408_ sky130_fd_sc_hd__mux2_1
X_2688_ _1280_ VGND VGND VPWR VPWR _1281_ sky130_fd_sc_hd__inv_2
XFILLER_0_26_382 VGND VGND VPWR VPWR sky130_fd_sc_hd__fill_2
X_2757_ reg_file.registers\[11\]\[22\] _1345_ _1059_ VGND VGND VPWR VPWR _1346_ sky130_fd_sc_hd__mux2_1
X_3309_ _1703_ VGND VGND VPWR VPWR _0101_ sky130_fd_sc_hd__inv_2
XFILLER_0_39_90 VGND VGND VPWR VPWR sky130_fd_sc_hd__fill_2
XFILLER_0_68_227 VGND VGND VPWR VPWR sky130_fd_sc_hd__decap_4
XTAP_TAPCELL_ROW_44_509 VGND VPWR sky130_fd_sc_hd__tapvpwrvgnd_1
XTAP_TAPCELL_ROW_1_164 VGND VPWR sky130_fd_sc_hd__tapvpwrvgnd_1
XFILLER_0_64_433 VPWR VGND VPWR VGND sky130_ef_sc_hd__decap_12
XTAP_TAPCELL_ROW_52_575 VGND VPWR sky130_fd_sc_hd__tapvpwrvgnd_1
XFILLER_0_32_363 VGND VGND VPWR VPWR sky130_fd_sc_hd__fill_1
XTAP_TAPCELL_ROW_9_231 VGND VPWR sky130_fd_sc_hd__tapvpwrvgnd_1
XFILLER_0_10_29 VPWR VGND VPWR VGND sky130_ef_sc_hd__decap_12
XFILLER_0_19_27 VGND VGND VPWR VPWR sky130_fd_sc_hd__decap_8
X_1990_ _0455_ net59 _0469_ _0474_ VGND VGND VPWR VPWR _0588_ sky130_fd_sc_hd__and4b_4
XFILLER_0_59_249 VGND VGND VPWR VPWR sky130_fd_sc_hd__decap_4
XFILLER_0_55_411 VGND VGND VPWR VPWR sky130_fd_sc_hd__fill_1
XFILLER_0_51_36 VGND VGND VPWR VPWR sky130_fd_sc_hd__decap_6
XTAP_TAPCELL_ROW_15_277 VGND VPWR sky130_fd_sc_hd__tapvpwrvgnd_1
Xclkload12 clknet_leaf_10_clk VGND VGND VPWR VPWR clkload12/Y sky130_fd_sc_hd__clkinv_2
X_2611_ _0458_ _0481_ _0457_ VGND VGND VPWR VPWR _1207_ sky130_fd_sc_hd__or3b_4
X_3591_ clknet_leaf_4_clk _0353_ _0164_ VGND VGND VPWR VPWR reg_file.registers\[5\]\[11\]
+ sky130_fd_sc_hd__dfrtp_1
X_2542_ _0575_ _1138_ _0580_ VGND VGND VPWR VPWR _1139_ sky130_fd_sc_hd__a21oi_1
X_3660_ clknet_leaf_17_clk _0012_ VGND VGND VPWR VPWR display.counter\[14\] sky130_fd_sc_hd__dfxtp_1
X_2473_ _0770_ VGND VGND VPWR VPWR _1070_ sky130_fd_sc_hd__buf_2
XFILLER_0_23_385 VGND VGND VPWR VPWR sky130_fd_sc_hd__decap_6
X_3025_ imem.address\[18\] _1527_ VGND VGND VPWR VPWR _1546_ sky130_fd_sc_hd__nor2_1
Xclkload6 clknet_leaf_6_clk VGND VGND VPWR VPWR clkload6/Y sky130_fd_sc_hd__bufinv_16
XFILLER_0_41_80 VPWR VGND VPWR VGND sky130_ef_sc_hd__decap_12
XFILLER_0_33_116 VGND VGND VPWR VPWR sky130_fd_sc_hd__fill_1
XFILLER_0_41_193 VPWR VGND VPWR VGND sky130_ef_sc_hd__decap_12
X_2809_ _1392_ VGND VGND VPWR VPWR _0295_ sky130_fd_sc_hd__clkbuf_1
XTAP_TAPCELL_ROW_6_201 VGND VPWR sky130_fd_sc_hd__tapvpwrvgnd_1
XFILLER_0_14_330 VGND VGND VPWR VPWR sky130_fd_sc_hd__decap_4
XTAP_TAPCELL_ROW_57_612 VGND VPWR sky130_fd_sc_hd__tapvpwrvgnd_1
XFILLER_0_24_149 VGND VGND VPWR VPWR sky130_fd_sc_hd__decap_6
XFILLER_0_21_39 VGND VGND VPWR VPWR sky130_fd_sc_hd__decap_8
XFILLER_0_1_27 VPWR VGND VPWR VGND sky130_ef_sc_hd__decap_12
XFILLER_0_70_200 VGND VGND VPWR VPWR sky130_fd_sc_hd__fill_1
XTAP_TAPCELL_ROW_63_659 VGND VPWR sky130_fd_sc_hd__tapvpwrvgnd_1
XFILLER_0_43_414 VGND VGND VPWR VPWR sky130_fd_sc_hd__decap_8
XTAP_TAPCELL_ROW_28_380 VGND VPWR sky130_fd_sc_hd__tapvpwrvgnd_1
XFILLER_0_7_305 VPWR VGND VPWR VGND sky130_ef_sc_hd__decap_12
XFILLER_0_15_127 VGND VGND VPWR VPWR sky130_fd_sc_hd__decap_8
X_1973_ net51 _0570_ VGND VGND VPWR VPWR _0571_ sky130_fd_sc_hd__nor2_1
XFILLER_0_70_277 VPWR VGND VPWR VGND sky130_ef_sc_hd__decap_12
XFILLER_0_70_244 VGND VGND VPWR VPWR sky130_fd_sc_hd__decap_8
X_2525_ _1120_ _1121_ _1069_ VGND VGND VPWR VPWR _1122_ sky130_fd_sc_hd__mux2_1
X_3643_ clknet_leaf_15_clk _0405_ VGND VGND VPWR VPWR display.digit_sel\[0\] sky130_fd_sc_hd__dfxtp_2
X_3574_ clknet_leaf_18_clk _0336_ _0147_ VGND VGND VPWR VPWR reg_file.registers\[10\]\[26\]
+ sky130_fd_sc_hd__dfrtp_2
X_2456_ _1050_ _1053_ _0597_ VGND VGND VPWR VPWR _1054_ sky130_fd_sc_hd__mux2_1
XFILLER_0_39_3 VPWR VGND VPWR VGND sky130_ef_sc_hd__decap_12
X_2387_ _0984_ VGND VGND VPWR VPWR _0985_ sky130_fd_sc_hd__inv_2
XFILLER_0_11_388 VGND VGND VPWR VPWR sky130_fd_sc_hd__decap_4
X_3008_ _1535_ _1539_ VGND VGND VPWR VPWR _0243_ sky130_fd_sc_hd__nor2_1
XFILLER_0_19_411 VGND VGND VPWR VPWR sky130_fd_sc_hd__fill_1
XFILLER_0_61_244 VGND VGND VPWR VPWR sky130_fd_sc_hd__fill_1
XFILLER_0_34_447 VGND VGND VPWR VPWR sky130_fd_sc_hd__decap_4
XFILLER_0_14_193 VGND VGND VPWR VPWR sky130_fd_sc_hd__decap_3
XFILLER_0_52_277 VGND VGND VPWR VPWR sky130_fd_sc_hd__fill_1
XFILLER_0_12_119 VGND VGND VPWR VPWR sky130_fd_sc_hd__fill_1
XFILLER_0_20_141 VGND VGND VPWR VPWR sky130_fd_sc_hd__decap_3
XFILLER_0_57_57 VGND VGND VPWR VPWR sky130_fd_sc_hd__fill_2
X_2172_ _0578_ _0715_ VGND VGND VPWR VPWR _0770_ sky130_fd_sc_hd__or2_2
X_2241_ _0824_ _0825_ VGND VGND VPWR VPWR _0839_ sky130_fd_sc_hd__nor2_1
X_2310_ _0906_ _0907_ VGND VGND VPWR VPWR _0908_ sky130_fd_sc_hd__nor2_1
XPHY_EDGE_ROW_29_Left_101 VGND VGND VPWR VPWR sky130_fd_sc_hd__decap_3
X_3290_ _1692_ VGND VGND VPWR VPWR _1699_ sky130_fd_sc_hd__buf_1
XFILLER_0_20_163 VPWR VGND VPWR VGND sky130_ef_sc_hd__decap_12
XPHY_EDGE_ROW_38_Left_110 VGND VGND VPWR VPWR sky130_fd_sc_hd__decap_3
X_1956_ _0473_ _0469_ _0468_ VGND VGND VPWR VPWR _0554_ sky130_fd_sc_hd__and3b_2
X_1887_ _0517_ VGND VGND VPWR VPWR _0342_ sky130_fd_sc_hd__clkbuf_1
XFILLER_0_7_113 VPWR VGND VPWR VGND sky130_ef_sc_hd__decap_12
XFILLER_0_16_447 VGND VGND VPWR VPWR sky130_fd_sc_hd__fill_1
X_3557_ clknet_leaf_10_clk _0319_ _0130_ VGND VGND VPWR VPWR reg_file.registers\[10\]\[9\]
+ sky130_fd_sc_hd__dfrtp_1
X_3488_ clknet_leaf_3_clk _0250_ _0061_ VGND VGND VPWR VPWR reg_file.registers\[15\]\[4\]
+ sky130_fd_sc_hd__dfrtp_1
X_2508_ _1101_ _1104_ _1017_ VGND VGND VPWR VPWR _1105_ sky130_fd_sc_hd__mux2_1
X_3626_ clknet_leaf_4_clk _0388_ _0199_ VGND VGND VPWR VPWR reg_file.registers\[2\]\[15\]
+ sky130_fd_sc_hd__dfrtp_1
XFILLER_0_3_385 VGND VGND VPWR VPWR sky130_fd_sc_hd__decap_6
X_2439_ _0853_ _0788_ _0995_ VGND VGND VPWR VPWR _1037_ sky130_fd_sc_hd__mux2_1
XTAP_TAPCELL_ROW_39_464 VGND VPWR sky130_fd_sc_hd__tapvpwrvgnd_1
XTAP_TAPCELL_ROW_22_331 VGND VPWR sky130_fd_sc_hd__tapvpwrvgnd_1
XFILLER_0_34_288 VGND VGND VPWR VPWR sky130_fd_sc_hd__fill_2
XFILLER_0_69_163 VGND VGND VPWR VPWR sky130_fd_sc_hd__decap_4
X_1810_ imem.address\[5\] imem.address\[4\] _0458_ _0457_ VGND VGND VPWR VPWR _0472_
+ sky130_fd_sc_hd__or4b_1
X_2790_ _1058_ VGND VGND VPWR VPWR _1376_ sky130_fd_sc_hd__clkbuf_4
XFILLER_0_25_222 VGND VGND VPWR VPWR sky130_fd_sc_hd__fill_2
X_1741_ reg_file.registers\[2\]\[22\] VGND VGND VPWR VPWR _0425_ sky130_fd_sc_hd__clkbuf_1
X_3411_ _1717_ VGND VGND VPWR VPWR _0189_ sky130_fd_sc_hd__inv_2
XFILLER_0_40_214 VGND VGND VPWR VPWR sky130_fd_sc_hd__decap_6
X_3342_ _1704_ VGND VGND VPWR VPWR _1707_ sky130_fd_sc_hd__buf_4
XFILLER_0_7_15 VPWR VGND VPWR VGND sky130_ef_sc_hd__decap_12
XFILLER_0_0_377 VPWR VGND VPWR VGND sky130_ef_sc_hd__decap_12
XFILLER_0_0_333 VGND VGND VPWR VPWR sky130_fd_sc_hd__decap_3
X_2155_ net35 _0752_ VGND VGND VPWR VPWR _0753_ sky130_fd_sc_hd__xnor2_1
X_2224_ _0816_ _0821_ VGND VGND VPWR VPWR _0822_ sky130_fd_sc_hd__nand2_1
X_3273_ _1697_ VGND VGND VPWR VPWR _0071_ sky130_fd_sc_hd__inv_2
XTAP_TAPCELL_ROW_36_445 VGND VPWR sky130_fd_sc_hd__tapvpwrvgnd_1
XFILLER_0_8_433 VGND VGND VPWR VPWR sky130_fd_sc_hd__decap_3
XFILLER_0_8_444 VGND VGND VPWR VPWR sky130_fd_sc_hd__decap_6
X_2086_ reg_file.registers\[5\]\[29\] _0680_ _0568_ reg_file.registers\[15\]\[29\]
+ VGND VGND VPWR VPWR _0684_ sky130_fd_sc_hd__a22o_1
XFILLER_0_71_361 VGND VGND VPWR VPWR sky130_fd_sc_hd__decap_3
X_1939_ _0545_ VGND VGND VPWR VPWR _0318_ sky130_fd_sc_hd__clkbuf_1
X_2988_ imem.address\[9\] _1521_ VGND VGND VPWR VPWR _1522_ sky130_fd_sc_hd__and2_1
XFILLER_0_31_258 VGND VGND VPWR VPWR sky130_fd_sc_hd__decap_3
XFILLER_0_16_288 VPWR VGND VPWR VGND sky130_ef_sc_hd__decap_12
X_3609_ clknet_leaf_20_clk _0371_ _0182_ VGND VGND VPWR VPWR reg_file.registers\[5\]\[29\]
+ sky130_fd_sc_hd__dfrtp_1
XFILLER_0_3_193 VPWR VGND VPWR VGND sky130_ef_sc_hd__decap_12
XTAP_TAPCELL_ROW_70_713 VGND VPWR sky130_fd_sc_hd__tapvpwrvgnd_1
XFILLER_0_66_133 VGND VGND VPWR VPWR sky130_fd_sc_hd__fill_2
XFILLER_0_47_391 VGND VGND VPWR VPWR sky130_fd_sc_hd__fill_1
XFILLER_0_39_358 VGND VGND VPWR VPWR sky130_fd_sc_hd__fill_1
XPHY_EDGE_ROW_11_Right_11 VGND VGND VPWR VPWR sky130_fd_sc_hd__decap_3
XFILLER_0_22_203 VGND VGND VPWR VPWR sky130_fd_sc_hd__fill_1
XPHY_EDGE_ROW_20_Right_20 VGND VGND VPWR VPWR sky130_fd_sc_hd__decap_3
X_2911_ _0996_ _0734_ VGND VGND VPWR VPWR _1478_ sky130_fd_sc_hd__and2_1
XFILLER_0_53_372 VPWR VGND VPWR VGND sky130_ef_sc_hd__decap_12
X_2842_ _0991_ _1358_ VGND VGND VPWR VPWR _1422_ sky130_fd_sc_hd__and2_1
XTAP_TAPCELL_ROW_41_481 VGND VPWR sky130_fd_sc_hd__tapvpwrvgnd_1
X_2773_ reg_file.registers\[11\]\[21\] _1360_ _1059_ VGND VGND VPWR VPWR _1361_ sky130_fd_sc_hd__mux2_1
X_1724_ _0416_ VGND VGND VPWR VPWR _0404_ sky130_fd_sc_hd__clkbuf_1
XFILLER_0_13_225 VPWR VGND VPWR VGND sky130_ef_sc_hd__decap_12
X_3256_ _1695_ VGND VGND VPWR VPWR _0056_ sky130_fd_sc_hd__inv_2
XFILLER_0_0_141 VPWR VGND VPWR VGND sky130_ef_sc_hd__decap_12
XFILLER_0_21_291 VGND VGND VPWR VPWR sky130_fd_sc_hd__fill_2
X_3325_ _1705_ VGND VGND VPWR VPWR _0115_ sky130_fd_sc_hd__inv_2
X_2138_ reg_file.registers\[10\]\[1\] net18 _0732_ VGND VGND VPWR VPWR _0736_ sky130_fd_sc_hd__and3_1
X_2207_ _0800_ _0635_ _0622_ _0640_ VGND VGND VPWR VPWR _0805_ sky130_fd_sc_hd__o31a_1
X_2069_ _0574_ _0666_ _0579_ VGND VGND VPWR VPWR _0667_ sky130_fd_sc_hd__a21o_1
X_3187_ display.counter\[6\] _1668_ VGND VGND VPWR VPWR _1671_ sky130_fd_sc_hd__nor2_1
XFILLER_0_21_3 VPWR VGND VPWR VGND sky130_ef_sc_hd__decap_12
XFILLER_0_48_155 VGND VGND VPWR VPWR sky130_fd_sc_hd__decap_8
XFILLER_0_48_144 VGND VGND VPWR VPWR sky130_fd_sc_hd__fill_2
XFILLER_0_44_361 VGND VGND VPWR VPWR sky130_fd_sc_hd__decap_3
XTAP_TAPCELL_ROW_47_529 VGND VPWR sky130_fd_sc_hd__tapvpwrvgnd_1
XTAP_TAPCELL_ROW_4_184 VGND VPWR sky130_fd_sc_hd__tapvpwrvgnd_1
XTAP_TAPCELL_ROW_55_595 VGND VPWR sky130_fd_sc_hd__tapvpwrvgnd_1
XFILLER_0_40_38 VGND VGND VPWR VPWR sky130_fd_sc_hd__decap_6
XFILLER_0_40_27 VGND VGND VPWR VPWR sky130_fd_sc_hd__fill_1
X_3110_ _1472_ _0408_ VGND VGND VPWR VPWR _1609_ sky130_fd_sc_hd__or2_1
XFILLER_0_4_27 VGND VGND VPWR VPWR sky130_fd_sc_hd__fill_1
X_3041_ _1522_ _1552_ VGND VGND VPWR VPWR _0223_ sky130_fd_sc_hd__nor2_1
XFILLER_0_65_57 VPWR VGND VPWR VGND sky130_ef_sc_hd__decap_12
XFILLER_0_45_125 VGND VGND VPWR VPWR sky130_fd_sc_hd__decap_6
X_2825_ _1065_ _1405_ _1406_ _1332_ _1055_ VGND VGND VPWR VPWR _1407_ sky130_fd_sc_hd__a32o_1
XFILLER_0_14_83 VGND VGND VPWR VPWR sky130_fd_sc_hd__fill_1
XTAP_TAPCELL_ROW_18_297 VGND VPWR sky130_fd_sc_hd__tapvpwrvgnd_1
XFILLER_0_69_3 VPWR VGND VPWR VGND sky130_ef_sc_hd__decap_12
XFILLER_0_60_128 VGND VGND VPWR VPWR sky130_fd_sc_hd__fill_2
XFILLER_0_60_117 VGND VGND VPWR VPWR sky130_fd_sc_hd__fill_1
X_2687_ _0995_ _0907_ _1279_ VGND VGND VPWR VPWR _1280_ sky130_fd_sc_hd__a21o_1
X_2756_ _1337_ _1338_ _1344_ VGND VGND VPWR VPWR _1345_ sky130_fd_sc_hd__a21o_1
X_3239_ _1694_ VGND VGND VPWR VPWR _0040_ sky130_fd_sc_hd__inv_2
X_3308_ _1700_ VGND VGND VPWR VPWR _1703_ sky130_fd_sc_hd__buf_4
XTAP_TAPCELL_ROW_1_165 VGND VPWR sky130_fd_sc_hd__tapvpwrvgnd_1
XFILLER_0_64_445 VGND VGND VPWR VPWR sky130_fd_sc_hd__decap_6
XFILLER_0_36_169 VGND VGND VPWR VPWR sky130_fd_sc_hd__decap_3
XFILLER_0_24_309 VGND VGND VPWR VPWR sky130_fd_sc_hd__decap_8
XFILLER_0_32_397 VGND VGND VPWR VPWR sky130_fd_sc_hd__decap_8
XFILLER_0_51_15 VGND VGND VPWR VPWR sky130_fd_sc_hd__fill_1
XFILLER_0_27_169 VGND VGND VPWR VPWR sky130_fd_sc_hd__decap_8
XFILLER_0_27_125 VGND VGND VPWR VPWR sky130_fd_sc_hd__fill_1
XTAP_TAPCELL_ROW_15_278 VGND VPWR sky130_fd_sc_hd__tapvpwrvgnd_1
Xclkload13 clknet_leaf_11_clk VGND VGND VPWR VPWR clkload13/Y sky130_fd_sc_hd__clkinvlp_4
X_2472_ _1068_ VGND VGND VPWR VPWR _1069_ sky130_fd_sc_hd__clkbuf_4
X_2541_ reg_file.registers\[15\]\[4\] _0599_ _0607_ _1137_ VGND VGND VPWR VPWR _1138_
+ sky130_fd_sc_hd__a211o_1
X_3590_ clknet_leaf_4_clk _0352_ _0163_ VGND VGND VPWR VPWR reg_file.registers\[5\]\[10\]
+ sky130_fd_sc_hd__dfrtp_1
X_2610_ _0608_ _1184_ _1198_ _1200_ _1205_ VGND VGND VPWR VPWR _1206_ sky130_fd_sc_hd__a221o_1
XFILLER_0_23_375 VGND VGND VPWR VPWR sky130_fd_sc_hd__fill_1
X_3024_ imem.address\[19\] _1528_ VGND VGND VPWR VPWR _0233_ sky130_fd_sc_hd__xor2_1
Xclkload7 clknet_leaf_7_clk VGND VGND VPWR VPWR clkload7/Y sky130_fd_sc_hd__bufinv_16
XFILLER_0_41_92 VPWR VGND VPWR VGND sky130_ef_sc_hd__decap_12
X_2808_ _1391_ reg_file.registers\[11\]\[17\] _1207_ VGND VGND VPWR VPWR _1392_ sky130_fd_sc_hd__mux2_1
X_2739_ _1065_ _1327_ _1328_ VGND VGND VPWR VPWR _1329_ sky130_fd_sc_hd__and3_1
XTAP_TAPCELL_ROW_6_202 VGND VPWR sky130_fd_sc_hd__tapvpwrvgnd_1
XTAP_TAPCELL_ROW_57_613 VGND VPWR sky130_fd_sc_hd__tapvpwrvgnd_1
XFILLER_0_5_81 VPWR VGND VPWR VGND sky130_ef_sc_hd__decap_12
XFILLER_0_64_253 VGND VGND VPWR VPWR sky130_fd_sc_hd__decap_4
XTAP_TAPCELL_ROW_12_248 VGND VPWR sky130_fd_sc_hd__tapvpwrvgnd_1
XFILLER_0_46_15 VGND VGND VPWR VPWR sky130_fd_sc_hd__decap_4
XTAP_TAPCELL_ROW_28_381 VGND VPWR sky130_fd_sc_hd__tapvpwrvgnd_1
XFILLER_0_1_39 VPWR VGND VPWR VGND sky130_ef_sc_hd__decap_12
XFILLER_0_28_434 VGND VGND VPWR VPWR sky130_fd_sc_hd__fill_1
XFILLER_0_28_401 VPWR VGND VPWR VGND sky130_ef_sc_hd__decap_12
X_3642_ clknet_leaf_2_clk _0404_ _0215_ VGND VGND VPWR VPWR reg_file.registers\[2\]\[31\]
+ sky130_fd_sc_hd__dfrtp_1
XFILLER_0_7_317 VPWR VGND VPWR VGND sky130_ef_sc_hd__decap_12
XFILLER_0_11_51 VGND VGND VPWR VPWR sky130_fd_sc_hd__decap_4
X_1972_ reg_file.registers\[2\]\[27\] _0559_ _0569_ VGND VGND VPWR VPWR _0570_ sky130_fd_sc_hd__a21oi_1
XFILLER_0_70_289 VGND VGND VPWR VPWR sky130_fd_sc_hd__decap_4
X_2455_ _1051_ _1052_ _1002_ VGND VGND VPWR VPWR _1053_ sky130_fd_sc_hd__mux2_1
XPHY_EDGE_ROW_49_Right_49 VGND VGND VPWR VPWR sky130_fd_sc_hd__decap_3
X_2524_ reg_file.registers\[11\]\[19\] _1114_ _1115_ reg_file.registers\[10\]\[19\]
+ VGND VGND VPWR VPWR _1121_ sky130_fd_sc_hd__a22o_1
X_3573_ clknet_leaf_18_clk _0335_ _0146_ VGND VGND VPWR VPWR reg_file.registers\[10\]\[25\]
+ sky130_fd_sc_hd__dfrtp_1
XFILLER_0_11_323 VGND VGND VPWR VPWR sky130_fd_sc_hd__fill_2
XPHY_EDGE_ROW_58_Right_58 VGND VGND VPWR VPWR sky130_fd_sc_hd__decap_3
X_2386_ _0968_ _0983_ VGND VGND VPWR VPWR _0984_ sky130_fd_sc_hd__xnor2_1
X_3007_ imem.address\[28\] _1534_ imem.address\[29\] VGND VGND VPWR VPWR _1539_ sky130_fd_sc_hd__a21oi_1
XFILLER_0_46_231 VPWR VGND VPWR VGND sky130_ef_sc_hd__decap_12
XFILLER_0_38_209 VGND VGND VPWR VPWR sky130_fd_sc_hd__decap_4
XPHY_EDGE_ROW_67_Right_67 VGND VGND VPWR VPWR sky130_fd_sc_hd__decap_3
XFILLER_0_46_253 VPWR VGND VPWR VGND sky130_ef_sc_hd__decap_12
XFILLER_0_14_161 VPWR VGND VPWR VGND sky130_ef_sc_hd__decap_12
XFILLER_0_69_334 VGND VGND VPWR VPWR sky130_fd_sc_hd__fill_2
XFILLER_0_16_29 VPWR VGND VPWR VGND sky130_ef_sc_hd__decap_12
XFILLER_0_4_309 VPWR VGND VPWR VGND sky130_ef_sc_hd__decap_12
XFILLER_0_40_407 VGND VGND VPWR VPWR sky130_fd_sc_hd__fill_1
XFILLER_0_12_109 VGND VGND VPWR VPWR sky130_fd_sc_hd__decap_6
X_2171_ _0710_ _0711_ VGND VGND VPWR VPWR _0769_ sky130_fd_sc_hd__or2_1
X_2240_ _0822_ _0828_ _0837_ VGND VGND VPWR VPWR _0838_ sky130_fd_sc_hd__or3_1
XFILLER_0_20_197 VGND VGND VPWR VPWR sky130_fd_sc_hd__decap_8
X_1955_ _0553_ VGND VGND VPWR VPWR _0310_ sky130_fd_sc_hd__clkbuf_1
X_1886_ reg_file.registers\[5\]\[0\] _0482_ VGND VGND VPWR VPWR _0517_ sky130_fd_sc_hd__and2_1
X_3625_ clknet_leaf_0_clk _0387_ _0198_ VGND VGND VPWR VPWR reg_file.registers\[2\]\[14\]
+ sky130_fd_sc_hd__dfrtp_1
XFILLER_0_28_253 VGND VGND VPWR VPWR sky130_fd_sc_hd__decap_3
XFILLER_0_22_83 VGND VGND VPWR VPWR sky130_fd_sc_hd__fill_1
XFILLER_0_7_125 VPWR VGND VPWR VGND sky130_ef_sc_hd__decap_12
XFILLER_0_7_169 VPWR VGND VPWR VGND sky130_ef_sc_hd__decap_12
XFILLER_0_16_426 VGND VGND VPWR VPWR sky130_fd_sc_hd__decap_4
X_3556_ clknet_leaf_10_clk _0318_ _0129_ VGND VGND VPWR VPWR reg_file.registers\[10\]\[8\]
+ sky130_fd_sc_hd__dfrtp_4
X_3487_ clknet_leaf_5_clk _0249_ _0060_ VGND VGND VPWR VPWR reg_file.registers\[15\]\[3\]
+ sky130_fd_sc_hd__dfrtp_1
XFILLER_0_51_3 VPWR VGND VPWR VGND sky130_ef_sc_hd__decap_12
X_2507_ _1102_ _1103_ _1068_ VGND VGND VPWR VPWR _1104_ sky130_fd_sc_hd__mux2_1
X_2438_ _0991_ _1015_ _1035_ VGND VGND VPWR VPWR _1036_ sky130_fd_sc_hd__a21o_1
XTAP_TAPCELL_ROW_39_465 VGND VPWR sky130_fd_sc_hd__tapvpwrvgnd_1
X_2369_ _0457_ _0575_ _0966_ VGND VGND VPWR VPWR _0967_ sky130_fd_sc_hd__o21ai_1
XTAP_TAPCELL_ROW_22_332 VGND VPWR sky130_fd_sc_hd__tapvpwrvgnd_1
XFILLER_0_19_242 VGND VGND VPWR VPWR sky130_fd_sc_hd__fill_1
XFILLER_0_19_297 VGND VGND VPWR VPWR sky130_fd_sc_hd__fill_2
XFILLER_0_57_359 VPWR VGND VPWR VGND sky130_ef_sc_hd__decap_12
XFILLER_0_57_315 VGND VGND VPWR VPWR sky130_fd_sc_hd__fill_2
XFILLER_0_43_16 VGND VGND VPWR VPWR sky130_fd_sc_hd__fill_1
X_1740_ _0424_ VGND VGND VPWR VPWR _0396_ sky130_fd_sc_hd__clkbuf_1
XFILLER_0_25_278 VGND VGND VPWR VPWR sky130_fd_sc_hd__fill_2
XFILLER_0_7_27 VPWR VGND VPWR VGND sky130_ef_sc_hd__decap_12
XFILLER_0_4_139 VGND VGND VPWR VPWR sky130_fd_sc_hd__fill_1
XFILLER_0_13_429 VGND VGND VPWR VPWR sky130_fd_sc_hd__fill_1
X_3341_ _1706_ VGND VGND VPWR VPWR _0130_ sky130_fd_sc_hd__inv_2
X_3410_ _1717_ VGND VGND VPWR VPWR _0188_ sky130_fd_sc_hd__inv_2
X_3272_ _1697_ VGND VGND VPWR VPWR _0070_ sky130_fd_sc_hd__inv_2
XFILLER_0_0_389 VGND VGND VPWR VPWR sky130_fd_sc_hd__decap_3
XFILLER_0_21_440 VGND VGND VPWR VPWR sky130_fd_sc_hd__decap_4
X_2154_ _0572_ _0751_ net21 VGND VGND VPWR VPWR _0752_ sky130_fd_sc_hd__a21oi_4
X_2223_ _0818_ _0820_ VGND VGND VPWR VPWR _0821_ sky130_fd_sc_hd__xnor2_2
X_2085_ _0575_ _0682_ _0580_ VGND VGND VPWR VPWR _0683_ sky130_fd_sc_hd__a21o_1
X_2987_ imem.address\[8\] imem.address\[7\] _1520_ VGND VGND VPWR VPWR _1521_ sky130_fd_sc_hd__and3_1
XTAP_TAPCELL_ROW_36_446 VGND VPWR sky130_fd_sc_hd__tapvpwrvgnd_1
X_1938_ reg_file.registers\[10\]\[8\] _0539_ VGND VGND VPWR VPWR _0545_ sky130_fd_sc_hd__and2_1
X_1869_ _0508_ VGND VGND VPWR VPWR _0351_ sky130_fd_sc_hd__clkbuf_1
XFILLER_0_3_161 VGND VGND VPWR VPWR sky130_fd_sc_hd__decap_6
X_3608_ clknet_leaf_20_clk _0370_ _0181_ VGND VGND VPWR VPWR reg_file.registers\[5\]\[28\]
+ sky130_fd_sc_hd__dfrtp_1
X_3539_ clknet_leaf_19_clk _0301_ _0112_ VGND VGND VPWR VPWR reg_file.registers\[11\]\[23\]
+ sky130_fd_sc_hd__dfrtp_2
XTAP_TAPCELL_ROW_70_714 VGND VPWR sky130_fd_sc_hd__tapvpwrvgnd_1
XPHY_EDGE_ROW_57_Left_129 VGND VGND VPWR VPWR sky130_fd_sc_hd__decap_3
XFILLER_0_22_215 VGND VGND VPWR VPWR sky130_fd_sc_hd__fill_1
XPHY_EDGE_ROW_66_Left_138 VGND VGND VPWR VPWR sky130_fd_sc_hd__decap_3
X_2910_ _1477_ VGND VGND VPWR VPWR _0279_ sky130_fd_sc_hd__clkbuf_1
XFILLER_0_57_123 VGND VGND VPWR VPWR sky130_fd_sc_hd__fill_1
X_2841_ _1417_ _1419_ _1401_ VGND VGND VPWR VPWR _1421_ sky130_fd_sc_hd__or3_1
XTAP_TAPCELL_ROW_33_416 VGND VPWR sky130_fd_sc_hd__tapvpwrvgnd_1
XFILLER_0_53_384 VGND VGND VPWR VPWR sky130_fd_sc_hd__decap_4
XTAP_TAPCELL_ROW_41_482 VGND VPWR sky130_fd_sc_hd__tapvpwrvgnd_1
X_2772_ _1348_ _1347_ _1064_ _1355_ _1359_ VGND VGND VPWR VPWR _1360_ sky130_fd_sc_hd__a311o_1
X_1723_ reg_file.registers\[2\]\[31\] VGND VGND VPWR VPWR _0416_ sky130_fd_sc_hd__clkbuf_1
XFILLER_0_13_237 VGND VGND VPWR VPWR sky130_fd_sc_hd__decap_6
X_3255_ _1695_ VGND VGND VPWR VPWR _0055_ sky130_fd_sc_hd__inv_2
X_2206_ _0801_ _0803_ VGND VGND VPWR VPWR _0804_ sky130_fd_sc_hd__xnor2_1
XFILLER_0_0_153 VPWR VGND VPWR VGND sky130_ef_sc_hd__decap_12
XFILLER_0_0_197 VPWR VGND VPWR VGND sky130_ef_sc_hd__decap_12
X_3324_ _1705_ VGND VGND VPWR VPWR _0114_ sky130_fd_sc_hd__inv_2
X_2137_ _0731_ _0734_ VGND VGND VPWR VPWR _0735_ sky130_fd_sc_hd__nor2_1
XFILLER_0_44_70 VGND VGND VPWR VPWR sky130_fd_sc_hd__decap_8
X_2068_ reg_file.registers\[5\]\[20\] _0563_ _0567_ reg_file.registers\[15\]\[20\]
+ _0665_ VGND VGND VPWR VPWR _0666_ sky130_fd_sc_hd__a221o_1
X_3186_ display.counter\[6\] _1668_ VGND VGND VPWR VPWR _1670_ sky130_fd_sc_hd__and2_1
XFILLER_0_14_3 VPWR VGND VPWR VGND sky130_ef_sc_hd__decap_12
XFILLER_0_60_80 VGND VGND VPWR VPWR sky130_fd_sc_hd__decap_4
XFILLER_0_29_370 VGND VGND VPWR VPWR sky130_fd_sc_hd__decap_4
XFILLER_0_8_253 VPWR VGND VPWR VGND sky130_ef_sc_hd__decap_12
XFILLER_0_8_297 VGND VGND VPWR VPWR sky130_fd_sc_hd__fill_1
XFILLER_0_71_181 VPWR VGND VPWR VGND sky130_ef_sc_hd__decap_12
XTAP_TAPCELL_ROW_4_185 VGND VPWR sky130_fd_sc_hd__tapvpwrvgnd_1
XTAP_TAPCELL_ROW_55_596 VGND VPWR sky130_fd_sc_hd__tapvpwrvgnd_1
XFILLER_0_50_365 VPWR VGND VPWR VGND sky130_ef_sc_hd__decap_12
X_3040_ imem.address\[9\] _1521_ VGND VGND VPWR VPWR _1552_ sky130_fd_sc_hd__nor2_1
XFILLER_0_65_69 VPWR VGND VPWR VGND sky130_ef_sc_hd__decap_12
XFILLER_0_45_159 VGND VGND VPWR VPWR sky130_fd_sc_hd__fill_1
X_2824_ _0854_ _1404_ _0789_ _0793_ VGND VGND VPWR VPWR _1406_ sky130_fd_sc_hd__o211ai_1
XFILLER_0_26_362 VGND VGND VPWR VPWR sky130_fd_sc_hd__fill_2
XFILLER_0_5_223 VGND VGND VPWR VPWR sky130_fd_sc_hd__fill_1
XFILLER_0_14_73 VGND VGND VPWR VPWR sky130_fd_sc_hd__decap_3
XTAP_TAPCELL_ROW_18_298 VGND VPWR sky130_fd_sc_hd__tapvpwrvgnd_1
XFILLER_0_41_310 VPWR VGND VPWR VGND sky130_ef_sc_hd__decap_12
X_2686_ _0994_ _0788_ VGND VGND VPWR VPWR _1279_ sky130_fd_sc_hd__nor2_1
XFILLER_0_30_61 VGND VGND VPWR VPWR sky130_fd_sc_hd__decap_3
X_2755_ _1108_ _1140_ _1127_ _1343_ VGND VGND VPWR VPWR _1344_ sky130_fd_sc_hd__a31o_1
X_3238_ _1694_ VGND VGND VPWR VPWR _0039_ sky130_fd_sc_hd__inv_2
X_3307_ _1702_ VGND VGND VPWR VPWR _0100_ sky130_fd_sc_hd__inv_2
X_3169_ _1653_ VGND VGND VPWR VPWR _1661_ sky130_fd_sc_hd__inv_2
XTAP_TAPCELL_ROW_1_166 VGND VPWR sky130_fd_sc_hd__tapvpwrvgnd_1
XFILLER_0_51_107 VGND VGND VPWR VPWR sky130_fd_sc_hd__fill_2
XFILLER_0_32_321 VPWR VGND VPWR VGND sky130_ef_sc_hd__decap_12
XFILLER_0_3_3 VPWR VGND VPWR VGND sky130_ef_sc_hd__decap_12
XTAP_TAPCELL_ROW_43_500 VGND VPWR sky130_fd_sc_hd__tapvpwrvgnd_1
XFILLER_0_67_251 VPWR VGND VPWR VGND sky130_ef_sc_hd__decap_12
XFILLER_0_27_104 VGND VGND VPWR VPWR sky130_fd_sc_hd__fill_2
XTAP_TAPCELL_ROW_15_279 VGND VPWR sky130_fd_sc_hd__tapvpwrvgnd_1
X_2471_ _0717_ VGND VGND VPWR VPWR _1068_ sky130_fd_sc_hd__clkbuf_4
XFILLER_0_50_195 VGND VGND VPWR VPWR sky130_fd_sc_hd__fill_1
Xclkload14 clknet_leaf_12_clk VGND VGND VPWR VPWR clkload14/Y sky130_fd_sc_hd__clkinv_4
XFILLER_0_35_181 VGND VGND VPWR VPWR sky130_fd_sc_hd__fill_1
X_2540_ reg_file.registers\[5\]\[4\] _0715_ VGND VGND VPWR VPWR _1137_ sky130_fd_sc_hd__and2_2
XFILLER_0_23_310 VGND VGND VPWR VPWR sky130_fd_sc_hd__fill_1
X_3023_ _1529_ _1545_ VGND VGND VPWR VPWR _0234_ sky130_fd_sc_hd__nor2_1
XFILLER_0_58_251 VGND VGND VPWR VPWR sky130_fd_sc_hd__fill_1
Xclkload8 clknet_leaf_8_clk VGND VGND VPWR VPWR clkload8/Y sky130_fd_sc_hd__inv_8
XFILLER_0_61_449 VGND VGND VPWR VPWR sky130_fd_sc_hd__fill_2
XFILLER_0_61_405 VGND VGND VPWR VPWR sky130_fd_sc_hd__decap_6
XFILLER_0_41_140 VGND VGND VPWR VPWR sky130_fd_sc_hd__fill_1
X_2807_ _1063_ _1386_ _1387_ _1388_ _1390_ VGND VGND VPWR VPWR _1391_ sky130_fd_sc_hd__a311o_1
X_2738_ _1320_ _1326_ _0867_ VGND VGND VPWR VPWR _1328_ sky130_fd_sc_hd__o21ai_1
X_2669_ _0747_ VGND VGND VPWR VPWR _1262_ sky130_fd_sc_hd__inv_2
XFILLER_0_1_281 VPWR VGND VPWR VGND sky130_ef_sc_hd__decap_12
XTAP_TAPCELL_ROW_6_203 VGND VPWR sky130_fd_sc_hd__tapvpwrvgnd_1
XTAP_TAPCELL_ROW_57_614 VGND VPWR sky130_fd_sc_hd__tapvpwrvgnd_1
XFILLER_0_5_93 VPWR VGND VPWR VGND sky130_ef_sc_hd__decap_12
XFILLER_0_64_276 VPWR VGND VPWR VGND sky130_ef_sc_hd__decap_12
XFILLER_0_49_295 VGND VGND VPWR VPWR sky130_fd_sc_hd__decap_8
XFILLER_0_24_107 VGND VGND VPWR VPWR sky130_fd_sc_hd__decap_8
XTAP_TAPCELL_ROW_12_249 VGND VPWR sky130_fd_sc_hd__tapvpwrvgnd_1
XFILLER_0_32_195 VGND VGND VPWR VPWR sky130_fd_sc_hd__fill_1
XFILLER_0_28_413 VGND VGND VPWR VPWR sky130_fd_sc_hd__fill_2
XTAP_TAPCELL_ROW_28_382 VGND VPWR sky130_fd_sc_hd__tapvpwrvgnd_1
XFILLER_0_43_449 VGND VGND VPWR VPWR sky130_fd_sc_hd__fill_2
X_3641_ clknet_leaf_1_clk _0403_ _0214_ VGND VGND VPWR VPWR reg_file.registers\[2\]\[30\]
+ sky130_fd_sc_hd__dfrtp_1
XFILLER_0_7_329 VGND VGND VPWR VPWR sky130_fd_sc_hd__decap_6
X_3572_ clknet_leaf_18_clk _0334_ _0145_ VGND VGND VPWR VPWR reg_file.registers\[10\]\[24\]
+ sky130_fd_sc_hd__dfrtp_1
X_1971_ reg_file.registers\[5\]\[27\] _0564_ _0568_ reg_file.registers\[15\]\[27\]
+ VGND VGND VPWR VPWR _0569_ sky130_fd_sc_hd__a22o_1
X_2454_ _0994_ _0737_ _0735_ VGND VGND VPWR VPWR _1052_ sky130_fd_sc_hd__a21oi_1
X_2523_ reg_file.registers\[11\]\[20\] _1114_ _1115_ reg_file.registers\[10\]\[20\]
+ VGND VGND VPWR VPWR _1120_ sky130_fd_sc_hd__a22o_1
X_2385_ _0979_ _0982_ VGND VGND VPWR VPWR _0983_ sky130_fd_sc_hd__xnor2_1
Xinput1 control VGND VGND VPWR VPWR net1 sky130_fd_sc_hd__buf_1
X_3006_ _1538_ VGND VGND VPWR VPWR _0244_ sky130_fd_sc_hd__clkbuf_1
XTAP_TAPCELL_ROW_62_650 VGND VPWR sky130_fd_sc_hd__tapvpwrvgnd_1
XFILLER_0_46_265 VGND VGND VPWR VPWR sky130_fd_sc_hd__decap_6
XFILLER_0_46_243 VGND VGND VPWR VPWR sky130_fd_sc_hd__decap_8
XFILLER_0_61_279 VGND VGND VPWR VPWR sky130_fd_sc_hd__fill_1
XFILLER_0_61_257 VGND VGND VPWR VPWR sky130_fd_sc_hd__decap_3
XFILLER_0_6_362 VGND VGND VPWR VPWR sky130_fd_sc_hd__fill_2
XFILLER_0_6_395 VGND VGND VPWR VPWR sky130_fd_sc_hd__fill_1
XFILLER_0_14_173 VPWR VGND VPWR VGND sky130_ef_sc_hd__decap_12
XFILLER_0_32_29 VGND VGND VPWR VPWR sky130_fd_sc_hd__decap_3
XFILLER_0_25_449 VGND VGND VPWR VPWR sky130_fd_sc_hd__fill_2
XTAP_TAPCELL_ROW_25_352 VGND VPWR sky130_fd_sc_hd__tapvpwrvgnd_1
XFILLER_0_60_290 VGND VGND VPWR VPWR sky130_fd_sc_hd__decap_6
XFILLER_0_57_15 VPWR VGND VPWR VGND sky130_ef_sc_hd__decap_12
XPHY_EDGE_ROW_27_Left_99 VGND VGND VPWR VPWR sky130_fd_sc_hd__decap_3
X_2170_ _0749_ _0758_ _0765_ _0767_ VGND VGND VPWR VPWR _0768_ sky130_fd_sc_hd__o31a_1
X_1954_ reg_file.registers\[10\]\[0\] _0518_ VGND VGND VPWR VPWR _0553_ sky130_fd_sc_hd__and2_1
XFILLER_0_7_137 VPWR VGND VPWR VGND sky130_ef_sc_hd__decap_12
X_3555_ clknet_leaf_10_clk _0317_ _0128_ VGND VGND VPWR VPWR reg_file.registers\[10\]\[7\]
+ sky130_fd_sc_hd__dfrtp_1
X_1885_ _0516_ VGND VGND VPWR VPWR _0343_ sky130_fd_sc_hd__clkbuf_1
XFILLER_0_43_279 VGND VGND VPWR VPWR sky130_fd_sc_hd__fill_1
X_3624_ clknet_leaf_4_clk _0386_ _0197_ VGND VGND VPWR VPWR reg_file.registers\[2\]\[13\]
+ sky130_fd_sc_hd__dfrtp_1
XFILLER_0_31_419 VGND VGND VPWR VPWR sky130_fd_sc_hd__fill_1
X_3486_ clknet_leaf_7_clk _0248_ _0059_ VGND VGND VPWR VPWR reg_file.registers\[15\]\[2\]
+ sky130_fd_sc_hd__dfrtp_1
X_2506_ reg_file.registers\[11\]\[13\] _1070_ _1073_ reg_file.registers\[10\]\[13\]
+ VGND VGND VPWR VPWR _1103_ sky130_fd_sc_hd__a22oi_1
XFILLER_0_44_3 VGND VGND VPWR VPWR sky130_fd_sc_hd__decap_4
X_2368_ reg_file.registers\[15\]\[30\] _0599_ net50 _0965_ VGND VGND VPWR VPWR _0966_
+ sky130_fd_sc_hd__a211o_1
X_2437_ _1016_ _1024_ _1034_ VGND VGND VPWR VPWR _1035_ sky130_fd_sc_hd__a21o_1
XTAP_TAPCELL_ROW_39_466 VGND VPWR sky130_fd_sc_hd__tapvpwrvgnd_1
X_2299_ reg_file.registers\[15\]\[16\] _0588_ _0590_ reg_file.registers\[5\]\[16\]
+ _0651_ VGND VGND VPWR VPWR _0897_ sky130_fd_sc_hd__a221o_1
XFILLER_0_2_83 VGND VGND VPWR VPWR sky130_fd_sc_hd__fill_1
XFILLER_0_66_338 VGND VGND VPWR VPWR sky130_fd_sc_hd__decap_3
XTAP_TAPCELL_ROW_22_333 VGND VPWR sky130_fd_sc_hd__tapvpwrvgnd_1
XFILLER_0_42_290 VPWR VGND VPWR VGND sky130_ef_sc_hd__decap_12
XFILLER_0_69_121 VGND VGND VPWR VPWR sky130_fd_sc_hd__fill_1
XFILLER_0_57_349 VGND VGND VPWR VPWR sky130_fd_sc_hd__fill_1
XFILLER_0_65_393 VPWR VGND VPWR VGND sky130_ef_sc_hd__decap_12
XFILLER_0_65_382 VGND VGND VPWR VPWR sky130_fd_sc_hd__decap_8
XFILLER_0_40_205 VGND VGND VPWR VPWR sky130_fd_sc_hd__fill_2
XFILLER_0_7_39 VPWR VGND VPWR VGND sky130_ef_sc_hd__decap_12
X_3340_ _1706_ VGND VGND VPWR VPWR _0129_ sky130_fd_sc_hd__inv_2
X_2222_ _0819_ VGND VGND VPWR VPWR _0820_ sky130_fd_sc_hd__inv_2
X_3271_ _1697_ VGND VGND VPWR VPWR _0069_ sky130_fd_sc_hd__inv_2
X_2153_ reg_file.registers\[15\]\[4\] _0566_ _0607_ _0750_ VGND VGND VPWR VPWR _0751_
+ sky130_fd_sc_hd__a211o_1
XTAP_TAPCELL_ROW_36_447 VGND VPWR sky130_fd_sc_hd__tapvpwrvgnd_1
X_2084_ reg_file.registers\[5\]\[28\] _0680_ _0568_ reg_file.registers\[15\]\[28\]
+ _0681_ VGND VGND VPWR VPWR _0682_ sky130_fd_sc_hd__a221o_1
X_1937_ _0544_ VGND VGND VPWR VPWR _0319_ sky130_fd_sc_hd__clkbuf_1
X_2986_ imem.address\[6\] _1519_ VGND VGND VPWR VPWR _1520_ sky130_fd_sc_hd__and2_1
XFILLER_0_63_308 VGND VGND VPWR VPWR sky130_fd_sc_hd__fill_1
XFILLER_0_56_382 VGND VGND VPWR VPWR sky130_fd_sc_hd__decap_4
XFILLER_0_56_360 VGND VGND VPWR VPWR sky130_fd_sc_hd__decap_4
XFILLER_0_16_224 VPWR VGND VPWR VGND sky130_ef_sc_hd__decap_12
XFILLER_0_16_257 VGND VGND VPWR VPWR sky130_fd_sc_hd__fill_1
X_1799_ _0448_ _0451_ _0460_ _0454_ VGND VGND VPWR VPWR _0461_ sky130_fd_sc_hd__nor4_4
X_1868_ reg_file.registers\[5\]\[9\] _0504_ VGND VGND VPWR VPWR _0508_ sky130_fd_sc_hd__and2_1
X_3607_ clknet_leaf_21_clk _0369_ _0180_ VGND VGND VPWR VPWR reg_file.registers\[5\]\[27\]
+ sky130_fd_sc_hd__dfrtp_1
X_3538_ clknet_leaf_16_clk _0300_ _0111_ VGND VGND VPWR VPWR reg_file.registers\[11\]\[22\]
+ sky130_fd_sc_hd__dfrtp_2
X_3469_ clknet_leaf_6_clk _0238_ _0049_ VGND VGND VPWR VPWR imem.address\[24\] sky130_fd_sc_hd__dfrtp_1
XFILLER_0_58_80 VGND VGND VPWR VPWR sky130_fd_sc_hd__decap_4
XTAP_TAPCELL_ROW_70_715 VGND VPWR sky130_fd_sc_hd__tapvpwrvgnd_1
XFILLER_0_39_305 VGND VGND VPWR VPWR sky130_fd_sc_hd__decap_6
XFILLER_0_62_363 VGND VGND VPWR VPWR sky130_fd_sc_hd__fill_1
XFILLER_0_47_393 VPWR VGND VPWR VGND sky130_ef_sc_hd__decap_12
XFILLER_0_22_249 VGND VGND VPWR VPWR sky130_fd_sc_hd__decap_3
XFILLER_0_22_227 VPWR VGND VPWR VGND sky130_ef_sc_hd__decap_12
XFILLER_0_54_27 VGND VGND VPWR VPWR sky130_fd_sc_hd__fill_1
XFILLER_0_54_16 VGND VGND VPWR VPWR sky130_fd_sc_hd__fill_2
XFILLER_0_70_15 VPWR VGND VPWR VGND sky130_ef_sc_hd__decap_12
XFILLER_0_57_113 VGND VGND VPWR VPWR sky130_fd_sc_hd__decap_6
X_2840_ _1417_ _1401_ _1419_ VGND VGND VPWR VPWR _1420_ sky130_fd_sc_hd__o21ai_1
XTAP_TAPCELL_ROW_41_483 VGND VPWR sky130_fd_sc_hd__tapvpwrvgnd_1
X_2771_ _1108_ _0750_ _1358_ VGND VGND VPWR VPWR _1359_ sky130_fd_sc_hd__and3_1
XFILLER_0_38_360 VGND VGND VPWR VPWR sky130_fd_sc_hd__decap_4
XTAP_TAPCELL_ROW_33_417 VGND VPWR sky130_fd_sc_hd__tapvpwrvgnd_1
XFILLER_0_5_449 VGND VGND VPWR VPWR sky130_fd_sc_hd__fill_2
XPHY_EDGE_ROW_9_Right_9 VGND VGND VPWR VPWR sky130_fd_sc_hd__decap_3
XFILLER_0_13_205 VPWR VGND VPWR VGND sky130_ef_sc_hd__decap_12
X_3254_ _1695_ VGND VGND VPWR VPWR _0054_ sky130_fd_sc_hd__inv_2
XTAP_TAPCELL_ROW_49_550 VGND VPWR sky130_fd_sc_hd__tapvpwrvgnd_1
X_2205_ _0802_ VGND VGND VPWR VPWR _0803_ sky130_fd_sc_hd__inv_2
XFILLER_0_0_165 VGND VGND VPWR VPWR sky130_fd_sc_hd__decap_3
X_3185_ _1668_ _1669_ VGND VGND VPWR VPWR _0022_ sky130_fd_sc_hd__nor2_1
X_3323_ _1705_ VGND VGND VPWR VPWR _0113_ sky130_fd_sc_hd__inv_2
X_2136_ reg_file.registers\[11\]\[0\] _0691_ _0733_ VGND VGND VPWR VPWR _0734_ sky130_fd_sc_hd__a21o_1
X_2067_ reg_file.registers\[2\]\[20\] _0558_ VGND VGND VPWR VPWR _0665_ sky130_fd_sc_hd__and2_1
XFILLER_0_8_221 VPWR VGND VPWR VGND sky130_ef_sc_hd__decap_12
XPHY_EDGE_ROW_14_Left_86 VGND VGND VPWR VPWR sky130_fd_sc_hd__decap_3
XFILLER_0_71_193 VGND VGND VPWR VPWR sky130_fd_sc_hd__decap_3
X_2969_ _1510_ VGND VGND VPWR VPWR _0253_ sky130_fd_sc_hd__clkbuf_1
XFILLER_0_48_179 VGND VGND VPWR VPWR sky130_fd_sc_hd__decap_4
XFILLER_0_44_374 VGND VGND VPWR VPWR sky130_fd_sc_hd__fill_2
XFILLER_0_36_319 VGND VGND VPWR VPWR sky130_fd_sc_hd__decap_4
XFILLER_0_29_393 VPWR VGND VPWR VGND sky130_ef_sc_hd__decap_12
XFILLER_0_8_265 VPWR VGND VPWR VGND sky130_ef_sc_hd__decap_12
XTAP_TAPCELL_ROW_4_186 VGND VPWR sky130_fd_sc_hd__tapvpwrvgnd_1
XTAP_TAPCELL_ROW_55_597 VGND VPWR sky130_fd_sc_hd__tapvpwrvgnd_1
XFILLER_0_39_102 VGND VGND VPWR VPWR sky130_fd_sc_hd__decap_4
XFILLER_0_40_29 VGND VGND VPWR VPWR sky130_fd_sc_hd__fill_2
XFILLER_0_50_377 VPWR VGND VPWR VGND sky130_ef_sc_hd__decap_12
XFILLER_0_35_396 VGND VGND VPWR VPWR sky130_fd_sc_hd__decap_3
XFILLER_0_2_419 VGND VGND VPWR VPWR sky130_fd_sc_hd__fill_1
XFILLER_0_4_29 VPWR VGND VPWR VGND sky130_ef_sc_hd__decap_12
XTAP_TAPCELL_ROW_46_520 VGND VPWR sky130_fd_sc_hd__tapvpwrvgnd_1
XFILLER_0_14_41 VPWR VGND VPWR VGND sky130_ef_sc_hd__decap_12
XTAP_TAPCELL_ROW_18_299 VGND VPWR sky130_fd_sc_hd__tapvpwrvgnd_1
X_2754_ _1090_ _1339_ _1341_ _1342_ VGND VGND VPWR VPWR _1343_ sky130_fd_sc_hd__a2bb2o_1
XFILLER_0_41_322 VGND VGND VPWR VPWR sky130_fd_sc_hd__fill_2
XFILLER_0_41_300 VGND VGND VPWR VPWR sky130_fd_sc_hd__decap_6
X_2823_ _0789_ _0793_ _0854_ _1404_ VGND VGND VPWR VPWR _1405_ sky130_fd_sc_hd__a211o_1
XFILLER_0_26_374 VGND VGND VPWR VPWR sky130_fd_sc_hd__decap_8
XFILLER_0_5_279 VGND VGND VPWR VPWR sky130_fd_sc_hd__fill_1
X_3306_ _1702_ VGND VGND VPWR VPWR _0099_ sky130_fd_sc_hd__inv_2
X_2685_ _0902_ _0894_ _0995_ VGND VGND VPWR VPWR _1278_ sky130_fd_sc_hd__mux2_1
XFILLER_0_1_441 VGND VGND VPWR VPWR sky130_fd_sc_hd__decap_4
X_3237_ _1694_ VGND VGND VPWR VPWR _0038_ sky130_fd_sc_hd__inv_2
X_2119_ _0713_ _0716_ _0572_ VGND VGND VPWR VPWR _0717_ sky130_fd_sc_hd__mux2_1
XTAP_TAPCELL_ROW_1_167 VGND VPWR sky130_fd_sc_hd__tapvpwrvgnd_1
X_3168_ _1616_ _1645_ _1660_ _1608_ VGND VGND VPWR VPWR _0004_ sky130_fd_sc_hd__a22o_1
XFILLER_0_71_91 VGND VGND VPWR VPWR sky130_fd_sc_hd__fill_1
XFILLER_0_64_403 VPWR VGND VPWR VGND sky130_ef_sc_hd__decap_12
X_3099_ reg_file.registers\[11\]\[28\] _0927_ _0928_ reg_file.registers\[10\]\[28\]
+ _1153_ VGND VGND VPWR VPWR _1599_ sky130_fd_sc_hd__a221o_1
XFILLER_0_32_388 VGND VGND VPWR VPWR sky130_fd_sc_hd__fill_1
XFILLER_0_32_333 VGND VGND VPWR VPWR sky130_fd_sc_hd__decap_6
XFILLER_0_17_396 VGND VGND VPWR VPWR sky130_fd_sc_hd__decap_8
XTAP_TAPCELL_ROW_43_501 VGND VPWR sky130_fd_sc_hd__tapvpwrvgnd_1
XFILLER_0_67_263 VGND VGND VPWR VPWR sky130_fd_sc_hd__fill_1
Xclkload15 clknet_leaf_13_clk VGND VGND VPWR VPWR clkload15/Y sky130_fd_sc_hd__inv_6
XFILLER_0_35_160 VGND VGND VPWR VPWR sky130_fd_sc_hd__decap_8
XFILLER_0_50_141 VGND VGND VPWR VPWR sky130_fd_sc_hd__fill_2
X_2470_ reg_file.registers\[5\]\[4\] _0715_ VGND VGND VPWR VPWR _1067_ sky130_fd_sc_hd__nand2_1
X_3022_ imem.address\[19\] _1528_ imem.address\[20\] VGND VGND VPWR VPWR _1545_ sky130_fd_sc_hd__a21oi_1
XFILLER_0_58_274 VPWR VGND VPWR VGND sky130_ef_sc_hd__decap_12
XFILLER_0_25_73 VGND VGND VPWR VPWR sky130_fd_sc_hd__fill_1
Xclkload9 clknet_leaf_9_clk VGND VGND VPWR VPWR clkload9/Y sky130_fd_sc_hd__inv_6
X_2668_ _0763_ _0711_ _0995_ VGND VGND VPWR VPWR _1261_ sky130_fd_sc_hd__mux2_1
X_2806_ _0594_ _1200_ _1296_ _1389_ _0608_ VGND VGND VPWR VPWR _1390_ sky130_fd_sc_hd__a32o_1
XFILLER_0_41_163 VGND VGND VPWR VPWR sky130_fd_sc_hd__decap_4
X_2737_ _0867_ _1320_ _1326_ VGND VGND VPWR VPWR _1327_ sky130_fd_sc_hd__or3_1
XFILLER_0_14_388 VPWR VGND VPWR VGND sky130_ef_sc_hd__decap_12
X_2599_ _1191_ _1194_ _1018_ VGND VGND VPWR VPWR _1195_ sky130_fd_sc_hd__mux2_1
XFILLER_0_1_293 VPWR VGND VPWR VGND sky130_ef_sc_hd__decap_12
XTAP_TAPCELL_ROW_6_204 VGND VPWR sky130_fd_sc_hd__tapvpwrvgnd_1
XTAP_TAPCELL_ROW_57_615 VGND VPWR sky130_fd_sc_hd__tapvpwrvgnd_1
XFILLER_0_49_241 VGND VGND VPWR VPWR sky130_fd_sc_hd__decap_4
XFILLER_0_64_288 VPWR VGND VPWR VGND sky130_ef_sc_hd__decap_12
XFILLER_0_49_263 VPWR VGND VPWR VGND sky130_ef_sc_hd__decap_12
XFILLER_0_37_447 VGND VGND VPWR VPWR sky130_fd_sc_hd__fill_1
XFILLER_0_9_360 VGND VGND VPWR VPWR sky130_fd_sc_hd__decap_6
XFILLER_0_17_182 VGND VGND VPWR VPWR sky130_fd_sc_hd__decap_4
XFILLER_0_20_325 VGND VGND VPWR VPWR sky130_fd_sc_hd__fill_1
XFILLER_0_20_369 VGND VGND VPWR VPWR sky130_fd_sc_hd__fill_1
XFILLER_0_62_49 VGND VGND VPWR VPWR sky130_fd_sc_hd__fill_1
XFILLER_0_55_244 VPWR VGND VPWR VGND sky130_ef_sc_hd__decap_12
XTAP_TAPCELL_ROW_28_383 VGND VPWR sky130_fd_sc_hd__tapvpwrvgnd_1
X_1970_ _0567_ VGND VGND VPWR VPWR _0568_ sky130_fd_sc_hd__buf_2
XFILLER_0_43_406 VGND VGND VPWR VPWR sky130_fd_sc_hd__fill_1
X_2522_ _1113_ _1118_ _1018_ VGND VGND VPWR VPWR _1119_ sky130_fd_sc_hd__mux2_1
X_3571_ clknet_leaf_18_clk _0333_ _0144_ VGND VGND VPWR VPWR reg_file.registers\[10\]\[23\]
+ sky130_fd_sc_hd__dfrtp_2
X_3640_ clknet_leaf_20_clk _0402_ _0213_ VGND VGND VPWR VPWR reg_file.registers\[2\]\[29\]
+ sky130_fd_sc_hd__dfrtp_1
X_2453_ _0721_ _0747_ _0994_ VGND VGND VPWR VPWR _1051_ sky130_fd_sc_hd__mux2_1
X_2384_ _0575_ _0981_ _0580_ VGND VGND VPWR VPWR _0982_ sky130_fd_sc_hd__a21oi_1
X_3005_ _1536_ _1537_ VGND VGND VPWR VPWR _1538_ sky130_fd_sc_hd__and2_1
XTAP_TAPCELL_ROW_62_651 VGND VPWR sky130_fd_sc_hd__tapvpwrvgnd_1
XFILLER_0_19_436 VPWR VGND VPWR VGND sky130_ef_sc_hd__decap_12
XFILLER_0_61_269 VGND VGND VPWR VPWR sky130_fd_sc_hd__fill_1
XFILLER_0_42_450 VGND VGND VPWR VPWR sky130_fd_sc_hd__fill_1
XFILLER_0_14_185 VGND VGND VPWR VPWR sky130_fd_sc_hd__decap_8
XTAP_TAPCELL_ROW_25_353 VGND VPWR sky130_fd_sc_hd__tapvpwrvgnd_1
XFILLER_0_52_236 VPWR VGND VPWR VGND sky130_ef_sc_hd__decap_12
XPHY_EDGE_ROW_2_Left_74 VGND VGND VPWR VPWR sky130_fd_sc_hd__decap_3
XFILLER_0_57_27 VGND VGND VPWR VPWR sky130_fd_sc_hd__decap_3
XFILLER_0_20_100 VGND VGND VPWR VPWR sky130_fd_sc_hd__fill_2
X_1953_ _0552_ VGND VGND VPWR VPWR _0311_ sky130_fd_sc_hd__clkbuf_1
X_1884_ reg_file.registers\[5\]\[1\] _0483_ VGND VGND VPWR VPWR _0516_ sky130_fd_sc_hd__or2b_1
XFILLER_0_43_225 VPWR VGND VPWR VGND sky130_ef_sc_hd__decap_12
XFILLER_0_28_222 VGND VGND VPWR VPWR sky130_fd_sc_hd__fill_1
XFILLER_0_22_85 VGND VGND VPWR VPWR sky130_fd_sc_hd__decap_4
XFILLER_0_22_41 VPWR VGND VPWR VGND sky130_ef_sc_hd__decap_12
XFILLER_0_7_105 VGND VGND VPWR VPWR sky130_fd_sc_hd__decap_6
XFILLER_0_7_149 VPWR VGND VPWR VGND sky130_ef_sc_hd__decap_12
X_3554_ clknet_leaf_10_clk _0316_ _0127_ VGND VGND VPWR VPWR reg_file.registers\[10\]\[6\]
+ sky130_fd_sc_hd__dfrtp_2
X_3485_ clknet_leaf_8_clk _0247_ _0058_ VGND VGND VPWR VPWR reg_file.registers\[15\]\[1\]
+ sky130_fd_sc_hd__dfrtp_1
XFILLER_0_51_291 VGND VGND VPWR VPWR sky130_fd_sc_hd__decap_8
X_3623_ clknet_leaf_3_clk _0385_ _0196_ VGND VGND VPWR VPWR reg_file.registers\[2\]\[12\]
+ sky130_fd_sc_hd__dfrtp_1
X_2505_ reg_file.registers\[11\]\[14\] _1070_ _1073_ reg_file.registers\[10\]\[14\]
+ VGND VGND VPWR VPWR _1102_ sky130_fd_sc_hd__a22oi_1
XFILLER_0_11_111 VGND VGND VPWR VPWR sky130_fd_sc_hd__fill_1
XFILLER_0_37_3 VPWR VGND VPWR VGND sky130_ef_sc_hd__decap_12
X_2298_ _0890_ _0891_ _0895_ VGND VGND VPWR VPWR _0896_ sky130_fd_sc_hd__or3b_4
X_2367_ reg_file.registers\[2\]\[30\] _0559_ _0715_ reg_file.registers\[5\]\[30\]
+ VGND VGND VPWR VPWR _0965_ sky130_fd_sc_hd__a22o_1
X_2436_ _1026_ _1031_ _1032_ _1033_ VGND VGND VPWR VPWR _1034_ sky130_fd_sc_hd__a211o_1
XTAP_TAPCELL_ROW_39_467 VGND VPWR sky130_fd_sc_hd__tapvpwrvgnd_1
XFILLER_0_19_222 VGND VGND VPWR VPWR sky130_fd_sc_hd__fill_2
XTAP_TAPCELL_ROW_22_334 VGND VPWR sky130_fd_sc_hd__tapvpwrvgnd_1
XFILLER_0_19_255 VGND VGND VPWR VPWR sky130_fd_sc_hd__decap_4
XFILLER_0_69_111 VGND VGND VPWR VPWR sky130_fd_sc_hd__fill_1
XFILLER_0_43_29 VGND VGND VPWR VPWR sky130_fd_sc_hd__fill_1
XFILLER_0_25_225 VGND VGND VPWR VPWR sky130_fd_sc_hd__decap_4
XFILLER_0_68_15 VPWR VGND VPWR VGND sky130_ef_sc_hd__decap_12
XFILLER_0_25_258 VPWR VGND VPWR VGND sky130_ef_sc_hd__decap_12
XFILLER_0_13_409 VPWR VGND VPWR VGND sky130_ef_sc_hd__decap_12
X_2221_ reg_file.registers\[11\]\[10\] _0692_ _0697_ reg_file.registers\[10\]\[10\]
+ VGND VGND VPWR VPWR _0819_ sky130_fd_sc_hd__a22o_2
X_2152_ reg_file.registers\[5\]\[4\] _0562_ VGND VGND VPWR VPWR _0750_ sky130_fd_sc_hd__and2_2
X_3270_ _1697_ VGND VGND VPWR VPWR _0068_ sky130_fd_sc_hd__inv_2
XFILLER_0_8_403 VGND VGND VPWR VPWR sky130_fd_sc_hd__decap_3
XFILLER_0_17_52 VGND VGND VPWR VPWR sky130_fd_sc_hd__fill_1
X_2083_ reg_file.registers\[2\]\[28\] _0559_ VGND VGND VPWR VPWR _0681_ sky130_fd_sc_hd__and2_1
X_2985_ imem.address\[5\] _0455_ _1482_ VGND VGND VPWR VPWR _1519_ sky130_fd_sc_hd__and3_1
X_1936_ reg_file.registers\[10\]\[9\] _0539_ VGND VGND VPWR VPWR _0544_ sky130_fd_sc_hd__and2_1
XFILLER_0_56_372 VGND VGND VPWR VPWR sky130_fd_sc_hd__decap_6
X_1867_ _0507_ VGND VGND VPWR VPWR _0352_ sky130_fd_sc_hd__clkbuf_1
XFILLER_0_16_236 VGND VGND VPWR VPWR sky130_fd_sc_hd__decap_4
XFILLER_0_16_269 VGND VGND VPWR VPWR sky130_fd_sc_hd__decap_6
X_1798_ imem.address\[5\] _0455_ _0456_ _0459_ VGND VGND VPWR VPWR _0460_ sky130_fd_sc_hd__or4_4
X_3468_ clknet_leaf_6_clk _0237_ _0048_ VGND VGND VPWR VPWR imem.address\[23\] sky130_fd_sc_hd__dfrtp_1
X_3537_ clknet_leaf_14_clk _0299_ _0110_ VGND VGND VPWR VPWR reg_file.registers\[11\]\[21\]
+ sky130_fd_sc_hd__dfrtp_1
X_3606_ clknet_leaf_20_clk _0368_ _0179_ VGND VGND VPWR VPWR reg_file.registers\[5\]\[26\]
+ sky130_fd_sc_hd__dfrtp_1
X_2419_ _0723_ VGND VGND VPWR VPWR _1017_ sky130_fd_sc_hd__buf_2
X_3399_ _1713_ VGND VGND VPWR VPWR _0181_ sky130_fd_sc_hd__inv_2
XTAP_TAPCELL_ROW_70_716 VGND VPWR sky130_fd_sc_hd__tapvpwrvgnd_1
XFILLER_0_54_309 VGND VGND VPWR VPWR sky130_fd_sc_hd__fill_2
XFILLER_0_47_350 VGND VGND VPWR VPWR sky130_fd_sc_hd__decap_3
XFILLER_0_62_386 VGND VGND VPWR VPWR sky130_fd_sc_hd__fill_1
XFILLER_0_22_239 VGND VGND VPWR VPWR sky130_fd_sc_hd__fill_1
XTAP_TAPCELL_ROW_33_418 VGND VPWR sky130_fd_sc_hd__tapvpwrvgnd_1
XFILLER_0_70_27 VGND VGND VPWR VPWR sky130_fd_sc_hd__fill_1
XFILLER_0_57_169 VGND VGND VPWR VPWR sky130_fd_sc_hd__decap_3
X_2770_ _1025_ _1356_ _1357_ VGND VGND VPWR VPWR _1358_ sky130_fd_sc_hd__a21o_1
XTAP_TAPCELL_ROW_41_484 VGND VPWR sky130_fd_sc_hd__tapvpwrvgnd_1
XFILLER_0_38_350 VGND VGND VPWR VPWR sky130_fd_sc_hd__decap_3
XFILLER_0_13_217 VGND VGND VPWR VPWR sky130_fd_sc_hd__decap_6
X_3322_ _1705_ VGND VGND VPWR VPWR _0112_ sky130_fd_sc_hd__inv_2
X_3253_ _1695_ VGND VGND VPWR VPWR _0053_ sky130_fd_sc_hd__inv_2
X_2135_ reg_file.registers\[10\]\[0\] net17 _0732_ VGND VGND VPWR VPWR _0733_ sky130_fd_sc_hd__and3_1
XTAP_TAPCELL_ROW_49_551 VGND VPWR sky130_fd_sc_hd__tapvpwrvgnd_1
X_2204_ reg_file.registers\[11\]\[12\] _0692_ _0697_ reg_file.registers\[10\]\[12\]
+ VGND VGND VPWR VPWR _0802_ sky130_fd_sc_hd__a22o_1
X_3184_ display.counter\[4\] _1666_ display.counter\[5\] VGND VGND VPWR VPWR _1669_
+ sky130_fd_sc_hd__a21oi_1
XFILLER_0_36_309 VGND VGND VPWR VPWR sky130_fd_sc_hd__fill_1
XFILLER_0_29_383 VGND VGND VPWR VPWR sky130_fd_sc_hd__fill_1
X_2066_ reg_file.registers\[5\]\[21\] _0564_ _0568_ reg_file.registers\[15\]\[21\]
+ _0663_ VGND VGND VPWR VPWR _0664_ sky130_fd_sc_hd__a221o_1
XFILLER_0_8_233 VPWR VGND VPWR VGND sky130_ef_sc_hd__decap_12
X_2899_ reg_file.registers\[11\]\[3\] _1468_ _1058_ VGND VGND VPWR VPWR _1469_ sky130_fd_sc_hd__mux2_1
XFILLER_0_60_93 VGND VGND VPWR VPWR sky130_fd_sc_hd__fill_1
X_2968_ reg_file.registers\[15\]\[7\] _1483_ VGND VGND VPWR VPWR _1510_ sky130_fd_sc_hd__and2_1
X_1919_ reg_file.registers\[10\]\[17\] _0528_ VGND VGND VPWR VPWR _0535_ sky130_fd_sc_hd__and2_1
XFILLER_0_8_83 VGND VGND VPWR VPWR sky130_fd_sc_hd__fill_1
XFILLER_0_8_277 VPWR VGND VPWR VGND sky130_ef_sc_hd__decap_12
XTAP_TAPCELL_ROW_4_187 VGND VPWR sky130_fd_sc_hd__tapvpwrvgnd_1
XTAP_TAPCELL_ROW_55_598 VGND VPWR sky130_fd_sc_hd__tapvpwrvgnd_1
XFILLER_0_54_139 VGND VGND VPWR VPWR sky130_fd_sc_hd__fill_1
XFILLER_0_54_106 VGND VGND VPWR VPWR sky130_fd_sc_hd__fill_1
XFILLER_0_50_389 VGND VGND VPWR VPWR sky130_fd_sc_hd__decap_8
XFILLER_0_50_345 VGND VGND VPWR VPWR sky130_fd_sc_hd__fill_1
XFILLER_0_10_209 VPWR VGND VPWR VGND sky130_ef_sc_hd__decap_12
XTAP_TAPCELL_ROW_46_521 VGND VPWR sky130_fd_sc_hd__tapvpwrvgnd_1
XFILLER_0_14_53 VPWR VGND VPWR VGND sky130_ef_sc_hd__decap_12
XFILLER_0_18_309 VGND VGND VPWR VPWR sky130_fd_sc_hd__decap_4
XFILLER_0_60_109 VGND VGND VPWR VPWR sky130_fd_sc_hd__decap_8
XFILLER_0_45_139 VGND VGND VPWR VPWR sky130_fd_sc_hd__fill_2
X_2753_ _1106_ VGND VGND VPWR VPWR _1342_ sky130_fd_sc_hd__inv_2
X_2822_ _1403_ _0796_ VGND VGND VPWR VPWR _1404_ sky130_fd_sc_hd__and2b_1
XFILLER_0_38_180 VGND VGND VPWR VPWR sky130_fd_sc_hd__decap_6
XFILLER_0_30_85 VGND VGND VPWR VPWR sky130_fd_sc_hd__decap_4
X_2684_ _1145_ _1271_ _1276_ _1244_ VGND VGND VPWR VPWR _1277_ sky130_fd_sc_hd__o211a_1
XFILLER_0_5_225 VPWR VGND VPWR VGND sky130_ef_sc_hd__decap_12
X_3305_ _1702_ VGND VGND VPWR VPWR _0098_ sky130_fd_sc_hd__inv_2
XFILLER_0_39_72 VGND VGND VPWR VPWR sky130_fd_sc_hd__decap_3
X_3236_ _1694_ VGND VGND VPWR VPWR _0037_ sky130_fd_sc_hd__inv_2
X_2118_ reg_file.registers\[15\]\[0\] _0599_ _0715_ reg_file.registers\[5\]\[0\] _0601_
+ VGND VGND VPWR VPWR _0716_ sky130_fd_sc_hd__a221o_1
XFILLER_0_49_401 VGND VGND VPWR VPWR sky130_fd_sc_hd__fill_2
X_2049_ _0573_ _0646_ _0579_ VGND VGND VPWR VPWR _0647_ sky130_fd_sc_hd__a21oi_1
X_3167_ _1616_ _1634_ _1644_ VGND VGND VPWR VPWR _1660_ sky130_fd_sc_hd__o21bai_1
X_3098_ reg_file.registers\[11\]\[29\] _0927_ _0928_ reg_file.registers\[10\]\[29\]
+ _1155_ VGND VGND VPWR VPWR _1598_ sky130_fd_sc_hd__a221o_1
XFILLER_0_71_81 VGND VGND VPWR VPWR sky130_fd_sc_hd__decap_3
XFILLER_0_64_415 VGND VGND VPWR VPWR sky130_fd_sc_hd__decap_4
XTAP_TAPCELL_ROW_52_568 VGND VPWR sky130_fd_sc_hd__tapvpwrvgnd_1
XFILLER_0_36_139 VGND VGND VPWR VPWR sky130_fd_sc_hd__fill_1
XTAP_TAPCELL_ROW_9_224 VGND VPWR sky130_fd_sc_hd__tapvpwrvgnd_1
XFILLER_0_55_426 VGND VGND VPWR VPWR sky130_fd_sc_hd__decap_6
XFILLER_0_55_415 VGND VGND VPWR VPWR sky130_fd_sc_hd__decap_8
XTAP_TAPCELL_ROW_43_502 VGND VPWR sky130_fd_sc_hd__tapvpwrvgnd_1
Xclkload16 clknet_leaf_14_clk VGND VGND VPWR VPWR clkload16/Y sky130_fd_sc_hd__inv_8
XFILLER_0_23_334 VGND VGND VPWR VPWR sky130_fd_sc_hd__fill_2
X_3021_ _1530_ _1544_ VGND VGND VPWR VPWR _0235_ sky130_fd_sc_hd__nor2_1
XFILLER_0_58_286 VGND VGND VPWR VPWR sky130_fd_sc_hd__decap_4
XFILLER_0_58_231 VPWR VGND VPWR VGND sky130_ef_sc_hd__decap_12
X_2805_ _1145_ _1181_ VGND VGND VPWR VPWR _1389_ sky130_fd_sc_hd__nor2_1
XFILLER_0_46_404 VGND VGND VPWR VPWR sky130_fd_sc_hd__decap_3
XTAP_TAPCELL_ROW_14_270 VGND VPWR sky130_fd_sc_hd__tapvpwrvgnd_1
XFILLER_0_67_3 VGND VGND VPWR VPWR sky130_fd_sc_hd__decap_6
XFILLER_0_61_429 VPWR VGND VPWR VGND sky130_ef_sc_hd__decap_12
X_2667_ _1259_ VGND VGND VPWR VPWR _1260_ sky130_fd_sc_hd__inv_2
XFILLER_0_41_153 VGND VGND VPWR VPWR sky130_fd_sc_hd__decap_3
X_2736_ _0924_ _1325_ _0872_ _0921_ VGND VGND VPWR VPWR _1326_ sky130_fd_sc_hd__o211a_1
XFILLER_0_1_261 VPWR VGND VPWR VGND sky130_ef_sc_hd__decap_12
XFILLER_0_14_334 VGND VGND VPWR VPWR sky130_fd_sc_hd__fill_1
XFILLER_0_14_356 VGND VGND VPWR VPWR sky130_fd_sc_hd__decap_8
XFILLER_0_5_51 VGND VGND VPWR VPWR sky130_fd_sc_hd__decap_4
XTAP_TAPCELL_ROW_6_205 VGND VPWR sky130_fd_sc_hd__tapvpwrvgnd_1
X_3219_ _1688_ _1689_ VGND VGND VPWR VPWR _1690_ sky130_fd_sc_hd__and2_1
X_2598_ _1192_ _1193_ _1153_ VGND VGND VPWR VPWR _1194_ sky130_fd_sc_hd__mux2_1
XFILLER_0_49_275 VGND VGND VPWR VPWR sky130_fd_sc_hd__decap_4
XFILLER_0_46_29 VGND VGND VPWR VPWR sky130_fd_sc_hd__decap_4
XFILLER_0_55_267 VPWR VGND VPWR VGND sky130_ef_sc_hd__decap_12
XFILLER_0_55_256 VGND VGND VPWR VPWR sky130_fd_sc_hd__decap_4
XFILLER_0_70_226 VGND VGND VPWR VPWR sky130_fd_sc_hd__decap_3
XFILLER_0_51_440 VGND VGND VPWR VPWR sky130_fd_sc_hd__fill_1
X_2521_ _1116_ _1117_ _1069_ VGND VGND VPWR VPWR _1118_ sky130_fd_sc_hd__mux2_1
XTAP_TAPCELL_ROW_11_240 VGND VPWR sky130_fd_sc_hd__tapvpwrvgnd_1
XFILLER_0_11_337 VGND VGND VPWR VPWR sky130_fd_sc_hd__fill_1
X_3570_ clknet_leaf_18_clk _0332_ _0143_ VGND VGND VPWR VPWR reg_file.registers\[10\]\[22\]
+ sky130_fd_sc_hd__dfrtp_4
X_2452_ _1047_ _1049_ _1002_ VGND VGND VPWR VPWR _1050_ sky130_fd_sc_hd__mux2_1
X_2383_ reg_file.registers\[5\]\[31\] _0680_ _0568_ reg_file.registers\[15\]\[31\]
+ _0980_ VGND VGND VPWR VPWR _0981_ sky130_fd_sc_hd__a221o_1
XPHY_EDGE_ROW_18_Right_18 VGND VGND VPWR VPWR sky130_fd_sc_hd__decap_3
X_3004_ imem.address\[30\] _1535_ VGND VGND VPWR VPWR _1537_ sky130_fd_sc_hd__or2_1
XPHY_EDGE_ROW_27_Right_27 VGND VGND VPWR VPWR sky130_fd_sc_hd__decap_3
XFILLER_0_19_415 VGND VGND VPWR VPWR sky130_fd_sc_hd__fill_2
XTAP_TAPCELL_ROW_62_652 VGND VPWR sky130_fd_sc_hd__tapvpwrvgnd_1
XFILLER_0_61_248 VGND VGND VPWR VPWR sky130_fd_sc_hd__decap_4
XFILLER_0_6_375 VGND VGND VPWR VPWR sky130_fd_sc_hd__fill_1
X_2719_ _1217_ VGND VGND VPWR VPWR _1310_ sky130_fd_sc_hd__inv_2
XPHY_EDGE_ROW_36_Right_36 VGND VGND VPWR VPWR sky130_fd_sc_hd__decap_3
XFILLER_0_14_197 VPWR VGND VPWR VGND sky130_ef_sc_hd__decap_12
XPHY_EDGE_ROW_45_Right_45 VGND VGND VPWR VPWR sky130_fd_sc_hd__decap_3
XFILLER_0_37_223 VGND VGND VPWR VPWR sky130_fd_sc_hd__fill_1
XTAP_TAPCELL_ROW_25_354 VGND VPWR sky130_fd_sc_hd__tapvpwrvgnd_1
XPHY_EDGE_ROW_54_Right_54 VGND VGND VPWR VPWR sky130_fd_sc_hd__decap_3
XFILLER_0_52_259 VGND VGND VPWR VPWR sky130_fd_sc_hd__fill_1
XFILLER_0_52_248 VGND VGND VPWR VPWR sky130_fd_sc_hd__decap_4
XPHY_EDGE_ROW_63_Right_63 VGND VGND VPWR VPWR sky130_fd_sc_hd__decap_3
X_1952_ reg_file.registers\[10\]\[1\] _0519_ VGND VGND VPWR VPWR _0552_ sky130_fd_sc_hd__or2b_1
X_1883_ _0515_ VGND VGND VPWR VPWR _0344_ sky130_fd_sc_hd__clkbuf_1
X_3622_ clknet_leaf_4_clk _0384_ _0195_ VGND VGND VPWR VPWR reg_file.registers\[2\]\[11\]
+ sky130_fd_sc_hd__dfrtp_1
XFILLER_0_43_237 VPWR VGND VPWR VGND sky130_ef_sc_hd__decap_12
XFILLER_0_22_53 VGND VGND VPWR VPWR sky130_fd_sc_hd__decap_3
X_3553_ clknet_leaf_10_clk _0315_ _0126_ VGND VGND VPWR VPWR reg_file.registers\[10\]\[5\]
+ sky130_fd_sc_hd__dfrtp_1
X_3484_ clknet_leaf_8_clk _0246_ _0057_ VGND VGND VPWR VPWR reg_file.registers\[15\]\[0\]
+ sky130_fd_sc_hd__dfrtp_1
X_2504_ _1099_ _1100_ _1068_ VGND VGND VPWR VPWR _1101_ sky130_fd_sc_hd__mux2_1
X_2435_ net37 _0979_ VGND VGND VPWR VPWR _1033_ sky130_fd_sc_hd__nor2_1
XFILLER_0_11_167 VGND VGND VPWR VPWR sky130_fd_sc_hd__fill_1
XFILLER_0_47_72 VGND VGND VPWR VPWR sky130_fd_sc_hd__fill_1
XFILLER_0_47_50 VGND VGND VPWR VPWR sky130_fd_sc_hd__decap_6
XTAP_TAPCELL_ROW_39_468 VGND VPWR sky130_fd_sc_hd__tapvpwrvgnd_1
X_2297_ _0894_ _0892_ VGND VGND VPWR VPWR _0895_ sky130_fd_sc_hd__xnor2_1
XFILLER_0_2_41 VPWR VGND VPWR VGND sky130_ef_sc_hd__decap_12
X_2366_ _0962_ _0700_ _0963_ VGND VGND VPWR VPWR _0964_ sky130_fd_sc_hd__a21oi_2
XFILLER_0_59_381 VGND VGND VPWR VPWR sky130_fd_sc_hd__decap_4
XFILLER_0_2_85 VPWR VGND VPWR VGND sky130_ef_sc_hd__decap_12
XFILLER_0_19_234 VGND VGND VPWR VPWR sky130_fd_sc_hd__decap_8
XFILLER_0_34_248 VGND VGND VPWR VPWR sky130_fd_sc_hd__decap_4
XTAP_TAPCELL_ROW_22_335 VGND VPWR sky130_fd_sc_hd__tapvpwrvgnd_1
XFILLER_0_19_289 VGND VGND VPWR VPWR sky130_fd_sc_hd__decap_8
XFILLER_0_69_167 VGND VGND VPWR VPWR sky130_fd_sc_hd__fill_1
XFILLER_0_4_109 VPWR VGND VPWR VGND sky130_ef_sc_hd__decap_12
XFILLER_0_68_27 VGND VGND VPWR VPWR sky130_fd_sc_hd__fill_1
XFILLER_0_33_281 VPWR VGND VPWR VGND sky130_ef_sc_hd__decap_12
XFILLER_0_0_337 VPWR VGND VPWR VGND sky130_ef_sc_hd__decap_12
X_2151_ _0740_ _0746_ _0748_ VGND VGND VPWR VPWR _0749_ sky130_fd_sc_hd__a21boi_1
X_2220_ _0628_ _0817_ VGND VGND VPWR VPWR _0818_ sky130_fd_sc_hd__xor2_2
X_2082_ _0564_ VGND VGND VPWR VPWR _0680_ sky130_fd_sc_hd__clkbuf_4
X_2984_ _1518_ VGND VGND VPWR VPWR _0246_ sky130_fd_sc_hd__clkbuf_1
XFILLER_0_71_365 VPWR VGND VPWR VGND sky130_ef_sc_hd__decap_12
XFILLER_0_71_321 VPWR VGND VPWR VGND sky130_ef_sc_hd__decap_12
X_1797_ _0457_ _0458_ VGND VGND VPWR VPWR _0459_ sky130_fd_sc_hd__nand2_1
XFILLER_0_56_351 VGND VGND VPWR VPWR sky130_fd_sc_hd__fill_2
X_1935_ _0543_ VGND VGND VPWR VPWR _0320_ sky130_fd_sc_hd__clkbuf_1
X_1866_ reg_file.registers\[5\]\[10\] _0504_ VGND VGND VPWR VPWR _0507_ sky130_fd_sc_hd__and2_1
X_3605_ clknet_leaf_21_clk _0367_ _0178_ VGND VGND VPWR VPWR reg_file.registers\[5\]\[25\]
+ sky130_fd_sc_hd__dfrtp_1
X_3467_ clknet_leaf_6_clk _0236_ _0047_ VGND VGND VPWR VPWR imem.address\[22\] sky130_fd_sc_hd__dfrtp_1
XFILLER_0_58_93 VGND VGND VPWR VPWR sky130_fd_sc_hd__fill_2
X_2418_ _0594_ _1014_ VGND VGND VPWR VPWR _1016_ sky130_fd_sc_hd__nor2_2
X_3536_ clknet_leaf_14_clk _0298_ _0109_ VGND VGND VPWR VPWR reg_file.registers\[11\]\[20\]
+ sky130_fd_sc_hd__dfrtp_2
XFILLER_0_12_443 VGND VGND VPWR VPWR sky130_fd_sc_hd__decap_8
X_3398_ _1713_ VGND VGND VPWR VPWR _0180_ sky130_fd_sc_hd__inv_2
X_2349_ reg_file.registers\[11\]\[27\] _0694_ _0946_ VGND VGND VPWR VPWR _0947_ sky130_fd_sc_hd__a21oi_1
XTAP_TAPCELL_ROW_70_717 VGND VPWR sky130_fd_sc_hd__tapvpwrvgnd_1
XFILLER_0_62_343 VPWR VGND VPWR VGND sky130_ef_sc_hd__decap_12
XFILLER_0_47_362 VGND VGND VPWR VPWR sky130_fd_sc_hd__decap_8
XPHY_EDGE_ROW_0_Right_0 VGND VGND VPWR VPWR sky130_fd_sc_hd__decap_3
XFILLER_0_62_365 VGND VGND VPWR VPWR sky130_fd_sc_hd__fill_2
XFILLER_0_30_262 VGND VGND VPWR VPWR sky130_fd_sc_hd__decap_4
XFILLER_0_54_29 VGND VGND VPWR VPWR sky130_fd_sc_hd__decap_4
XPHY_EDGE_ROW_35_Left_107 VGND VGND VPWR VPWR sky130_fd_sc_hd__decap_3
XTAP_TAPCELL_ROW_33_419 VGND VPWR sky130_fd_sc_hd__tapvpwrvgnd_1
XPHY_EDGE_ROW_44_Left_116 VGND VGND VPWR VPWR sky130_fd_sc_hd__decap_3
XTAP_TAPCELL_ROW_41_485 VGND VPWR sky130_fd_sc_hd__tapvpwrvgnd_1
XFILLER_0_38_373 VGND VGND VPWR VPWR sky130_fd_sc_hd__fill_2
X_3252_ _1695_ VGND VGND VPWR VPWR _0052_ sky130_fd_sc_hd__inv_2
X_3321_ _1705_ VGND VGND VPWR VPWR _0111_ sky130_fd_sc_hd__inv_2
X_2134_ net25 _0562_ VGND VGND VPWR VPWR _0732_ sky130_fd_sc_hd__nor2_1
XPHY_EDGE_ROW_53_Left_125 VGND VGND VPWR VPWR sky130_fd_sc_hd__decap_3
X_2203_ _0798_ _0800_ VGND VGND VPWR VPWR _0801_ sky130_fd_sc_hd__xor2_1
XFILLER_0_44_40 VGND VGND VPWR VPWR sky130_fd_sc_hd__fill_1
XFILLER_0_28_63 VPWR VGND VPWR VGND sky130_ef_sc_hd__decap_12
X_2065_ reg_file.registers\[2\]\[21\] _0559_ VGND VGND VPWR VPWR _0663_ sky130_fd_sc_hd__and2_1
X_3183_ display.counter\[4\] display.counter\[5\] _1666_ VGND VGND VPWR VPWR _1668_
+ sky130_fd_sc_hd__and3_1
X_2967_ _1509_ VGND VGND VPWR VPWR _0254_ sky130_fd_sc_hd__clkbuf_1
XFILLER_0_48_126 VGND VGND VPWR VPWR sky130_fd_sc_hd__decap_4
XFILLER_0_8_245 VGND VGND VPWR VPWR sky130_fd_sc_hd__decap_6
XPHY_EDGE_ROW_62_Left_134 VGND VGND VPWR VPWR sky130_fd_sc_hd__decap_3
X_2898_ _1016_ _1332_ _1053_ _1467_ VGND VGND VPWR VPWR _1468_ sky130_fd_sc_hd__a31o_1
X_1918_ _0534_ VGND VGND VPWR VPWR _0328_ sky130_fd_sc_hd__clkbuf_1
X_1849_ reg_file.registers\[5\]\[18\] _0493_ VGND VGND VPWR VPWR _0498_ sky130_fd_sc_hd__and2_1
XFILLER_0_8_289 VGND VGND VPWR VPWR sky130_fd_sc_hd__decap_8
XFILLER_0_12_251 VGND VGND VPWR VPWR sky130_fd_sc_hd__fill_1
XPHY_EDGE_ROW_71_Left_143 VGND VGND VPWR VPWR sky130_fd_sc_hd__decap_3
X_3519_ clknet_leaf_11_clk _0281_ _0092_ VGND VGND VPWR VPWR reg_file.registers\[11\]\[3\]
+ sky130_fd_sc_hd__dfrtp_1
XTAP_TAPCELL_ROW_55_599 VGND VPWR sky130_fd_sc_hd__tapvpwrvgnd_1
XFILLER_0_39_148 VPWR VGND VPWR VGND sky130_ef_sc_hd__decap_12
XTAP_TAPCELL_ROW_4_188 VGND VPWR sky130_fd_sc_hd__tapvpwrvgnd_1
Xclkbuf_leaf_20_clk clknet_1_0__leaf_clk VGND VGND VPWR VPWR clknet_leaf_20_clk sky130_fd_sc_hd__clkbuf_8
XFILLER_0_62_195 VGND VGND VPWR VPWR sky130_fd_sc_hd__fill_1
XTAP_TAPCELL_ROW_46_522 VGND VPWR sky130_fd_sc_hd__tapvpwrvgnd_1
XFILLER_0_58_424 VPWR VGND VPWR VGND sky130_ef_sc_hd__decap_12
X_2821_ _0807_ _1401_ _1402_ VGND VGND VPWR VPWR _1403_ sky130_fd_sc_hd__a21oi_1
XFILLER_0_14_65 VGND VGND VPWR VPWR sky130_fd_sc_hd__decap_8
Xclkbuf_leaf_11_clk clknet_1_1__leaf_clk VGND VGND VPWR VPWR clknet_leaf_11_clk sky130_fd_sc_hd__clkbuf_8
X_2752_ _1107_ _1340_ VGND VGND VPWR VPWR _1341_ sky130_fd_sc_hd__nor2_1
XFILLER_0_41_379 VPWR VGND VPWR VGND sky130_ef_sc_hd__decap_12
XFILLER_0_41_357 VPWR VGND VPWR VGND sky130_ef_sc_hd__decap_12
XFILLER_0_41_335 VGND VGND VPWR VPWR sky130_fd_sc_hd__fill_1
X_2683_ _1026_ _1275_ VGND VGND VPWR VPWR _1276_ sky130_fd_sc_hd__nand2_1
XFILLER_0_5_237 VPWR VGND VPWR VGND sky130_ef_sc_hd__decap_12
X_3235_ _1692_ VGND VGND VPWR VPWR _1694_ sky130_fd_sc_hd__buf_4
X_3304_ _1702_ VGND VGND VPWR VPWR _0097_ sky130_fd_sc_hd__inv_2
X_2117_ _0714_ VGND VGND VPWR VPWR _0715_ sky130_fd_sc_hd__clkbuf_4
X_2048_ reg_file.registers\[15\]\[15\] _0588_ _0590_ reg_file.registers\[5\]\[15\]
+ _0645_ VGND VGND VPWR VPWR _0646_ sky130_fd_sc_hd__a221o_1
X_3097_ _1595_ _1596_ _1022_ VGND VGND VPWR VPWR _1597_ sky130_fd_sc_hd__mux2_1
XFILLER_0_12_3 VPWR VGND VPWR VGND sky130_ef_sc_hd__decap_12
X_3166_ _1657_ _1658_ _1659_ _1654_ VGND VGND VPWR VPWR _0003_ sky130_fd_sc_hd__a211oi_2
XTAP_TAPCELL_ROW_52_569 VGND VPWR sky130_fd_sc_hd__tapvpwrvgnd_1
XFILLER_0_44_173 VGND VGND VPWR VPWR sky130_fd_sc_hd__fill_1
XTAP_TAPCELL_ROW_17_290 VGND VPWR sky130_fd_sc_hd__tapvpwrvgnd_1
XTAP_TAPCELL_ROW_9_225 VGND VPWR sky130_fd_sc_hd__tapvpwrvgnd_1
XFILLER_0_55_449 VGND VGND VPWR VPWR sky130_fd_sc_hd__fill_2
XTAP_TAPCELL_ROW_43_503 VGND VPWR sky130_fd_sc_hd__tapvpwrvgnd_1
XFILLER_0_70_419 VGND VGND VPWR VPWR sky130_fd_sc_hd__fill_1
Xclkload17 clknet_leaf_15_clk VGND VGND VPWR VPWR clkload17/Y sky130_fd_sc_hd__clkinv_4
X_3020_ imem.address\[21\] _1529_ VGND VGND VPWR VPWR _1544_ sky130_fd_sc_hd__nor2_1
XFILLER_0_58_243 VGND VGND VPWR VPWR sky130_fd_sc_hd__decap_8
Xclkbuf_leaf_0_clk clknet_1_0__leaf_clk VGND VGND VPWR VPWR clknet_leaf_0_clk sky130_fd_sc_hd__clkbuf_8
XFILLER_0_25_42 VGND VGND VPWR VPWR sky130_fd_sc_hd__fill_1
XFILLER_0_46_416 VGND VGND VPWR VPWR sky130_fd_sc_hd__decap_4
X_2804_ _1304_ _1107_ _1200_ VGND VGND VPWR VPWR _1388_ sky130_fd_sc_hd__and3b_1
XFILLER_0_14_313 VGND VGND VPWR VPWR sky130_fd_sc_hd__fill_1
XTAP_TAPCELL_ROW_14_271 VGND VPWR sky130_fd_sc_hd__tapvpwrvgnd_1
X_2666_ _1256_ _1258_ _1002_ VGND VGND VPWR VPWR _1259_ sky130_fd_sc_hd__mux2_1
X_2735_ _1324_ _0919_ _0875_ VGND VGND VPWR VPWR _1325_ sky130_fd_sc_hd__a21oi_2
XFILLER_0_1_273 VGND VGND VPWR VPWR sky130_fd_sc_hd__decap_6
XTAP_TAPCELL_ROW_6_206 VGND VPWR sky130_fd_sc_hd__tapvpwrvgnd_1
XFILLER_0_14_379 VGND VGND VPWR VPWR sky130_fd_sc_hd__decap_3
X_2597_ reg_file.registers\[11\]\[25\] _0927_ _0928_ reg_file.registers\[10\]\[25\]
+ VGND VGND VPWR VPWR _1193_ sky130_fd_sc_hd__a22o_1
XFILLER_0_66_93 VGND VGND VPWR VPWR sky130_fd_sc_hd__fill_2
X_3149_ _1644_ _1634_ _1615_ _1609_ VGND VGND VPWR VPWR _1646_ sky130_fd_sc_hd__and4bb_1
X_3218_ display.counter\[19\] _1686_ VGND VGND VPWR VPWR _1689_ sky130_fd_sc_hd__or2_1
XTAP_TAPCELL_ROW_65_672 VGND VPWR sky130_fd_sc_hd__tapvpwrvgnd_1
XFILLER_0_37_449 VGND VGND VPWR VPWR sky130_fd_sc_hd__fill_2
XFILLER_0_64_257 VGND VGND VPWR VPWR sky130_fd_sc_hd__fill_1
XFILLER_0_52_419 VGND VGND VPWR VPWR sky130_fd_sc_hd__fill_1
XFILLER_0_17_173 VGND VGND VPWR VPWR sky130_fd_sc_hd__fill_1
XFILLER_0_1_3 VPWR VGND VPWR VGND sky130_ef_sc_hd__decap_12
XFILLER_0_62_29 VPWR VGND VPWR VGND sky130_ef_sc_hd__decap_12
XFILLER_0_55_279 VGND VGND VPWR VPWR sky130_fd_sc_hd__fill_1
X_2451_ _1048_ _0762_ _0731_ VGND VGND VPWR VPWR _1049_ sky130_fd_sc_hd__mux2_1
X_2520_ reg_file.registers\[11\]\[17\] _1071_ _1073_ reg_file.registers\[10\]\[17\]
+ VGND VGND VPWR VPWR _1117_ sky130_fd_sc_hd__a22o_1
XFILLER_0_23_187 VPWR VGND VPWR VGND sky130_ef_sc_hd__decap_12
XFILLER_0_23_154 VGND VGND VPWR VPWR sky130_fd_sc_hd__fill_1
XFILLER_0_11_55 VGND VGND VPWR VPWR sky130_fd_sc_hd__fill_1
XTAP_TAPCELL_ROW_11_241 VGND VPWR sky130_fd_sc_hd__tapvpwrvgnd_1
X_3003_ imem.address\[31\] _1536_ VGND VGND VPWR VPWR _0245_ sky130_fd_sc_hd__xnor2_1
X_2382_ reg_file.registers\[2\]\[31\] _0559_ VGND VGND VPWR VPWR _0980_ sky130_fd_sc_hd__and2_1
XTAP_TAPCELL_ROW_62_653 VGND VPWR sky130_fd_sc_hd__tapvpwrvgnd_1
XFILLER_0_19_405 VGND VGND VPWR VPWR sky130_fd_sc_hd__decap_6
XFILLER_0_19_449 VGND VGND VPWR VPWR sky130_fd_sc_hd__fill_2
XFILLER_0_61_216 VGND VGND VPWR VPWR sky130_fd_sc_hd__decap_8
XFILLER_0_6_321 VPWR VGND VPWR VGND sky130_ef_sc_hd__decap_12
X_2718_ _1309_ VGND VGND VPWR VPWR _0303_ sky130_fd_sc_hd__clkbuf_1
X_2649_ _1241_ _1242_ _0594_ VGND VGND VPWR VPWR _1243_ sky130_fd_sc_hd__mux2_1
XFILLER_0_37_279 VGND VGND VPWR VPWR sky130_fd_sc_hd__fill_1
XFILLER_0_25_408 VGND VGND VPWR VPWR sky130_fd_sc_hd__decap_3
XTAP_TAPCELL_ROW_25_355 VGND VPWR sky130_fd_sc_hd__tapvpwrvgnd_1
XFILLER_0_9_181 VPWR VGND VPWR VGND sky130_ef_sc_hd__decap_12
XFILLER_0_20_135 VGND VGND VPWR VPWR sky130_fd_sc_hd__decap_4
XFILLER_0_68_371 VPWR VGND VPWR VGND sky130_ef_sc_hd__decap_12
XFILLER_0_28_202 VPWR VGND VPWR VGND sky130_ef_sc_hd__decap_12
X_1951_ _0551_ VGND VGND VPWR VPWR _0312_ sky130_fd_sc_hd__clkbuf_1
X_3552_ clknet_leaf_10_clk _0314_ _0125_ VGND VGND VPWR VPWR reg_file.registers\[10\]\[4\]
+ sky130_fd_sc_hd__dfrtp_2
X_1882_ reg_file.registers\[5\]\[2\] _0482_ VGND VGND VPWR VPWR _0515_ sky130_fd_sc_hd__and2_1
X_3621_ clknet_leaf_4_clk _0383_ _0194_ VGND VGND VPWR VPWR reg_file.registers\[2\]\[10\]
+ sky130_fd_sc_hd__dfrtp_1
XFILLER_0_43_249 VPWR VGND VPWR VGND sky130_ef_sc_hd__decap_12
XFILLER_0_28_246 VGND VGND VPWR VPWR sky130_fd_sc_hd__decap_6
XFILLER_0_3_335 VGND VGND VPWR VPWR sky130_fd_sc_hd__fill_1
X_2503_ reg_file.registers\[11\]\[11\] _1070_ _1072_ reg_file.registers\[10\]\[11\]
+ VGND VGND VPWR VPWR _1100_ sky130_fd_sc_hd__a22oi_1
X_2434_ _0680_ _0752_ VGND VGND VPWR VPWR _1032_ sky130_fd_sc_hd__nand2_1
XFILLER_0_11_113 VPWR VGND VPWR VGND sky130_ef_sc_hd__decap_12
X_3483_ clknet_leaf_16_clk _0006_ VGND VGND VPWR VPWR net16 sky130_fd_sc_hd__dfxtp_1
X_2365_ _0689_ _0699_ VGND VGND VPWR VPWR _0963_ sky130_fd_sc_hd__and2_1
XTAP_TAPCELL_ROW_39_469 VGND VPWR sky130_fd_sc_hd__tapvpwrvgnd_1
X_2296_ _0893_ VGND VGND VPWR VPWR _0894_ sky130_fd_sc_hd__inv_2
XFILLER_0_2_53 VPWR VGND VPWR VGND sky130_ef_sc_hd__decap_12
XFILLER_0_2_97 VPWR VGND VPWR VGND sky130_ef_sc_hd__decap_12
XFILLER_0_19_202 VGND VGND VPWR VPWR sky130_fd_sc_hd__fill_2
XFILLER_0_19_279 VGND VGND VPWR VPWR sky130_fd_sc_hd__fill_1
XFILLER_0_30_433 VGND VGND VPWR VPWR sky130_fd_sc_hd__fill_1
XFILLER_0_30_400 VGND VGND VPWR VPWR sky130_fd_sc_hd__decap_8
XFILLER_0_27_290 VGND VGND VPWR VPWR sky130_fd_sc_hd__decap_8
XFILLER_0_6_195 VGND VGND VPWR VPWR sky130_fd_sc_hd__fill_1
XFILLER_0_33_293 VPWR VGND VPWR VGND sky130_ef_sc_hd__decap_12
XFILLER_0_0_305 VGND VGND VPWR VPWR sky130_fd_sc_hd__decap_3
XFILLER_0_0_349 VPWR VGND VPWR VGND sky130_ef_sc_hd__decap_12
XFILLER_0_21_444 VGND VGND VPWR VPWR sky130_fd_sc_hd__fill_1
X_2150_ _0744_ _0747_ VGND VGND VPWR VPWR _0748_ sky130_fd_sc_hd__nand2_1
X_2081_ _0571_ _0581_ _0678_ VGND VGND VPWR VPWR _0679_ sky130_fd_sc_hd__nand3b_4
X_2983_ reg_file.registers\[15\]\[0\] _1514_ VGND VGND VPWR VPWR _1518_ sky130_fd_sc_hd__or2_1
X_1934_ reg_file.registers\[10\]\[10\] _0539_ VGND VGND VPWR VPWR _0543_ sky130_fd_sc_hd__and2_1
XFILLER_0_71_377 VPWR VGND VPWR VGND sky130_ef_sc_hd__decap_12
XFILLER_0_71_333 VGND VGND VPWR VPWR sky130_fd_sc_hd__decap_3
X_1796_ imem.address\[2\] VGND VGND VPWR VPWR _0458_ sky130_fd_sc_hd__buf_2
X_1865_ _0506_ VGND VGND VPWR VPWR _0353_ sky130_fd_sc_hd__clkbuf_1
X_3535_ clknet_leaf_14_clk _0297_ _0108_ VGND VGND VPWR VPWR reg_file.registers\[11\]\[19\]
+ sky130_fd_sc_hd__dfrtp_1
X_3604_ clknet_leaf_21_clk _0366_ _0177_ VGND VGND VPWR VPWR reg_file.registers\[5\]\[24\]
+ sky130_fd_sc_hd__dfrtp_1
X_3466_ clknet_leaf_6_clk _0235_ _0046_ VGND VGND VPWR VPWR imem.address\[21\] sky130_fd_sc_hd__dfrtp_1
XFILLER_0_58_72 VGND VGND VPWR VPWR sky130_fd_sc_hd__fill_1
XFILLER_0_42_3 VGND VGND VPWR VPWR sky130_fd_sc_hd__decap_3
X_2417_ _1006_ _1012_ _1014_ VGND VGND VPWR VPWR _1015_ sky130_fd_sc_hd__mux2_1
X_3397_ _1713_ VGND VGND VPWR VPWR _0179_ sky130_fd_sc_hd__inv_2
X_2348_ reg_file.registers\[10\]\[27\] _0785_ _0786_ VGND VGND VPWR VPWR _0946_ sky130_fd_sc_hd__and3_1
XTAP_TAPCELL_ROW_70_718 VGND VPWR sky130_fd_sc_hd__tapvpwrvgnd_1
X_2279_ _0575_ _0664_ _0580_ VGND VGND VPWR VPWR _0877_ sky130_fd_sc_hd__a21o_1
XFILLER_0_62_355 VGND VGND VPWR VPWR sky130_fd_sc_hd__decap_8
XFILLER_0_62_399 VGND VGND VPWR VPWR sky130_fd_sc_hd__fill_2
XFILLER_0_70_29 VGND VGND VPWR VPWR sky130_fd_sc_hd__decap_6
XFILLER_0_57_127 VPWR VGND VPWR VGND sky130_ef_sc_hd__decap_12
XFILLER_0_65_193 VGND VGND VPWR VPWR sky130_fd_sc_hd__decap_3
XFILLER_0_53_388 VGND VGND VPWR VPWR sky130_fd_sc_hd__fill_1
XFILLER_0_53_333 VGND VGND VPWR VPWR sky130_fd_sc_hd__decap_3
XFILLER_0_53_322 VGND VGND VPWR VPWR sky130_fd_sc_hd__decap_8
XTAP_TAPCELL_ROW_41_486 VGND VPWR sky130_fd_sc_hd__tapvpwrvgnd_1
X_3251_ _1695_ VGND VGND VPWR VPWR _0051_ sky130_fd_sc_hd__inv_2
X_2202_ _0573_ _0799_ _0578_ VGND VGND VPWR VPWR _0800_ sky130_fd_sc_hd__a21o_1
XFILLER_0_28_75 VGND VGND VPWR VPWR sky130_fd_sc_hd__decap_3
XFILLER_0_0_113 VPWR VGND VPWR VGND sky130_ef_sc_hd__decap_12
X_3182_ display.counter\[4\] _1666_ VGND VGND VPWR VPWR _0021_ sky130_fd_sc_hd__xor2_1
X_3320_ _1704_ VGND VGND VPWR VPWR _1705_ sky130_fd_sc_hd__buf_4
X_2133_ _0713_ net47 _0730_ VGND VGND VPWR VPWR _0731_ sky130_fd_sc_hd__a21oi_4
XFILLER_0_44_63 VGND VGND VPWR VPWR sky130_fd_sc_hd__decap_4
X_2064_ _0661_ _0648_ _0642_ VGND VGND VPWR VPWR _0662_ sky130_fd_sc_hd__or3_4
XFILLER_0_71_141 VPWR VGND VPWR VGND sky130_ef_sc_hd__decap_12
X_2897_ _1462_ _1065_ _1466_ VGND VGND VPWR VPWR _1467_ sky130_fd_sc_hd__and3_1
XFILLER_0_60_62 VPWR VGND VPWR VGND sky130_ef_sc_hd__decap_12
X_2966_ reg_file.registers\[15\]\[8\] _1483_ VGND VGND VPWR VPWR _1509_ sky130_fd_sc_hd__and2_1
XFILLER_0_44_333 VGND VGND VPWR VPWR sky130_fd_sc_hd__decap_3
X_1917_ reg_file.registers\[10\]\[18\] _0528_ VGND VGND VPWR VPWR _0534_ sky130_fd_sc_hd__and2_1
X_3518_ clknet_leaf_11_clk _0280_ _0091_ VGND VGND VPWR VPWR reg_file.registers\[11\]\[2\]
+ sky130_fd_sc_hd__dfrtp_1
X_1779_ reg_file.registers\[2\]\[3\] VGND VGND VPWR VPWR _0444_ sky130_fd_sc_hd__clkbuf_1
X_1848_ _0497_ VGND VGND VPWR VPWR _0361_ sky130_fd_sc_hd__clkbuf_1
XFILLER_0_8_41 VPWR VGND VPWR VGND sky130_ef_sc_hd__decap_12
XFILLER_0_8_85 VPWR VGND VPWR VGND sky130_ef_sc_hd__decap_12
X_3449_ clknet_leaf_9_clk _0218_ _0029_ VGND VGND VPWR VPWR imem.address\[4\] sky130_fd_sc_hd__dfrtp_1
XTAP_TAPCELL_ROW_4_189 VGND VPWR sky130_fd_sc_hd__tapvpwrvgnd_1
XFILLER_0_67_447 VGND VGND VPWR VPWR sky130_fd_sc_hd__fill_1
Xclone10 _0448_ _0454_ net27 VGND VGND VPWR VPWR net26 sky130_fd_sc_hd__nor3_2
XFILLER_0_62_185 VGND VGND VPWR VPWR sky130_fd_sc_hd__fill_2
XFILLER_0_62_141 VGND VGND VPWR VPWR sky130_fd_sc_hd__decap_4
XFILLER_0_50_303 VGND VGND VPWR VPWR sky130_fd_sc_hd__decap_4
XTAP_TAPCELL_ROW_46_523 VGND VPWR sky130_fd_sc_hd__tapvpwrvgnd_1
XFILLER_0_58_436 VPWR VGND VPWR VGND sky130_ef_sc_hd__decap_12
X_2820_ _0849_ _0850_ VGND VGND VPWR VPWR _1402_ sky130_fd_sc_hd__or2_1
X_2751_ _0715_ _1139_ VGND VGND VPWR VPWR _1340_ sky130_fd_sc_hd__nand2_1
XFILLER_0_5_205 VPWR VGND VPWR VGND sky130_ef_sc_hd__decap_12
XFILLER_0_41_369 VGND VGND VPWR VPWR sky130_fd_sc_hd__fill_1
XFILLER_0_39_41 VPWR VGND VPWR VGND sky130_ef_sc_hd__decap_12
XFILLER_0_30_43 VGND VGND VPWR VPWR sky130_fd_sc_hd__fill_2
X_2682_ _1273_ _1274_ _1004_ VGND VGND VPWR VPWR _1275_ sky130_fd_sc_hd__mux2_1
XFILLER_0_5_249 VPWR VGND VPWR VGND sky130_ef_sc_hd__decap_12
X_3234_ _1693_ VGND VGND VPWR VPWR _0036_ sky130_fd_sc_hd__inv_2
X_3303_ _1702_ VGND VGND VPWR VPWR _0096_ sky130_fd_sc_hd__inv_2
XFILLER_0_55_40 VPWR VGND VPWR VGND sky130_ef_sc_hd__decap_12
X_3165_ _1648_ _1649_ _1645_ VGND VGND VPWR VPWR _1659_ sky130_fd_sc_hd__nor3_1
XFILLER_0_71_50 VGND VGND VPWR VPWR sky130_fd_sc_hd__decap_6
X_2116_ net26 _0469_ _0560_ VGND VGND VPWR VPWR _0714_ sky130_fd_sc_hd__and3_1
XFILLER_0_55_73 VPWR VGND VPWR VGND sky130_ef_sc_hd__decap_12
X_2047_ reg_file.registers\[2\]\[15\] _0558_ VGND VGND VPWR VPWR _0645_ sky130_fd_sc_hd__and2_1
X_3096_ _1194_ VGND VGND VPWR VPWR _1596_ sky130_fd_sc_hd__inv_2
XFILLER_0_44_163 VGND VGND VPWR VPWR sky130_fd_sc_hd__fill_1
XFILLER_0_44_141 VGND VGND VPWR VPWR sky130_fd_sc_hd__decap_4
X_2949_ _1500_ VGND VGND VPWR VPWR _0263_ sky130_fd_sc_hd__clkbuf_1
XFILLER_0_29_193 VGND VGND VPWR VPWR sky130_fd_sc_hd__decap_4
XTAP_TAPCELL_ROW_17_291 VGND VPWR sky130_fd_sc_hd__tapvpwrvgnd_1
XFILLER_0_17_333 VGND VGND VPWR VPWR sky130_fd_sc_hd__decap_3
XTAP_TAPCELL_ROW_9_226 VGND VPWR sky130_fd_sc_hd__tapvpwrvgnd_1
XFILLER_0_35_141 VGND VGND VPWR VPWR sky130_fd_sc_hd__decap_4
XFILLER_0_35_130 VGND VGND VPWR VPWR sky130_fd_sc_hd__fill_1
XFILLER_0_27_119 VGND VGND VPWR VPWR sky130_fd_sc_hd__decap_6
XFILLER_0_35_196 VPWR VGND VPWR VGND sky130_ef_sc_hd__decap_12
XFILLER_0_35_185 VGND VGND VPWR VPWR sky130_fd_sc_hd__decap_6
Xclkload18 clknet_leaf_16_clk VGND VGND VPWR VPWR clkload18/Y sky130_fd_sc_hd__bufinv_16
XFILLER_0_58_222 VGND VGND VPWR VPWR sky130_fd_sc_hd__decap_3
XFILLER_0_25_65 VGND VGND VPWR VPWR sky130_fd_sc_hd__decap_8
XFILLER_0_18_108 VGND VGND VPWR VPWR sky130_fd_sc_hd__fill_1
XFILLER_0_54_450 VGND VGND VPWR VPWR sky130_fd_sc_hd__fill_1
XFILLER_0_41_20 VGND VGND VPWR VPWR sky130_fd_sc_hd__decap_3
X_2803_ _0905_ _1321_ _1385_ VGND VGND VPWR VPWR _1387_ sky130_fd_sc_hd__nand3_1
X_2734_ _1322_ _1323_ _0896_ VGND VGND VPWR VPWR _1324_ sky130_fd_sc_hd__o21bai_1
XFILLER_0_14_325 VGND VGND VPWR VPWR sky130_fd_sc_hd__fill_2
X_2665_ _0707_ _1257_ _0731_ VGND VGND VPWR VPWR _1258_ sky130_fd_sc_hd__mux2_1
XTAP_TAPCELL_ROW_6_207 VGND VPWR sky130_fd_sc_hd__tapvpwrvgnd_1
X_2596_ reg_file.registers\[11\]\[24\] _0927_ _0928_ reg_file.registers\[10\]\[24\]
+ VGND VGND VPWR VPWR _1192_ sky130_fd_sc_hd__a22o_1
XFILLER_0_66_83 VGND VGND VPWR VPWR sky130_fd_sc_hd__fill_1
X_3217_ display.counter\[19\] _1686_ VGND VGND VPWR VPWR _1688_ sky130_fd_sc_hd__nand2_2
X_3148_ _1634_ _1644_ VGND VGND VPWR VPWR _1645_ sky130_fd_sc_hd__and2b_1
XTAP_TAPCELL_ROW_65_673 VGND VPWR sky130_fd_sc_hd__tapvpwrvgnd_1
XFILLER_0_64_225 VGND VGND VPWR VPWR sky130_fd_sc_hd__fill_1
X_3079_ _1578_ display.digit_sel\[0\] _1557_ VGND VGND VPWR VPWR _1582_ sky130_fd_sc_hd__or3b_1
XFILLER_0_32_155 VGND VGND VPWR VPWR sky130_fd_sc_hd__decap_8
XFILLER_0_55_225 VPWR VGND VPWR VGND sky130_ef_sc_hd__decap_12
XTAP_TAPCELL_ROW_11_242 VGND VPWR sky130_fd_sc_hd__tapvpwrvgnd_1
X_2450_ _0755_ VGND VGND VPWR VPWR _1048_ sky130_fd_sc_hd__inv_2
XFILLER_0_23_199 VPWR VGND VPWR VGND sky130_ef_sc_hd__decap_12
X_2381_ reg_file.registers\[11\]\[31\] _0694_ _0978_ VGND VGND VPWR VPWR _0979_ sky130_fd_sc_hd__a21o_1
X_3002_ imem.address\[30\] _1535_ VGND VGND VPWR VPWR _1536_ sky130_fd_sc_hd__nand2_1
XTAP_TAPCELL_ROW_62_654 VGND VPWR sky130_fd_sc_hd__tapvpwrvgnd_1
XFILLER_0_61_206 VGND VGND VPWR VPWR sky130_fd_sc_hd__decap_4
XFILLER_0_6_333 VGND VGND VPWR VPWR sky130_fd_sc_hd__decap_3
XFILLER_0_6_355 VGND VGND VPWR VPWR sky130_fd_sc_hd__fill_2
X_2717_ _1308_ reg_file.registers\[11\]\[25\] _1207_ VGND VGND VPWR VPWR _1309_ sky130_fd_sc_hd__mux2_1
X_2579_ reg_file.registers\[11\]\[5\] _0790_ _0791_ reg_file.registers\[10\]\[5\]
+ net57 VGND VGND VPWR VPWR _1175_ sky130_fd_sc_hd__a221o_1
X_2648_ _0742_ _1053_ VGND VGND VPWR VPWR _1242_ sky130_fd_sc_hd__nand2_1
XFILLER_0_37_203 VPWR VGND VPWR VGND sky130_ef_sc_hd__decap_12
XTAP_TAPCELL_ROW_25_356 VGND VPWR sky130_fd_sc_hd__tapvpwrvgnd_1
XFILLER_0_9_193 VPWR VGND VPWR VGND sky130_ef_sc_hd__decap_12
XFILLER_0_60_283 VGND VGND VPWR VPWR sky130_fd_sc_hd__decap_3
XFILLER_0_68_383 VPWR VGND VPWR VGND sky130_ef_sc_hd__decap_12
X_1950_ reg_file.registers\[10\]\[2\] _0518_ VGND VGND VPWR VPWR _0551_ sky130_fd_sc_hd__and2_1
XFILLER_0_28_214 VGND VGND VPWR VPWR sky130_fd_sc_hd__decap_3
X_3551_ clknet_leaf_10_clk _0313_ _0124_ VGND VGND VPWR VPWR reg_file.registers\[10\]\[3\]
+ sky130_fd_sc_hd__dfrtp_4
X_1881_ _0514_ VGND VGND VPWR VPWR _0345_ sky130_fd_sc_hd__clkbuf_1
X_2502_ reg_file.registers\[11\]\[12\] _1070_ _1072_ reg_file.registers\[10\]\[12\]
+ VGND VGND VPWR VPWR _1099_ sky130_fd_sc_hd__a22oi_1
X_3620_ clknet_leaf_3_clk _0382_ _0193_ VGND VGND VPWR VPWR reg_file.registers\[2\]\[9\]
+ sky130_fd_sc_hd__dfrtp_1
XFILLER_0_11_125 VPWR VGND VPWR VGND sky130_ef_sc_hd__decap_12
XFILLER_0_11_169 VPWR VGND VPWR VGND sky130_ef_sc_hd__decap_12
X_3482_ clknet_leaf_16_clk _0005_ VGND VGND VPWR VPWR net15 sky130_fd_sc_hd__dfxtp_1
X_2364_ _0701_ _0702_ _0961_ _0703_ VGND VGND VPWR VPWR _0962_ sky130_fd_sc_hd__o22ai_2
X_2433_ _1027_ _1030_ _1004_ VGND VGND VPWR VPWR _1031_ sky130_fd_sc_hd__mux2_1
X_2295_ reg_file.registers\[11\]\[18\] _0692_ _0697_ reg_file.registers\[10\]\[18\]
+ VGND VGND VPWR VPWR _0893_ sky130_fd_sc_hd__a22o_1
XFILLER_0_2_65 VPWR VGND VPWR VGND sky130_ef_sc_hd__decap_12
XFILLER_0_59_372 VGND VGND VPWR VPWR sky130_fd_sc_hd__fill_1
XFILLER_0_34_228 VGND VGND VPWR VPWR sky130_fd_sc_hd__decap_3
XFILLER_0_6_141 VPWR VGND VPWR VGND sky130_ef_sc_hd__decap_12
XTAP_TAPCELL_ROW_30_392 VGND VPWR sky130_fd_sc_hd__tapvpwrvgnd_1
XFILLER_0_69_125 VGND VGND VPWR VPWR sky130_fd_sc_hd__fill_2
XFILLER_0_65_320 VGND VGND VPWR VPWR sky130_fd_sc_hd__fill_1
XPHY_EDGE_ROW_6_Left_78 VGND VGND VPWR VPWR sky130_fd_sc_hd__decap_3
XFILLER_0_68_29 VPWR VGND VPWR VGND sky130_ef_sc_hd__decap_12
XFILLER_0_21_423 VGND VGND VPWR VPWR sky130_fd_sc_hd__decap_3
X_2080_ _0584_ _0587_ _0677_ VGND VGND VPWR VPWR _0678_ sky130_fd_sc_hd__and3b_2
XFILLER_0_56_386 VGND VGND VPWR VPWR sky130_fd_sc_hd__fill_1
X_2982_ _1517_ VGND VGND VPWR VPWR _0247_ sky130_fd_sc_hd__clkbuf_1
X_1933_ _0542_ VGND VGND VPWR VPWR _0321_ sky130_fd_sc_hd__clkbuf_1
XFILLER_0_33_76 VGND VGND VPWR VPWR sky130_fd_sc_hd__fill_2
XFILLER_0_16_217 VGND VGND VPWR VPWR sky130_fd_sc_hd__decap_3
XFILLER_0_71_389 VGND VGND VPWR VPWR sky130_fd_sc_hd__decap_3
X_3465_ clknet_leaf_6_clk _0234_ _0045_ VGND VGND VPWR VPWR imem.address\[20\] sky130_fd_sc_hd__dfrtp_1
X_1795_ imem.address\[3\] VGND VGND VPWR VPWR _0457_ sky130_fd_sc_hd__buf_2
X_1864_ reg_file.registers\[5\]\[11\] _0504_ VGND VGND VPWR VPWR _0506_ sky130_fd_sc_hd__and2_1
X_3534_ clknet_leaf_14_clk _0296_ _0107_ VGND VGND VPWR VPWR reg_file.registers\[11\]\[18\]
+ sky130_fd_sc_hd__dfrtp_1
XFILLER_0_24_294 VPWR VGND VPWR VGND sky130_ef_sc_hd__decap_12
X_3603_ clknet_leaf_21_clk _0365_ _0176_ VGND VGND VPWR VPWR reg_file.registers\[5\]\[23\]
+ sky130_fd_sc_hd__dfrtp_1
XFILLER_0_3_111 VGND VGND VPWR VPWR sky130_fd_sc_hd__fill_1
X_2416_ _1013_ VGND VGND VPWR VPWR _1014_ sky130_fd_sc_hd__clkbuf_4
XFILLER_0_35_3 VGND VGND VPWR VPWR sky130_fd_sc_hd__decap_8
X_2278_ _0875_ VGND VGND VPWR VPWR _0876_ sky130_fd_sc_hd__inv_2
X_3396_ _1713_ VGND VGND VPWR VPWR _0178_ sky130_fd_sc_hd__inv_2
X_2347_ _0679_ _0943_ _0944_ VGND VGND VPWR VPWR _0945_ sky130_fd_sc_hd__and3_1
XTAP_TAPCELL_ROW_70_719 VGND VPWR sky130_fd_sc_hd__tapvpwrvgnd_1
XFILLER_0_47_342 VGND VGND VPWR VPWR sky130_fd_sc_hd__decap_8
XFILLER_0_30_275 VPWR VGND VPWR VGND sky130_ef_sc_hd__decap_12
XFILLER_0_30_231 VGND VGND VPWR VPWR sky130_fd_sc_hd__decap_3
XFILLER_0_57_139 VGND VGND VPWR VPWR sky130_fd_sc_hd__decap_4
XFILLER_0_38_342 VGND VGND VPWR VPWR sky130_fd_sc_hd__decap_8
XTAP_TAPCELL_ROW_41_487 VGND VPWR sky130_fd_sc_hd__tapvpwrvgnd_1
XFILLER_0_0_125 VPWR VGND VPWR VGND sky130_ef_sc_hd__decap_12
X_2132_ _0572_ _0729_ VGND VGND VPWR VPWR _0730_ sky130_fd_sc_hd__and2_1
X_3250_ _1695_ VGND VGND VPWR VPWR _0050_ sky130_fd_sc_hd__inv_2
X_2201_ reg_file.registers\[15\]\[12\] _0588_ _0590_ reg_file.registers\[5\]\[12\]
+ _0636_ VGND VGND VPWR VPWR _0799_ sky130_fd_sc_hd__a221o_1
XFILLER_0_0_169 VPWR VGND VPWR VGND sky130_ef_sc_hd__decap_12
X_3181_ _1666_ _1667_ VGND VGND VPWR VPWR _0020_ sky130_fd_sc_hd__nor2_1
X_2063_ _0574_ _0650_ _0660_ VGND VGND VPWR VPWR _0661_ sky130_fd_sc_hd__a21o_1
XFILLER_0_71_153 VPWR VGND VPWR VGND sky130_ef_sc_hd__decap_12
X_2896_ _0740_ _0746_ VGND VGND VPWR VPWR _1466_ sky130_fd_sc_hd__or2_1
XFILLER_0_60_85 VGND VGND VPWR VPWR sky130_fd_sc_hd__decap_8
XFILLER_0_60_74 VGND VGND VPWR VPWR sky130_fd_sc_hd__decap_3
X_2965_ _1508_ VGND VGND VPWR VPWR _0255_ sky130_fd_sc_hd__clkbuf_1
X_1916_ _0533_ VGND VGND VPWR VPWR _0329_ sky130_fd_sc_hd__clkbuf_1
X_1847_ reg_file.registers\[5\]\[19\] _0493_ VGND VGND VPWR VPWR _0497_ sky130_fd_sc_hd__and2_1
XTAP_TAPCELL_ROW_32_410 VGND VPWR sky130_fd_sc_hd__tapvpwrvgnd_1
XFILLER_0_71_197 VPWR VGND VPWR VGND sky130_ef_sc_hd__decap_12
XFILLER_0_69_94 VGND VGND VPWR VPWR sky130_fd_sc_hd__fill_2
X_3517_ clknet_leaf_10_clk _0279_ _0090_ VGND VGND VPWR VPWR reg_file.registers\[11\]\[1\]
+ sky130_fd_sc_hd__dfrtp_1
X_3448_ clknet_leaf_9_clk _0217_ _0028_ VGND VGND VPWR VPWR imem.address\[3\] sky130_fd_sc_hd__dfrtp_1
X_1778_ _0443_ VGND VGND VPWR VPWR _0377_ sky130_fd_sc_hd__clkbuf_1
XFILLER_0_8_53 VPWR VGND VPWR VGND sky130_ef_sc_hd__decap_12
XFILLER_0_8_97 VPWR VGND VPWR VGND sky130_ef_sc_hd__decap_12
XFILLER_0_12_253 VPWR VGND VPWR VGND sky130_ef_sc_hd__decap_12
X_3379_ _1710_ VGND VGND VPWR VPWR _1712_ sky130_fd_sc_hd__buf_4
XFILLER_0_47_161 VGND VGND VPWR VPWR sky130_fd_sc_hd__decap_6
XFILLER_0_39_128 VGND VGND VPWR VPWR sky130_fd_sc_hd__fill_2
XFILLER_0_35_334 VGND VGND VPWR VPWR sky130_fd_sc_hd__fill_2
XFILLER_0_58_448 VGND VGND VPWR VPWR sky130_fd_sc_hd__decap_3
XTAP_TAPCELL_ROW_46_524 VGND VPWR sky130_fd_sc_hd__tapvpwrvgnd_1
XPHY_EDGE_ROW_9_Left_81 VGND VGND VPWR VPWR sky130_fd_sc_hd__decap_3
XTAP_TAPCELL_ROW_54_590 VGND VPWR sky130_fd_sc_hd__tapvpwrvgnd_1
X_2750_ _1107_ _1137_ VGND VGND VPWR VPWR _1339_ sky130_fd_sc_hd__nand2_1
X_2681_ _1008_ _0874_ _0996_ VGND VGND VPWR VPWR _1274_ sky130_fd_sc_hd__mux2_1
XFILLER_0_5_217 VGND VGND VPWR VPWR sky130_fd_sc_hd__decap_6
X_3302_ _1702_ VGND VGND VPWR VPWR _0095_ sky130_fd_sc_hd__inv_2
XFILLER_0_41_337 VGND VGND VPWR VPWR sky130_fd_sc_hd__fill_2
XFILLER_0_39_53 VGND VGND VPWR VPWR sky130_fd_sc_hd__decap_3
X_3233_ _1693_ VGND VGND VPWR VPWR _0035_ sky130_fd_sc_hd__inv_2
X_2115_ _0457_ _0458_ VGND VGND VPWR VPWR _0713_ sky130_fd_sc_hd__or2_1
XFILLER_0_55_85 VGND VGND VPWR VPWR sky130_fd_sc_hd__fill_1
XFILLER_0_55_52 VGND VGND VPWR VPWR sky130_fd_sc_hd__decap_4
XFILLER_0_55_30 VGND VGND VPWR VPWR sky130_fd_sc_hd__fill_2
X_3095_ _1153_ _0944_ _1594_ VGND VGND VPWR VPWR _1595_ sky130_fd_sc_hd__a21bo_1
X_3164_ _1649_ _1651_ _1608_ VGND VGND VPWR VPWR _1658_ sky130_fd_sc_hd__a21oi_1
XFILLER_0_71_95 VPWR VGND VPWR VGND sky130_ef_sc_hd__decap_12
X_2046_ reg_file.registers\[15\]\[14\] _0588_ _0590_ reg_file.registers\[5\]\[14\]
+ _0643_ VGND VGND VPWR VPWR _0644_ sky130_fd_sc_hd__a221o_1
XTAP_TAPCELL_ROW_17_292 VGND VPWR sky130_fd_sc_hd__tapvpwrvgnd_1
X_2879_ _0712_ _0769_ VGND VGND VPWR VPWR _1452_ sky130_fd_sc_hd__and2b_1
X_2948_ reg_file.registers\[15\]\[17\] _1495_ VGND VGND VPWR VPWR _1500_ sky130_fd_sc_hd__and2_1
XFILLER_0_32_348 VGND VGND VPWR VPWR sky130_fd_sc_hd__decap_8
XTAP_TAPCELL_ROW_9_227 VGND VPWR sky130_fd_sc_hd__tapvpwrvgnd_1
XFILLER_0_67_267 VPWR VGND VPWR VGND sky130_ef_sc_hd__decap_12
XTAP_TAPCELL_ROW_51_560 VGND VPWR sky130_fd_sc_hd__tapvpwrvgnd_1
XFILLER_0_27_109 VGND VGND VPWR VPWR sky130_fd_sc_hd__decap_3
XFILLER_0_23_304 VGND VGND VPWR VPWR sky130_fd_sc_hd__decap_6
XFILLER_0_50_123 VGND VGND VPWR VPWR sky130_fd_sc_hd__fill_1
XFILLER_0_2_209 VPWR VGND VPWR VGND sky130_ef_sc_hd__decap_12
Xclkload19 clknet_leaf_18_clk VGND VGND VPWR VPWR clkload19/X sky130_fd_sc_hd__clkbuf_4
X_2664_ reg_file.registers\[11\]\[8\] _0693_ _0698_ reg_file.registers\[10\]\[8\]
+ VGND VGND VPWR VPWR _1257_ sky130_fd_sc_hd__a22o_1
XFILLER_0_41_167 VGND VGND VPWR VPWR sky130_fd_sc_hd__fill_1
XFILLER_0_41_145 VGND VGND VPWR VPWR sky130_fd_sc_hd__decap_8
X_2802_ _1321_ _1385_ _0905_ VGND VGND VPWR VPWR _1386_ sky130_fd_sc_hd__a21o_1
X_2733_ net43 _0911_ VGND VGND VPWR VPWR _1323_ sky130_fd_sc_hd__nor2_1
XFILLER_0_26_164 VPWR VGND VPWR VGND sky130_ef_sc_hd__decap_12
X_2595_ _1153_ _0864_ _1190_ VGND VGND VPWR VPWR _1191_ sky130_fd_sc_hd__a21oi_1
XTAP_TAPCELL_ROW_65_674 VGND VPWR sky130_fd_sc_hd__tapvpwrvgnd_1
XTAP_TAPCELL_ROW_57_608 VGND VPWR sky130_fd_sc_hd__tapvpwrvgnd_1
X_3078_ _1557_ _1580_ VGND VGND VPWR VPWR _1581_ sky130_fd_sc_hd__nor2_1
X_3147_ _1366_ _1579_ _1632_ _1233_ _1643_ VGND VGND VPWR VPWR _1644_ sky130_fd_sc_hd__a221o_1
X_3216_ _1686_ _1687_ VGND VGND VPWR VPWR _0016_ sky130_fd_sc_hd__nor2_1
XPHY_EDGE_ROW_59_Left_131 VGND VGND VPWR VPWR sky130_fd_sc_hd__decap_3
X_2029_ reg_file.registers\[5\]\[10\] _0563_ _0567_ reg_file.registers\[15\]\[10\]
+ _0626_ VGND VGND VPWR VPWR _0627_ sky130_fd_sc_hd__a221o_1
XFILLER_0_9_397 VGND VGND VPWR VPWR sky130_fd_sc_hd__decap_6
XFILLER_0_17_120 VGND VGND VPWR VPWR sky130_fd_sc_hd__fill_1
XFILLER_0_17_131 VPWR VGND VPWR VGND sky130_ef_sc_hd__decap_12
XPHY_EDGE_ROW_68_Left_140 VGND VGND VPWR VPWR sky130_fd_sc_hd__decap_3
XFILLER_0_60_421 VPWR VGND VPWR VGND sky130_ef_sc_hd__decap_12
XFILLER_0_32_123 VPWR VGND VPWR VGND sky130_ef_sc_hd__decap_12
XFILLER_0_17_186 VGND VGND VPWR VPWR sky130_fd_sc_hd__fill_1
XFILLER_0_20_307 VGND VGND VPWR VPWR sky130_fd_sc_hd__fill_1
XFILLER_0_28_418 VGND VGND VPWR VPWR sky130_fd_sc_hd__fill_2
XTAP_TAPCELL_ROW_28_376 VGND VPWR sky130_fd_sc_hd__tapvpwrvgnd_1
XFILLER_0_70_207 VGND VGND VPWR VPWR sky130_fd_sc_hd__fill_1
XFILLER_0_63_281 VPWR VGND VPWR VGND sky130_ef_sc_hd__decap_12
XFILLER_0_11_57 VPWR VGND VPWR VGND sky130_ef_sc_hd__decap_12
XTAP_TAPCELL_ROW_11_243 VGND VPWR sky130_fd_sc_hd__tapvpwrvgnd_1
XFILLER_0_23_167 VGND VGND VPWR VPWR sky130_fd_sc_hd__fill_1
XFILLER_0_11_318 VGND VGND VPWR VPWR sky130_fd_sc_hd__fill_2
X_2380_ reg_file.registers\[10\]\[31\] _0785_ _0786_ VGND VGND VPWR VPWR _0978_ sky130_fd_sc_hd__and3_1
X_3001_ imem.address\[29\] imem.address\[28\] _1534_ VGND VGND VPWR VPWR _1535_ sky130_fd_sc_hd__and3_1
XFILLER_0_36_32 VPWR VGND VPWR VGND sky130_ef_sc_hd__decap_12
XTAP_TAPCELL_ROW_19_310 VGND VPWR sky130_fd_sc_hd__tapvpwrvgnd_1
XTAP_TAPCELL_ROW_62_655 VGND VPWR sky130_fd_sc_hd__tapvpwrvgnd_1
XFILLER_0_6_301 VGND VGND VPWR VPWR sky130_fd_sc_hd__decap_6
XFILLER_0_65_3 VGND VGND VPWR VPWR sky130_fd_sc_hd__decap_3
X_2647_ _1043_ _1240_ _0597_ VGND VGND VPWR VPWR _1241_ sky130_fd_sc_hd__mux2_1
XFILLER_0_42_421 VGND VGND VPWR VPWR sky130_fd_sc_hd__fill_2
X_2716_ _1065_ _1294_ _1298_ _0608_ _1307_ VGND VGND VPWR VPWR _1308_ sky130_fd_sc_hd__a221o_1
XFILLER_0_14_123 VPWR VGND VPWR VGND sky130_ef_sc_hd__decap_12
X_2578_ reg_file.registers\[11\]\[4\] _0790_ _0791_ reg_file.registers\[10\]\[4\]
+ VGND VGND VPWR VPWR _1174_ sky130_fd_sc_hd__a22o_1
XFILLER_0_10_395 VPWR VGND VPWR VGND sky130_ef_sc_hd__decap_12
XFILLER_0_37_215 VGND VGND VPWR VPWR sky130_fd_sc_hd__decap_8
XTAP_TAPCELL_ROW_25_357 VGND VPWR sky130_fd_sc_hd__tapvpwrvgnd_1
XFILLER_0_45_281 VPWR VGND VPWR VGND sky130_ef_sc_hd__decap_12
XFILLER_0_33_421 VGND VGND VPWR VPWR sky130_fd_sc_hd__decap_6
XFILLER_0_9_161 VGND VGND VPWR VPWR sky130_fd_sc_hd__decap_6
XPHY_EDGE_ROW_14_Right_14 VGND VGND VPWR VPWR sky130_fd_sc_hd__decap_3
XPHY_EDGE_ROW_23_Right_23 VGND VGND VPWR VPWR sky130_fd_sc_hd__decap_3
XFILLER_0_68_395 VPWR VGND VPWR VGND sky130_ef_sc_hd__decap_12
X_1880_ reg_file.registers\[5\]\[3\] _0504_ VGND VGND VPWR VPWR _0514_ sky130_fd_sc_hd__and2_1
XPHY_EDGE_ROW_32_Right_32 VGND VGND VPWR VPWR sky130_fd_sc_hd__decap_3
XFILLER_0_28_259 VPWR VGND VPWR VGND sky130_ef_sc_hd__decap_12
XFILLER_0_22_67 VPWR VGND VPWR VGND sky130_ef_sc_hd__decap_12
X_3550_ clknet_leaf_10_clk _0312_ _0123_ VGND VGND VPWR VPWR reg_file.registers\[10\]\[2\]
+ sky130_fd_sc_hd__dfrtp_4
X_2501_ _1093_ _1097_ _1017_ VGND VGND VPWR VPWR _1098_ sky130_fd_sc_hd__mux2_1
XFILLER_0_36_281 VGND VGND VPWR VPWR sky130_fd_sc_hd__decap_3
XFILLER_0_24_432 VGND VGND VPWR VPWR sky130_fd_sc_hd__decap_3
XFILLER_0_3_337 VPWR VGND VPWR VGND sky130_ef_sc_hd__decap_12
XFILLER_0_11_137 VPWR VGND VPWR VGND sky130_ef_sc_hd__decap_12
X_3481_ clknet_leaf_16_clk _0004_ VGND VGND VPWR VPWR net14 sky130_fd_sc_hd__dfxtp_1
XFILLER_0_47_97 VGND VGND VPWR VPWR sky130_fd_sc_hd__fill_2
XFILLER_0_47_31 VGND VGND VPWR VPWR sky130_fd_sc_hd__fill_1
XPHY_EDGE_ROW_41_Right_41 VGND VGND VPWR VPWR sky130_fd_sc_hd__decap_3
X_2294_ _0884_ _0883_ VGND VGND VPWR VPWR _0892_ sky130_fd_sc_hd__xnor2_4
XPHY_EDGE_ROW_22_Left_94 VGND VGND VPWR VPWR sky130_fd_sc_hd__decap_3
X_2363_ _0955_ _0936_ _0960_ VGND VGND VPWR VPWR _0961_ sky130_fd_sc_hd__a21oi_2
X_2432_ _1028_ _1029_ _0996_ VGND VGND VPWR VPWR _1030_ sky130_fd_sc_hd__mux2_1
XPHY_EDGE_ROW_50_Right_50 VGND VGND VPWR VPWR sky130_fd_sc_hd__decap_3
XFILLER_0_2_77 VGND VGND VPWR VPWR sky130_fd_sc_hd__decap_6
XFILLER_0_6_153 VPWR VGND VPWR VGND sky130_ef_sc_hd__decap_12
XFILLER_0_19_259 VGND VGND VPWR VPWR sky130_fd_sc_hd__fill_1
XFILLER_0_42_262 VPWR VGND VPWR VGND sky130_ef_sc_hd__decap_12
XTAP_TAPCELL_ROW_30_393 VGND VPWR sky130_fd_sc_hd__tapvpwrvgnd_1
XFILLER_0_6_197 VPWR VGND VPWR VGND sky130_ef_sc_hd__decap_12
XFILLER_0_69_159 VGND VGND VPWR VPWR sky130_fd_sc_hd__fill_1
XFILLER_0_65_310 VGND VGND VPWR VPWR sky130_fd_sc_hd__fill_1
XTAP_TAPCELL_ROW_38_460 VGND VPWR sky130_fd_sc_hd__tapvpwrvgnd_1
XFILLER_0_25_229 VGND VGND VPWR VPWR sky130_fd_sc_hd__fill_1
XFILLER_0_17_67 VGND VGND VPWR VPWR sky130_fd_sc_hd__fill_2
X_2981_ reg_file.registers\[15\]\[1\] _1514_ VGND VGND VPWR VPWR _1517_ sky130_fd_sc_hd__or2_1
X_1932_ reg_file.registers\[10\]\[11\] _0539_ VGND VGND VPWR VPWR _0542_ sky130_fd_sc_hd__and2_1
X_1863_ _0505_ VGND VGND VPWR VPWR _0354_ sky130_fd_sc_hd__clkbuf_1
X_3602_ clknet_leaf_1_clk _0364_ _0175_ VGND VGND VPWR VPWR reg_file.registers\[5\]\[22\]
+ sky130_fd_sc_hd__dfrtp_1
XFILLER_0_8_418 VGND VGND VPWR VPWR sky130_fd_sc_hd__fill_2
X_3464_ clknet_leaf_6_clk _0233_ _0044_ VGND VGND VPWR VPWR imem.address\[19\] sky130_fd_sc_hd__dfrtp_1
X_1794_ imem.address\[9\] imem.address\[8\] imem.address\[7\] imem.address\[6\] VGND
+ VGND VPWR VPWR _0456_ sky130_fd_sc_hd__or4_1
XFILLER_0_58_41 VGND VGND VPWR VPWR sky130_fd_sc_hd__decap_4
X_2415_ _0597_ VGND VGND VPWR VPWR _1013_ sky130_fd_sc_hd__clkbuf_4
X_3533_ clknet_leaf_14_clk _0295_ _0106_ VGND VGND VPWR VPWR reg_file.registers\[11\]\[17\]
+ sky130_fd_sc_hd__dfrtp_1
XFILLER_0_24_262 VPWR VGND VPWR VGND sky130_ef_sc_hd__decap_12
XFILLER_0_24_251 VGND VGND VPWR VPWR sky130_fd_sc_hd__fill_1
XFILLER_0_3_167 VGND VGND VPWR VPWR sky130_fd_sc_hd__fill_1
XFILLER_0_58_85 VGND VGND VPWR VPWR sky130_fd_sc_hd__decap_8
X_2277_ _0873_ _0874_ VGND VGND VPWR VPWR _0875_ sky130_fd_sc_hd__xnor2_2
XFILLER_0_28_3 VPWR VGND VPWR VGND sky130_ef_sc_hd__decap_12
X_2346_ reg_file.registers\[11\]\[27\] _0927_ _0928_ reg_file.registers\[10\]\[27\]
+ VGND VGND VPWR VPWR _0944_ sky130_fd_sc_hd__a22oi_2
X_3395_ _1713_ VGND VGND VPWR VPWR _0177_ sky130_fd_sc_hd__inv_2
XFILLER_0_30_287 VPWR VGND VPWR VGND sky130_ef_sc_hd__decap_12
XFILLER_0_65_184 VGND VGND VPWR VPWR sky130_fd_sc_hd__fill_1
XFILLER_0_38_398 VGND VGND VPWR VPWR sky130_fd_sc_hd__fill_2
XFILLER_0_38_365 VGND VGND VPWR VPWR sky130_fd_sc_hd__decap_8
XFILLER_0_38_321 VGND VGND VPWR VPWR sky130_fd_sc_hd__decap_8
XFILLER_0_0_137 VGND VGND VPWR VPWR sky130_fd_sc_hd__decap_3
XFILLER_0_21_210 VPWR VGND VPWR VGND sky130_ef_sc_hd__decap_12
XFILLER_0_21_232 VGND VGND VPWR VPWR sky130_fd_sc_hd__decap_4
X_2131_ reg_file.registers\[5\]\[0\] _0562_ _0566_ reg_file.registers\[15\]\[0\] _0601_
+ VGND VGND VPWR VPWR _0729_ sky130_fd_sc_hd__a221o_1
XTAP_TAPCELL_ROW_49_544 VGND VPWR sky130_fd_sc_hd__tapvpwrvgnd_1
X_2200_ _0622_ _0635_ VGND VGND VPWR VPWR _0798_ sky130_fd_sc_hd__nor2_1
X_2062_ _0656_ _0659_ VGND VGND VPWR VPWR _0660_ sky130_fd_sc_hd__nand2_1
X_3180_ display.counter\[3\] _1664_ VGND VGND VPWR VPWR _1667_ sky130_fd_sc_hd__nor2_1
X_2964_ reg_file.registers\[15\]\[9\] _1483_ VGND VGND VPWR VPWR _1508_ sky130_fd_sc_hd__and2_1
XFILLER_0_44_54 VGND VGND VPWR VPWR sky130_fd_sc_hd__fill_1
XTAP_TAPCELL_ROW_32_411 VGND VPWR sky130_fd_sc_hd__tapvpwrvgnd_1
XFILLER_0_71_165 VGND VGND VPWR VPWR sky130_fd_sc_hd__decap_3
X_2895_ _1465_ VGND VGND VPWR VPWR _0282_ sky130_fd_sc_hd__clkbuf_1
X_1777_ reg_file.registers\[2\]\[4\] VGND VGND VPWR VPWR _0443_ sky130_fd_sc_hd__clkbuf_1
XFILLER_0_60_97 VPWR VGND VPWR VGND sky130_ef_sc_hd__decap_12
XFILLER_0_56_195 VGND VGND VPWR VPWR sky130_fd_sc_hd__fill_1
X_1915_ reg_file.registers\[10\]\[19\] _0528_ VGND VGND VPWR VPWR _0533_ sky130_fd_sc_hd__and2_1
Xclkbuf_leaf_14_clk clknet_1_1__leaf_clk VGND VGND VPWR VPWR clknet_leaf_14_clk sky130_fd_sc_hd__clkbuf_8
X_1846_ _0496_ VGND VGND VPWR VPWR _0362_ sky130_fd_sc_hd__clkbuf_1
XFILLER_0_4_421 VPWR VGND VPWR VGND sky130_ef_sc_hd__decap_12
XFILLER_0_8_65 VPWR VGND VPWR VGND sky130_ef_sc_hd__decap_12
XFILLER_0_12_221 VPWR VGND VPWR VGND sky130_ef_sc_hd__decap_12
X_3516_ clknet_leaf_10_clk _0278_ _0089_ VGND VGND VPWR VPWR reg_file.registers\[11\]\[0\]
+ sky130_fd_sc_hd__dfrtp_2
X_3447_ clknet_leaf_9_clk _0216_ _0027_ VGND VGND VPWR VPWR imem.address\[2\] sky130_fd_sc_hd__dfrtp_1
X_3378_ _1711_ VGND VGND VPWR VPWR _0162_ sky130_fd_sc_hd__inv_2
XPHY_EDGE_ROW_31_Left_103 VGND VGND VPWR VPWR sky130_fd_sc_hd__decap_3
XPHY_EDGE_ROW_4_Right_4 VGND VGND VPWR VPWR sky130_fd_sc_hd__decap_3
XFILLER_0_12_265 VPWR VGND VPWR VGND sky130_ef_sc_hd__decap_12
XFILLER_0_67_405 VPWR VGND VPWR VGND sky130_ef_sc_hd__decap_12
XPHY_EDGE_ROW_40_Left_112 VGND VGND VPWR VPWR sky130_fd_sc_hd__decap_3
X_2329_ _0862_ VGND VGND VPWR VPWR _0927_ sky130_fd_sc_hd__clkbuf_4
XFILLER_0_67_449 VGND VGND VPWR VPWR sky130_fd_sc_hd__fill_2
XFILLER_0_39_118 VGND VGND VPWR VPWR sky130_fd_sc_hd__fill_2
XFILLER_0_62_176 VGND VGND VPWR VPWR sky130_fd_sc_hd__decap_3
XFILLER_0_7_281 VPWR VGND VPWR VGND sky130_ef_sc_hd__decap_12
XTAP_TAPCELL_ROW_54_591 VGND VPWR sky130_fd_sc_hd__tapvpwrvgnd_1
XTAP_TAPCELL_ROW_46_525 VGND VPWR sky130_fd_sc_hd__tapvpwrvgnd_1
XTAP_TAPCELL_ROW_3_180 VGND VPWR sky130_fd_sc_hd__tapvpwrvgnd_1
XFILLER_0_53_176 VGND VGND VPWR VPWR sky130_fd_sc_hd__fill_1
XFILLER_0_53_121 VPWR VGND VPWR VGND sky130_ef_sc_hd__decap_12
XFILLER_0_26_335 VPWR VGND VPWR VGND sky130_ef_sc_hd__decap_12
X_2680_ _1272_ _0870_ _0996_ VGND VGND VPWR VPWR _1273_ sky130_fd_sc_hd__mux2_1
XFILLER_0_14_79 VGND VGND VPWR VPWR sky130_fd_sc_hd__decap_4
X_3232_ _1693_ VGND VGND VPWR VPWR _0034_ sky130_fd_sc_hd__inv_2
X_3301_ _1702_ VGND VGND VPWR VPWR _0094_ sky130_fd_sc_hd__inv_2
Xclkbuf_leaf_3_clk clknet_1_0__leaf_clk VGND VGND VPWR VPWR clknet_leaf_3_clk sky130_fd_sc_hd__clkbuf_8
XFILLER_0_39_65 VGND VGND VPWR VPWR sky130_fd_sc_hd__decap_4
X_2114_ _0710_ _0711_ VGND VGND VPWR VPWR _0712_ sky130_fd_sc_hd__and2_1
X_2045_ reg_file.registers\[2\]\[14\] _0558_ VGND VGND VPWR VPWR _0643_ sky130_fd_sc_hd__and2_1
X_3163_ _1648_ _1657_ _1655_ VGND VGND VPWR VPWR _0002_ sky130_fd_sc_hd__o21ai_1
X_3094_ reg_file.registers\[11\]\[26\] _0927_ _0928_ reg_file.registers\[10\]\[26\]
+ _1153_ VGND VGND VPWR VPWR _1594_ sky130_fd_sc_hd__a221o_1
XFILLER_0_71_85 VGND VGND VPWR VPWR sky130_fd_sc_hd__decap_6
XFILLER_0_71_41 VGND VGND VPWR VPWR sky130_fd_sc_hd__decap_6
XFILLER_0_64_419 VGND VGND VPWR VPWR sky130_fd_sc_hd__fill_1
XFILLER_0_49_449 VGND VGND VPWR VPWR sky130_fd_sc_hd__fill_2
X_2947_ _1499_ VGND VGND VPWR VPWR _0264_ sky130_fd_sc_hd__clkbuf_1
XTAP_TAPCELL_ROW_17_293 VGND VPWR sky130_fd_sc_hd__tapvpwrvgnd_1
X_2878_ _0594_ _1412_ VGND VGND VPWR VPWR _1451_ sky130_fd_sc_hd__nor2_1
XFILLER_0_32_305 VGND VGND VPWR VPWR sky130_fd_sc_hd__decap_3
XFILLER_0_4_251 VGND VGND VPWR VPWR sky130_fd_sc_hd__fill_1
XTAP_TAPCELL_ROW_9_228 VGND VPWR sky130_fd_sc_hd__tapvpwrvgnd_1
X_1829_ _0487_ VGND VGND VPWR VPWR _0370_ sky130_fd_sc_hd__clkbuf_1
XTAP_TAPCELL_ROW_0_150 VGND VPWR sky130_fd_sc_hd__tapvpwrvgnd_1
XFILLER_0_67_279 VGND VGND VPWR VPWR sky130_fd_sc_hd__fill_1
XTAP_TAPCELL_ROW_51_561 VGND VPWR sky130_fd_sc_hd__tapvpwrvgnd_1
XFILLER_0_35_110 VGND VGND VPWR VPWR sky130_fd_sc_hd__fill_2
XFILLER_0_50_179 VGND VGND VPWR VPWR sky130_fd_sc_hd__decap_6
XFILLER_0_31_393 VGND VGND VPWR VPWR sky130_fd_sc_hd__fill_1
XFILLER_0_41_11 VGND VGND VPWR VPWR sky130_fd_sc_hd__fill_1
X_2801_ _0857_ _0910_ VGND VGND VPWR VPWR _1385_ sky130_fd_sc_hd__or2_1
X_2663_ _0994_ _0819_ _1255_ VGND VGND VPWR VPWR _1256_ sky130_fd_sc_hd__a21o_1
X_2732_ _0904_ _1321_ _0903_ VGND VGND VPWR VPWR _1322_ sky130_fd_sc_hd__a21boi_1
XFILLER_0_26_176 VGND VGND VPWR VPWR sky130_fd_sc_hd__decap_8
X_2594_ _1155_ _0929_ VGND VGND VPWR VPWR _1190_ sky130_fd_sc_hd__and2_1
XFILLER_0_66_85 VGND VGND VPWR VPWR sky130_fd_sc_hd__decap_8
XTAP_TAPCELL_ROW_57_609 VGND VPWR sky130_fd_sc_hd__tapvpwrvgnd_1
XFILLER_0_5_55 VGND VGND VPWR VPWR sky130_fd_sc_hd__fill_1
X_3215_ display.counter\[18\] _1684_ VGND VGND VPWR VPWR _1687_ sky130_fd_sc_hd__nor2_1
XTAP_TAPCELL_ROW_65_675 VGND VPWR sky130_fd_sc_hd__tapvpwrvgnd_1
X_2028_ reg_file.registers\[2\]\[10\] _0557_ VGND VGND VPWR VPWR _0626_ sky130_fd_sc_hd__and2_1
X_3146_ _1318_ _1583_ _1635_ _1429_ _1642_ VGND VGND VPWR VPWR _1643_ sky130_fd_sc_hd__a221o_1
X_3077_ display.digit_sel\[1\] display.digit_sel\[0\] VGND VGND VPWR VPWR _1580_ sky130_fd_sc_hd__nand2_1
XFILLER_0_10_3 VPWR VGND VPWR VGND sky130_ef_sc_hd__decap_12
XFILLER_0_49_279 VGND VGND VPWR VPWR sky130_fd_sc_hd__fill_1
XFILLER_0_37_419 VGND VGND VPWR VPWR sky130_fd_sc_hd__decap_3
XFILLER_0_17_143 VGND VGND VPWR VPWR sky130_fd_sc_hd__decap_4
XFILLER_0_60_433 VGND VGND VPWR VPWR sky130_fd_sc_hd__fill_2
XFILLER_0_32_135 VGND VGND VPWR VPWR sky130_fd_sc_hd__decap_4
XFILLER_0_13_393 VGND VGND VPWR VPWR sky130_fd_sc_hd__decap_4
XTAP_TAPCELL_ROW_28_377 VGND VPWR sky130_fd_sc_hd__tapvpwrvgnd_1
XFILLER_0_63_293 VPWR VGND VPWR VGND sky130_ef_sc_hd__decap_12
XFILLER_0_63_271 VGND VGND VPWR VPWR sky130_fd_sc_hd__decap_8
XFILLER_0_51_444 VGND VGND VPWR VPWR sky130_fd_sc_hd__fill_1
XFILLER_0_36_441 VGND VGND VPWR VPWR sky130_fd_sc_hd__decap_6
XFILLER_0_23_146 VGND VGND VPWR VPWR sky130_fd_sc_hd__decap_8
XFILLER_0_23_113 VPWR VGND VPWR VGND sky130_ef_sc_hd__decap_12
XFILLER_0_11_69 VPWR VGND VPWR VGND sky130_ef_sc_hd__decap_12
XTAP_TAPCELL_ROW_11_244 VGND VPWR sky130_fd_sc_hd__tapvpwrvgnd_1
X_3000_ imem.address\[27\] _1533_ VGND VGND VPWR VPWR _1534_ sky130_fd_sc_hd__and2_1
XFILLER_0_36_99 VPWR VGND VPWR VGND sky130_ef_sc_hd__decap_12
XFILLER_0_36_88 VGND VGND VPWR VPWR sky130_fd_sc_hd__decap_3
XFILLER_0_36_44 VPWR VGND VPWR VGND sky130_ef_sc_hd__decap_12
XTAP_TAPCELL_ROW_19_311 VGND VPWR sky130_fd_sc_hd__tapvpwrvgnd_1
XFILLER_0_54_282 VGND VGND VPWR VPWR sky130_fd_sc_hd__decap_3
XFILLER_0_54_271 VGND VGND VPWR VPWR sky130_fd_sc_hd__decap_3
X_2577_ _1152_ _1171_ _1172_ VGND VGND VPWR VPWR _1173_ sky130_fd_sc_hd__o21ai_1
XFILLER_0_58_3 VPWR VGND VPWR VGND sky130_ef_sc_hd__decap_12
X_2646_ _1050_ VGND VGND VPWR VPWR _1240_ sky130_fd_sc_hd__inv_2
X_2715_ _1128_ _1187_ _1305_ _1306_ _1200_ VGND VGND VPWR VPWR _1307_ sky130_fd_sc_hd__o2111a_1
XFILLER_0_10_363 VGND VGND VPWR VPWR sky130_fd_sc_hd__fill_1
XFILLER_0_14_135 VGND VGND VPWR VPWR sky130_fd_sc_hd__fill_2
XTAP_TAPCELL_ROW_25_358 VGND VPWR sky130_fd_sc_hd__tapvpwrvgnd_1
X_3129_ _1022_ _1030_ VGND VGND VPWR VPWR _1628_ sky130_fd_sc_hd__nor2_1
XFILLER_0_45_293 VPWR VGND VPWR VGND sky130_ef_sc_hd__decap_12
XFILLER_0_68_341 VGND VGND VPWR VPWR sky130_fd_sc_hd__decap_3
XFILLER_0_24_400 VGND VGND VPWR VPWR sky130_fd_sc_hd__decap_6
XFILLER_0_22_79 VGND VGND VPWR VPWR sky130_fd_sc_hd__decap_4
X_2500_ _1094_ _1096_ _1068_ VGND VGND VPWR VPWR _1097_ sky130_fd_sc_hd__mux2_1
XFILLER_0_51_252 VGND VGND VPWR VPWR sky130_fd_sc_hd__decap_6
XFILLER_0_36_293 VPWR VGND VPWR VGND sky130_ef_sc_hd__decap_12
XFILLER_0_3_349 VPWR VGND VPWR VGND sky130_ef_sc_hd__decap_12
XFILLER_0_3_305 VPWR VGND VPWR VGND sky130_ef_sc_hd__decap_12
XFILLER_0_11_105 VGND VGND VPWR VPWR sky130_fd_sc_hd__decap_6
XFILLER_0_11_149 VPWR VGND VPWR VGND sky130_ef_sc_hd__decap_12
X_3480_ clknet_leaf_16_clk _0003_ VGND VGND VPWR VPWR net13 sky130_fd_sc_hd__dfxtp_1
X_2431_ _0939_ VGND VGND VPWR VPWR _1029_ sky130_fd_sc_hd__inv_2
XFILLER_0_47_43 VGND VGND VPWR VPWR sky130_fd_sc_hd__fill_2
X_2293_ _0662_ _0887_ _0889_ VGND VGND VPWR VPWR _0891_ sky130_fd_sc_hd__a21oi_1
X_2362_ _0958_ _0954_ _0956_ _0959_ _0948_ VGND VGND VPWR VPWR _0960_ sky130_fd_sc_hd__a311o_1
XFILLER_0_63_31 VGND VGND VPWR VPWR sky130_fd_sc_hd__decap_4
XTAP_TAPCELL_ROW_30_394 VGND VPWR sky130_fd_sc_hd__tapvpwrvgnd_1
XTAP_TAPCELL_ROW_22_328 VGND VPWR sky130_fd_sc_hd__tapvpwrvgnd_1
XFILLER_0_6_121 VPWR VGND VPWR VGND sky130_ef_sc_hd__decap_12
XFILLER_0_6_165 VPWR VGND VPWR VGND sky130_ef_sc_hd__decap_12
XFILLER_0_15_422 VGND VGND VPWR VPWR sky130_fd_sc_hd__decap_6
X_2629_ _1025_ _1223_ VGND VGND VPWR VPWR _1224_ sky130_fd_sc_hd__or2_1
XTAP_TAPCELL_ROW_38_461 VGND VPWR sky130_fd_sc_hd__tapvpwrvgnd_1
X_2980_ _1516_ VGND VGND VPWR VPWR _0248_ sky130_fd_sc_hd__clkbuf_1
XFILLER_0_56_300 VGND VGND VPWR VPWR sky130_fd_sc_hd__fill_2
XFILLER_0_33_67 VGND VGND VPWR VPWR sky130_fd_sc_hd__fill_1
X_1793_ imem.address\[4\] VGND VGND VPWR VPWR _0455_ sky130_fd_sc_hd__clkbuf_2
X_1931_ _0541_ VGND VGND VPWR VPWR _0322_ sky130_fd_sc_hd__clkbuf_1
X_1862_ reg_file.registers\[5\]\[12\] _0504_ VGND VGND VPWR VPWR _0505_ sky130_fd_sc_hd__and2_1
X_3601_ clknet_leaf_1_clk _0363_ _0174_ VGND VGND VPWR VPWR reg_file.registers\[5\]\[21\]
+ sky130_fd_sc_hd__dfrtp_1
XFILLER_0_3_113 VPWR VGND VPWR VGND sky130_ef_sc_hd__decap_12
X_3463_ clknet_leaf_6_clk _0232_ _0043_ VGND VGND VPWR VPWR imem.address\[18\] sky130_fd_sc_hd__dfrtp_1
XFILLER_0_58_53 VPWR VGND VPWR VGND sky130_ef_sc_hd__decap_12
X_3532_ clknet_leaf_13_clk _0294_ _0105_ VGND VGND VPWR VPWR reg_file.registers\[11\]\[16\]
+ sky130_fd_sc_hd__dfrtp_1
X_2414_ _1009_ _1011_ _1003_ VGND VGND VPWR VPWR _1012_ sky130_fd_sc_hd__mux2_1
XFILLER_0_24_274 VPWR VGND VPWR VGND sky130_ef_sc_hd__decap_12
X_3394_ _1713_ VGND VGND VPWR VPWR _0176_ sky130_fd_sc_hd__inv_2
X_2276_ reg_file.registers\[11\]\[20\] _0693_ _0698_ reg_file.registers\[10\]\[20\]
+ VGND VGND VPWR VPWR _0874_ sky130_fd_sc_hd__a22oi_4
X_2345_ _0580_ _0571_ _0581_ _0678_ VGND VGND VPWR VPWR _0943_ sky130_fd_sc_hd__a2bb2o_1
XFILLER_0_59_182 VGND VGND VPWR VPWR sky130_fd_sc_hd__fill_2
XFILLER_0_47_311 VGND VGND VPWR VPWR sky130_fd_sc_hd__decap_8
XFILLER_0_30_211 VGND VGND VPWR VPWR sky130_fd_sc_hd__fill_2
XFILLER_0_15_241 VGND VGND VPWR VPWR sky130_fd_sc_hd__fill_1
XFILLER_0_30_299 VGND VGND VPWR VPWR sky130_fd_sc_hd__decap_8
XFILLER_0_30_266 VGND VGND VPWR VPWR sky130_fd_sc_hd__fill_1
XFILLER_0_57_119 VGND VGND VPWR VPWR sky130_fd_sc_hd__fill_1
XFILLER_0_57_108 VGND VGND VPWR VPWR sky130_fd_sc_hd__decap_4
XFILLER_0_61_391 VGND VGND VPWR VPWR sky130_fd_sc_hd__fill_1
XFILLER_0_28_23 VGND VGND VPWR VPWR sky130_fd_sc_hd__fill_2
XFILLER_0_21_222 VGND VGND VPWR VPWR sky130_fd_sc_hd__fill_2
XFILLER_0_21_255 VPWR VGND VPWR VGND sky130_ef_sc_hd__decap_12
X_2130_ _0724_ _0727_ VGND VGND VPWR VPWR _0728_ sky130_fd_sc_hd__xor2_1
XTAP_TAPCELL_ROW_49_545 VGND VPWR sky130_fd_sc_hd__tapvpwrvgnd_1
X_2061_ _0573_ _0658_ _0578_ VGND VGND VPWR VPWR _0659_ sky130_fd_sc_hd__a21oi_1
XFILLER_0_60_32 VGND VGND VPWR VPWR sky130_fd_sc_hd__fill_2
XFILLER_0_56_163 VGND VGND VPWR VPWR sky130_fd_sc_hd__decap_4
XFILLER_0_56_141 VGND VGND VPWR VPWR sky130_fd_sc_hd__decap_8
X_2963_ _1507_ VGND VGND VPWR VPWR _0256_ sky130_fd_sc_hd__clkbuf_1
XTAP_TAPCELL_ROW_32_412 VGND VPWR sky130_fd_sc_hd__tapvpwrvgnd_1
X_1914_ _0532_ VGND VGND VPWR VPWR _0330_ sky130_fd_sc_hd__clkbuf_1
XFILLER_0_71_111 VGND VGND VPWR VPWR sky130_fd_sc_hd__fill_1
X_2894_ reg_file.registers\[11\]\[4\] _1464_ _1058_ VGND VGND VPWR VPWR _1465_ sky130_fd_sc_hd__mux2_1
X_1776_ _0442_ VGND VGND VPWR VPWR _0378_ sky130_fd_sc_hd__clkbuf_1
X_1845_ reg_file.registers\[5\]\[20\] _0493_ VGND VGND VPWR VPWR _0496_ sky130_fd_sc_hd__and2_1
X_3515_ clknet_leaf_2_clk _0277_ _0088_ VGND VGND VPWR VPWR reg_file.registers\[15\]\[31\]
+ sky130_fd_sc_hd__dfrtp_1
XFILLER_0_4_433 VPWR VGND VPWR VGND sky130_ef_sc_hd__decap_12
XFILLER_0_4_411 VGND VGND VPWR VPWR sky130_fd_sc_hd__fill_1
XFILLER_0_8_77 VGND VGND VPWR VPWR sky130_fd_sc_hd__decap_6
XFILLER_0_12_233 VPWR VGND VPWR VGND sky130_ef_sc_hd__decap_12
X_3446_ clknet_leaf_8_clk net1 VGND VGND VPWR VPWR prev_control sky130_fd_sc_hd__dfxtp_1
X_3377_ _1711_ VGND VGND VPWR VPWR _0161_ sky130_fd_sc_hd__inv_2
XFILLER_0_40_3 VPWR VGND VPWR VGND sky130_ef_sc_hd__decap_12
X_2328_ net28 _0872_ VGND VGND VPWR VPWR _0926_ sky130_fd_sc_hd__nand2_1
XFILLER_0_12_277 VGND VGND VPWR VPWR sky130_fd_sc_hd__decap_4
XFILLER_0_67_417 VPWR VGND VPWR VGND sky130_ef_sc_hd__decap_12
X_2259_ _0775_ _0810_ _0838_ _0856_ VGND VGND VPWR VPWR _0857_ sky130_fd_sc_hd__o31a_1
XFILLER_0_47_196 VGND VGND VPWR VPWR sky130_fd_sc_hd__decap_4
XFILLER_0_7_293 VPWR VGND VPWR VGND sky130_ef_sc_hd__decap_12
XTAP_TAPCELL_ROW_46_526 VGND VPWR sky130_fd_sc_hd__tapvpwrvgnd_1
XTAP_TAPCELL_ROW_3_181 VGND VPWR sky130_fd_sc_hd__tapvpwrvgnd_1
XFILLER_0_53_133 VGND VGND VPWR VPWR sky130_fd_sc_hd__decap_3
XFILLER_0_53_111 VGND VGND VPWR VPWR sky130_fd_sc_hd__fill_1
XFILLER_0_41_306 VGND VGND VPWR VPWR sky130_fd_sc_hd__fill_1
XFILLER_0_30_35 VGND VGND VPWR VPWR sky130_fd_sc_hd__decap_8
XFILLER_0_26_347 VGND VGND VPWR VPWR sky130_fd_sc_hd__fill_2
X_3231_ _1693_ VGND VGND VPWR VPWR _0033_ sky130_fd_sc_hd__inv_2
X_3300_ _1702_ VGND VGND VPWR VPWR _0093_ sky130_fd_sc_hd__inv_2
X_3162_ _1644_ _1649_ _1634_ VGND VGND VPWR VPWR _1657_ sky130_fd_sc_hd__or3b_4
X_2113_ reg_file.registers\[11\]\[6\] _0692_ _0697_ reg_file.registers\[10\]\[6\]
+ VGND VGND VPWR VPWR _0711_ sky130_fd_sc_hd__a22oi_4
XFILLER_0_49_417 VGND VGND VPWR VPWR sky130_fd_sc_hd__decap_8
X_2044_ _0641_ _0635_ _0622_ VGND VGND VPWR VPWR _0642_ sky130_fd_sc_hd__or3_4
X_3093_ _1577_ _1579_ _1592_ VGND VGND VPWR VPWR _1593_ sky130_fd_sc_hd__a21oi_1
X_2877_ _1450_ VGND VGND VPWR VPWR _0285_ sky130_fd_sc_hd__clkbuf_1
XFILLER_0_44_122 VPWR VGND VPWR VGND sky130_ef_sc_hd__decap_12
X_2946_ reg_file.registers\[15\]\[18\] _1495_ VGND VGND VPWR VPWR _1499_ sky130_fd_sc_hd__and2_1
XFILLER_0_29_185 VGND VGND VPWR VPWR sky130_fd_sc_hd__decap_4
XFILLER_0_29_130 VGND VGND VPWR VPWR sky130_fd_sc_hd__fill_1
XFILLER_0_17_369 VGND VGND VPWR VPWR sky130_fd_sc_hd__fill_2
XTAP_TAPCELL_ROW_17_294 VGND VPWR sky130_fd_sc_hd__tapvpwrvgnd_1
X_1759_ reg_file.registers\[2\]\[13\] VGND VGND VPWR VPWR _0434_ sky130_fd_sc_hd__clkbuf_1
XTAP_TAPCELL_ROW_9_229 VGND VPWR sky130_fd_sc_hd__tapvpwrvgnd_1
X_1828_ reg_file.registers\[5\]\[28\] _0483_ VGND VGND VPWR VPWR _0487_ sky130_fd_sc_hd__and2_1
X_3429_ _1718_ VGND VGND VPWR VPWR _0206_ sky130_fd_sc_hd__inv_2
XFILLER_0_67_225 VGND VGND VPWR VPWR sky130_fd_sc_hd__fill_1
XTAP_TAPCELL_ROW_0_151 VGND VPWR sky130_fd_sc_hd__tapvpwrvgnd_1
XTAP_TAPCELL_ROW_51_562 VGND VPWR sky130_fd_sc_hd__tapvpwrvgnd_1
XFILLER_0_50_158 VGND VGND VPWR VPWR sky130_fd_sc_hd__decap_3
XFILLER_0_35_122 VGND VGND VPWR VPWR sky130_fd_sc_hd__decap_8
XFILLER_0_23_328 VGND VGND VPWR VPWR sky130_fd_sc_hd__fill_2
XFILLER_0_58_214 VGND VGND VPWR VPWR sky130_fd_sc_hd__decap_8
X_2731_ _0909_ VGND VGND VPWR VPWR _1321_ sky130_fd_sc_hd__inv_2
X_2800_ _1384_ VGND VGND VPWR VPWR _0296_ sky130_fd_sc_hd__clkbuf_1
XTAP_TAPCELL_ROW_14_264 VGND VPWR sky130_fd_sc_hd__tapvpwrvgnd_1
X_2662_ _0731_ _0834_ VGND VGND VPWR VPWR _1255_ sky130_fd_sc_hd__nor2_1
X_2593_ _1025_ _1185_ _1188_ VGND VGND VPWR VPWR _1189_ sky130_fd_sc_hd__o21ai_2
X_3145_ _1444_ _1586_ _1636_ _1397_ _1641_ VGND VGND VPWR VPWR _1642_ sky130_fd_sc_hd__a221o_1
X_3214_ display.counter\[18\] _1684_ VGND VGND VPWR VPWR _1686_ sky130_fd_sc_hd__and2_1
XTAP_TAPCELL_ROW_65_676 VGND VPWR sky130_fd_sc_hd__tapvpwrvgnd_1
XFILLER_0_64_217 VGND VGND VPWR VPWR sky130_fd_sc_hd__decap_8
XFILLER_0_49_225 VGND VGND VPWR VPWR sky130_fd_sc_hd__fill_2
X_2027_ _0572_ _0624_ VGND VGND VPWR VPWR _0625_ sky130_fd_sc_hd__and2_1
X_3076_ _1578_ _1557_ display.digit_sel\[0\] VGND VGND VPWR VPWR _1579_ sky130_fd_sc_hd__and3_2
XFILLER_0_9_344 VGND VGND VPWR VPWR sky130_fd_sc_hd__fill_1
XFILLER_0_17_155 VGND VGND VPWR VPWR sky130_fd_sc_hd__fill_1
X_2929_ reg_file.registers\[15\]\[26\] _1484_ VGND VGND VPWR VPWR _1490_ sky130_fd_sc_hd__and2_1
XFILLER_0_20_309 VPWR VGND VPWR VGND sky130_ef_sc_hd__decap_12
XTAP_TAPCELL_ROW_28_378 VGND VPWR sky130_fd_sc_hd__tapvpwrvgnd_1
XFILLER_0_11_15 VPWR VGND VPWR VGND sky130_ef_sc_hd__decap_12
XFILLER_0_51_401 VGND VGND VPWR VPWR sky130_fd_sc_hd__fill_1
XFILLER_0_23_125 VGND VGND VPWR VPWR sky130_fd_sc_hd__fill_1
XTAP_TAPCELL_ROW_11_245 VGND VPWR sky130_fd_sc_hd__tapvpwrvgnd_1
XFILLER_0_36_56 VGND VGND VPWR VPWR sky130_fd_sc_hd__decap_8
X_2714_ _1145_ _1195_ VGND VGND VPWR VPWR _1306_ sky130_fd_sc_hd__or2_1
XFILLER_0_6_369 VGND VGND VPWR VPWR sky130_fd_sc_hd__decap_6
X_2576_ _1155_ _0745_ VGND VGND VPWR VPWR _1172_ sky130_fd_sc_hd__or2_1
X_2645_ reg_file.registers\[5\]\[4\] _0680_ VGND VGND VPWR VPWR _1239_ sky130_fd_sc_hd__nand2_1
X_3128_ _1621_ _1583_ _1579_ _1360_ _1626_ VGND VGND VPWR VPWR _1627_ sky130_fd_sc_hd__a221o_1
XFILLER_0_37_228 VPWR VGND VPWR VGND sky130_ef_sc_hd__decap_12
X_3059_ _0888_ _0917_ _1155_ VGND VGND VPWR VPWR _1562_ sky130_fd_sc_hd__mux2_1
XTAP_TAPCELL_ROW_25_359 VGND VPWR sky130_fd_sc_hd__tapvpwrvgnd_1
XFILLER_0_60_275 VGND VGND VPWR VPWR sky130_fd_sc_hd__decap_8
XFILLER_0_60_253 VGND VGND VPWR VPWR sky130_fd_sc_hd__decap_4
XFILLER_0_45_272 VGND VGND VPWR VPWR sky130_fd_sc_hd__decap_8
XFILLER_0_45_261 VGND VGND VPWR VPWR sky130_fd_sc_hd__fill_2
XFILLER_0_5_391 VGND VGND VPWR VPWR sky130_fd_sc_hd__fill_1
XFILLER_0_20_139 VGND VGND VPWR VPWR sky130_fd_sc_hd__fill_1
XFILLER_0_43_209 VGND VGND VPWR VPWR sky130_fd_sc_hd__decap_6
XFILLER_0_28_239 VGND VGND VPWR VPWR sky130_fd_sc_hd__decap_4
XFILLER_0_3_317 VPWR VGND VPWR VGND sky130_ef_sc_hd__decap_12
XFILLER_0_51_242 VGND VGND VPWR VPWR sky130_fd_sc_hd__fill_1
X_2361_ _0956_ _0953_ VGND VGND VPWR VPWR _0959_ sky130_fd_sc_hd__and2_1
X_2430_ _0934_ VGND VGND VPWR VPWR _1028_ sky130_fd_sc_hd__inv_2
XFILLER_0_47_66 VGND VGND VPWR VPWR sky130_fd_sc_hd__decap_6
X_2292_ _0662_ _0887_ _0889_ VGND VGND VPWR VPWR _0890_ sky130_fd_sc_hd__and3_1
XTAP_TAPCELL_ROW_22_329 VGND VPWR sky130_fd_sc_hd__tapvpwrvgnd_1
XFILLER_0_70_3 VPWR VGND VPWR VGND sky130_ef_sc_hd__decap_12
XFILLER_0_42_220 VPWR VGND VPWR VGND sky130_ef_sc_hd__decap_12
XFILLER_0_34_209 VGND VGND VPWR VPWR sky130_fd_sc_hd__decap_3
XFILLER_0_30_426 VGND VGND VPWR VPWR sky130_fd_sc_hd__fill_2
XTAP_TAPCELL_ROW_30_395 VGND VPWR sky130_fd_sc_hd__tapvpwrvgnd_1
XFILLER_0_27_261 VGND VGND VPWR VPWR sky130_fd_sc_hd__decap_3
XFILLER_0_6_133 VGND VGND VPWR VPWR sky130_fd_sc_hd__decap_6
XFILLER_0_6_177 VPWR VGND VPWR VGND sky130_ef_sc_hd__decap_12
XFILLER_0_15_445 VGND VGND VPWR VPWR sky130_fd_sc_hd__decap_3
X_2559_ net55 VGND VGND VPWR VPWR _1155_ sky130_fd_sc_hd__clkbuf_4
X_2628_ _1017_ _1113_ _1222_ VGND VGND VPWR VPWR _1223_ sky130_fd_sc_hd__a21oi_1
XFILLER_0_69_117 VGND VGND VPWR VPWR sky130_fd_sc_hd__decap_4
XTAP_TAPCELL_ROW_38_462 VGND VPWR sky130_fd_sc_hd__tapvpwrvgnd_1
XFILLER_0_18_250 VGND VGND VPWR VPWR sky130_fd_sc_hd__fill_2
XFILLER_0_18_283 VPWR VGND VPWR VGND sky130_ef_sc_hd__decap_12
XFILLER_0_0_309 VPWR VGND VPWR VGND sky130_ef_sc_hd__decap_12
XFILLER_0_17_47 VGND VGND VPWR VPWR sky130_fd_sc_hd__fill_2
X_1930_ reg_file.registers\[10\]\[12\] _0539_ VGND VGND VPWR VPWR _0541_ sky130_fd_sc_hd__and2_1
XFILLER_0_71_337 VPWR VGND VPWR VGND sky130_ef_sc_hd__decap_12
X_1792_ _0452_ _0453_ VGND VGND VPWR VPWR _0454_ sky130_fd_sc_hd__or2_4
XFILLER_0_56_378 VGND VGND VPWR VPWR sky130_fd_sc_hd__fill_1
X_1861_ _0482_ VGND VGND VPWR VPWR _0504_ sky130_fd_sc_hd__clkbuf_2
X_3531_ clknet_leaf_13_clk _0293_ _0104_ VGND VGND VPWR VPWR reg_file.registers\[11\]\[15\]
+ sky130_fd_sc_hd__dfrtp_1
X_3600_ clknet_leaf_0_clk _0362_ _0173_ VGND VGND VPWR VPWR reg_file.registers\[5\]\[20\]
+ sky130_fd_sc_hd__dfrtp_1
XFILLER_0_24_286 VGND VGND VPWR VPWR sky130_fd_sc_hd__decap_4
XFILLER_0_24_231 VGND VGND VPWR VPWR sky130_fd_sc_hd__decap_4
XFILLER_0_3_169 VPWR VGND VPWR VGND sky130_ef_sc_hd__decap_12
XFILLER_0_3_125 VPWR VGND VPWR VGND sky130_ef_sc_hd__decap_12
XFILLER_0_16_209 VGND VGND VPWR VPWR sky130_fd_sc_hd__decap_8
X_3462_ clknet_leaf_7_clk _0231_ _0042_ VGND VGND VPWR VPWR imem.address\[17\] sky130_fd_sc_hd__dfrtp_1
XFILLER_0_58_98 VGND VGND VPWR VPWR sky130_fd_sc_hd__fill_1
XFILLER_0_58_76 VGND VGND VPWR VPWR sky130_fd_sc_hd__fill_1
Xclkbuf_1_0__f_clk clknet_0_clk VGND VGND VPWR VPWR clknet_1_0__leaf_clk sky130_fd_sc_hd__clkbuf_16
X_2413_ _1010_ _0902_ _0995_ VGND VGND VPWR VPWR _1011_ sky130_fd_sc_hd__mux2_1
X_3393_ _1713_ VGND VGND VPWR VPWR _0175_ sky130_fd_sc_hd__inv_2
X_2344_ _0940_ _0941_ VGND VGND VPWR VPWR _0942_ sky130_fd_sc_hd__nor2_1
X_2275_ _0859_ _0667_ VGND VGND VPWR VPWR _0873_ sky130_fd_sc_hd__xnor2_2
XFILLER_0_47_334 VGND VGND VPWR VPWR sky130_fd_sc_hd__fill_2
XFILLER_0_47_301 VGND VGND VPWR VPWR sky130_fd_sc_hd__fill_1
XTAP_TAPCELL_ROW_35_432 VGND VPWR sky130_fd_sc_hd__tapvpwrvgnd_1
XFILLER_0_21_267 VGND VGND VPWR VPWR sky130_fd_sc_hd__fill_2
XTAP_TAPCELL_ROW_49_546 VGND VPWR sky130_fd_sc_hd__tapvpwrvgnd_1
X_2060_ reg_file.registers\[5\]\[18\] _0563_ _0567_ reg_file.registers\[15\]\[18\]
+ _0657_ VGND VGND VPWR VPWR _0658_ sky130_fd_sc_hd__a221o_1
XFILLER_0_60_22 VGND VGND VPWR VPWR sky130_fd_sc_hd__decap_6
XFILLER_0_56_153 VGND VGND VPWR VPWR sky130_fd_sc_hd__decap_3
X_2893_ _1107_ _1140_ _1461_ _1463_ VGND VGND VPWR VPWR _1464_ sky130_fd_sc_hd__a31o_1
XFILLER_0_48_109 VGND VGND VPWR VPWR sky130_fd_sc_hd__fill_1
X_2962_ reg_file.registers\[15\]\[10\] _1483_ VGND VGND VPWR VPWR _1507_ sky130_fd_sc_hd__and2_1
XTAP_TAPCELL_ROW_32_413 VGND VPWR sky130_fd_sc_hd__tapvpwrvgnd_1
XFILLER_0_29_312 VPWR VGND VPWR VGND sky130_ef_sc_hd__decap_12
X_1913_ reg_file.registers\[10\]\[20\] _0528_ VGND VGND VPWR VPWR _0532_ sky130_fd_sc_hd__and2_1
X_1775_ reg_file.registers\[2\]\[5\] VGND VGND VPWR VPWR _0442_ sky130_fd_sc_hd__clkbuf_1
X_3514_ clknet_leaf_2_clk _0276_ _0087_ VGND VGND VPWR VPWR reg_file.registers\[15\]\[30\]
+ sky130_fd_sc_hd__dfrtp_1
X_3445_ _0415_ _1688_ _1722_ VGND VGND VPWR VPWR _0407_ sky130_fd_sc_hd__o21a_1
X_1844_ _0495_ VGND VGND VPWR VPWR _0363_ sky130_fd_sc_hd__clkbuf_1
XFILLER_0_4_445 VGND VGND VPWR VPWR sky130_fd_sc_hd__decap_6
XFILLER_0_4_401 VGND VGND VPWR VPWR sky130_fd_sc_hd__decap_6
XFILLER_0_12_245 VGND VGND VPWR VPWR sky130_fd_sc_hd__decap_6
X_3376_ _1711_ VGND VGND VPWR VPWR _0160_ sky130_fd_sc_hd__inv_2
X_2258_ _0797_ _0809_ _0845_ _0851_ _0855_ VGND VGND VPWR VPWR _0856_ sky130_fd_sc_hd__a311oi_1
XFILLER_0_33_3 VGND VGND VPWR VPWR sky130_fd_sc_hd__decap_6
X_2327_ _0921_ _0924_ VGND VGND VPWR VPWR _0925_ sky130_fd_sc_hd__nand2_1
XFILLER_0_67_429 VPWR VGND VPWR VGND sky130_ef_sc_hd__decap_12
X_2189_ reg_file.registers\[10\]\[15\] _0785_ _0786_ VGND VGND VPWR VPWR _0787_ sky130_fd_sc_hd__and3_1
XFILLER_0_39_109 VGND VGND VPWR VPWR sky130_fd_sc_hd__decap_3
XFILLER_0_50_307 VGND VGND VPWR VPWR sky130_fd_sc_hd__fill_1
XFILLER_0_7_261 VPWR VGND VPWR VGND sky130_ef_sc_hd__decap_12
XTAP_TAPCELL_ROW_46_527 VGND VPWR sky130_fd_sc_hd__tapvpwrvgnd_1
XTAP_TAPCELL_ROW_3_182 VGND VPWR sky130_fd_sc_hd__tapvpwrvgnd_1
XFILLER_0_58_418 VGND VGND VPWR VPWR sky130_fd_sc_hd__fill_2
XFILLER_0_38_197 VGND VGND VPWR VPWR sky130_fd_sc_hd__fill_1
XFILLER_0_38_120 VGND VGND VPWR VPWR sky130_fd_sc_hd__fill_1
XFILLER_0_14_15 VPWR VGND VPWR VGND sky130_ef_sc_hd__decap_12
XFILLER_0_41_329 VGND VGND VPWR VPWR sky130_fd_sc_hd__decap_6
X_3230_ _1693_ VGND VGND VPWR VPWR _0032_ sky130_fd_sc_hd__inv_2
X_2112_ _0704_ _0709_ VGND VGND VPWR VPWR _0710_ sky130_fd_sc_hd__nor2_1
XFILLER_0_39_78 VGND VGND VPWR VPWR sky130_fd_sc_hd__fill_1
X_3161_ _1656_ VGND VGND VPWR VPWR _0001_ sky130_fd_sc_hd__clkbuf_1
X_2043_ _0573_ _0637_ _0640_ VGND VGND VPWR VPWR _0641_ sky130_fd_sc_hd__a21o_1
X_3092_ _1407_ _1581_ _1583_ _1250_ _1591_ VGND VGND VPWR VPWR _1592_ sky130_fd_sc_hd__a221o_1
X_2876_ reg_file.registers\[11\]\[7\] _1449_ _1058_ VGND VGND VPWR VPWR _1450_ sky130_fd_sc_hd__mux2_1
XFILLER_0_44_145 VGND VGND VPWR VPWR sky130_fd_sc_hd__fill_1
XFILLER_0_44_134 VGND VGND VPWR VPWR sky130_fd_sc_hd__decap_6
X_2945_ _1498_ VGND VGND VPWR VPWR _0265_ sky130_fd_sc_hd__clkbuf_1
XTAP_TAPCELL_ROW_17_295 VGND VPWR sky130_fd_sc_hd__tapvpwrvgnd_1
X_1827_ _0486_ VGND VGND VPWR VPWR _0371_ sky130_fd_sc_hd__clkbuf_1
X_1758_ _0433_ VGND VGND VPWR VPWR _0387_ sky130_fd_sc_hd__clkbuf_1
X_3428_ _1718_ VGND VGND VPWR VPWR _0205_ sky130_fd_sc_hd__inv_2
XFILLER_0_4_253 VPWR VGND VPWR VGND sky130_ef_sc_hd__decap_12
XFILLER_0_20_80 VGND VGND VPWR VPWR sky130_fd_sc_hd__decap_4
XFILLER_0_20_91 VGND VGND VPWR VPWR sky130_fd_sc_hd__fill_1
XTAP_TAPCELL_ROW_68_696 VGND VPWR sky130_fd_sc_hd__tapvpwrvgnd_1
X_3359_ _1708_ VGND VGND VPWR VPWR _0146_ sky130_fd_sc_hd__inv_2
XTAP_TAPCELL_ROW_51_563 VGND VPWR sky130_fd_sc_hd__tapvpwrvgnd_1
XTAP_TAPCELL_ROW_0_152 VGND VPWR sky130_fd_sc_hd__tapvpwrvgnd_1
XFILLER_0_50_137 VGND VGND VPWR VPWR sky130_fd_sc_hd__decap_3
XFILLER_0_35_145 VGND VGND VPWR VPWR sky130_fd_sc_hd__fill_1
XTAP_TAPCELL_ROW_59_630 VGND VPWR sky130_fd_sc_hd__tapvpwrvgnd_1
XFILLER_0_31_373 VGND VGND VPWR VPWR sky130_fd_sc_hd__fill_1
XFILLER_0_58_204 VGND VGND VPWR VPWR sky130_fd_sc_hd__decap_4
X_2661_ _1002_ _0995_ _0734_ _1253_ VGND VGND VPWR VPWR _1254_ sky130_fd_sc_hd__a31o_1
XFILLER_0_54_421 VGND VGND VPWR VPWR sky130_fd_sc_hd__fill_2
XFILLER_0_41_104 VGND VGND VPWR VPWR sky130_fd_sc_hd__fill_1
XFILLER_0_41_68 VPWR VGND VPWR VGND sky130_ef_sc_hd__decap_12
XFILLER_0_26_112 VGND VGND VPWR VPWR sky130_fd_sc_hd__decap_8
X_2730_ _0869_ _0870_ VGND VGND VPWR VPWR _1320_ sky130_fd_sc_hd__nor2_1
XTAP_TAPCELL_ROW_14_265 VGND VPWR sky130_fd_sc_hd__tapvpwrvgnd_1
XFILLER_0_67_9 VGND VGND VPWR VPWR sky130_fd_sc_hd__fill_1
X_2592_ _0742_ _1187_ VGND VGND VPWR VPWR _1188_ sky130_fd_sc_hd__nand2_1
XFILLER_0_22_395 VPWR VGND VPWR VGND sky130_ef_sc_hd__decap_12
XFILLER_0_1_223 VGND VGND VPWR VPWR sky130_fd_sc_hd__fill_1
XFILLER_0_66_43 VGND VGND VPWR VPWR sky130_fd_sc_hd__fill_2
X_3144_ _1464_ _1588_ _1637_ _1640_ VGND VGND VPWR VPWR _1641_ sky130_fd_sc_hd__a22o_1
X_3075_ display.digit_sel\[1\] VGND VGND VPWR VPWR _1578_ sky130_fd_sc_hd__inv_2
XFILLER_0_5_57 VPWR VGND VPWR VGND sky130_ef_sc_hd__decap_12
X_3213_ _1684_ _1685_ VGND VGND VPWR VPWR _0015_ sky130_fd_sc_hd__nor2_1
XTAP_TAPCELL_ROW_65_677 VGND VPWR sky130_fd_sc_hd__tapvpwrvgnd_1
X_2026_ reg_file.registers\[5\]\[11\] _0563_ _0566_ reg_file.registers\[15\]\[11\]
+ _0623_ VGND VGND VPWR VPWR _0624_ sky130_fd_sc_hd__a221o_1
XFILLER_0_45_410 VPWR VGND VPWR VGND sky130_ef_sc_hd__decap_12
X_2859_ _0821_ _1431_ VGND VGND VPWR VPWR _1436_ sky130_fd_sc_hd__xor2_1
XPHY_EDGE_ROW_28_Left_100 VGND VGND VPWR VPWR sky130_fd_sc_hd__decap_3
XFILLER_0_17_167 VGND VGND VPWR VPWR sky130_fd_sc_hd__fill_1
X_2928_ _1489_ VGND VGND VPWR VPWR _0273_ sky130_fd_sc_hd__clkbuf_1
XTAP_TAPCELL_ROW_56_600 VGND VPWR sky130_fd_sc_hd__tapvpwrvgnd_1
XTAP_TAPCELL_ROW_28_379 VGND VPWR sky130_fd_sc_hd__tapvpwrvgnd_1
XFILLER_0_55_218 VGND VGND VPWR VPWR sky130_fd_sc_hd__decap_6
XFILLER_0_36_432 VGND VGND VPWR VPWR sky130_fd_sc_hd__decap_6
XFILLER_0_36_421 VGND VGND VPWR VPWR sky130_fd_sc_hd__decap_8
XFILLER_0_23_104 VGND VGND VPWR VPWR sky130_fd_sc_hd__decap_8
XFILLER_0_11_27 VPWR VGND VPWR VGND sky130_ef_sc_hd__decap_12
XTAP_TAPCELL_ROW_11_246 VGND VPWR sky130_fd_sc_hd__tapvpwrvgnd_1
XFILLER_0_23_159 VGND VGND VPWR VPWR sky130_fd_sc_hd__decap_8
XFILLER_0_39_281 VGND VGND VPWR VPWR sky130_fd_sc_hd__decap_8
X_2713_ _0990_ _1304_ VGND VGND VPWR VPWR _1305_ sky130_fd_sc_hd__nand2_1
X_2644_ _0953_ _1236_ _0949_ VGND VGND VPWR VPWR _1238_ sky130_fd_sc_hd__o21ai_1
X_2575_ reg_file.registers\[11\]\[2\] _0862_ _0863_ reg_file.registers\[10\]\[2\]
+ VGND VGND VPWR VPWR _1171_ sky130_fd_sc_hd__a22o_1
XFILLER_0_22_192 VGND VGND VPWR VPWR sky130_fd_sc_hd__decap_4
XFILLER_0_10_365 VPWR VGND VPWR VGND sky130_ef_sc_hd__decap_12
X_3127_ _1622_ _1581_ _1625_ VGND VGND VPWR VPWR _1626_ sky130_fd_sc_hd__a21o_1
X_3058_ _1191_ _1560_ _1022_ VGND VGND VPWR VPWR _1561_ sky130_fd_sc_hd__mux2_1
X_2009_ reg_file.registers\[2\]\[4\] _0463_ _0466_ reg_file.registers\[10\]\[4\] VGND
+ VGND VPWR VPWR _0607_ sky130_fd_sc_hd__a22o_1
XFILLER_0_45_251 VGND VGND VPWR VPWR sky130_fd_sc_hd__fill_1
XFILLER_0_33_413 VGND VGND VPWR VPWR sky130_fd_sc_hd__decap_4
XFILLER_0_13_181 VPWR VGND VPWR VGND sky130_ef_sc_hd__decap_12
XFILLER_0_28_229 VGND VGND VPWR VPWR sky130_fd_sc_hd__decap_4
XFILLER_0_22_15 VPWR VGND VPWR VGND sky130_ef_sc_hd__decap_12
XFILLER_0_36_273 VGND VGND VPWR VPWR sky130_fd_sc_hd__decap_8
XFILLER_0_3_329 VGND VGND VPWR VPWR sky130_fd_sc_hd__decap_6
X_2291_ _0888_ VGND VGND VPWR VPWR _0889_ sky130_fd_sc_hd__inv_2
X_2360_ _0957_ _0934_ _0933_ _0941_ VGND VGND VPWR VPWR _0958_ sky130_fd_sc_hd__a31o_1
XFILLER_0_59_321 VGND VGND VPWR VPWR sky130_fd_sc_hd__fill_1
XPHY_EDGE_ROW_10_Right_10 VGND VGND VPWR VPWR sky130_fd_sc_hd__decap_3
XFILLER_0_59_343 VGND VGND VPWR VPWR sky130_fd_sc_hd__fill_1
X_2627_ _1017_ _1104_ VGND VGND VPWR VPWR _1222_ sky130_fd_sc_hd__nor2_1
XFILLER_0_30_449 VGND VGND VPWR VPWR sky130_fd_sc_hd__fill_2
XTAP_TAPCELL_ROW_30_396 VGND VPWR sky130_fd_sc_hd__tapvpwrvgnd_1
XFILLER_0_6_189 VGND VGND VPWR VPWR sky130_fd_sc_hd__decap_6
X_2489_ reg_file.registers\[11\]\[6\] _1070_ _1072_ reg_file.registers\[10\]\[6\]
+ VGND VGND VPWR VPWR _1086_ sky130_fd_sc_hd__a22o_1
X_2558_ reg_file.registers\[11\]\[12\] _0927_ _0928_ reg_file.registers\[10\]\[12\]
+ VGND VGND VPWR VPWR _1154_ sky130_fd_sc_hd__a22o_1
XFILLER_0_10_195 VGND VGND VPWR VPWR sky130_fd_sc_hd__fill_1
XTAP_TAPCELL_ROW_38_463 VGND VPWR sky130_fd_sc_hd__tapvpwrvgnd_1
XFILLER_0_65_335 VGND VGND VPWR VPWR sky130_fd_sc_hd__fill_1
XFILLER_0_18_262 VGND VGND VPWR VPWR sky130_fd_sc_hd__fill_2
XFILLER_0_18_295 VGND VGND VPWR VPWR sky130_fd_sc_hd__decap_6
XFILLER_0_33_265 VPWR VGND VPWR VGND sky130_ef_sc_hd__decap_12
XFILLER_0_21_449 VGND VGND VPWR VPWR sky130_fd_sc_hd__fill_2
XFILLER_0_17_15 VPWR VGND VPWR VGND sky130_ef_sc_hd__decap_12
XFILLER_0_71_305 VGND VGND VPWR VPWR sky130_fd_sc_hd__decap_3
XFILLER_0_68_195 VGND VGND VPWR VPWR sky130_fd_sc_hd__fill_1
X_1860_ _0503_ VGND VGND VPWR VPWR _0355_ sky130_fd_sc_hd__clkbuf_1
XFILLER_0_71_349 VPWR VGND VPWR VGND sky130_ef_sc_hd__decap_12
X_3461_ clknet_leaf_7_clk _0230_ _0041_ VGND VGND VPWR VPWR imem.address\[16\] sky130_fd_sc_hd__dfrtp_1
X_1791_ imem.address\[17\] imem.address\[16\] imem.address\[15\] imem.address\[14\]
+ VGND VGND VPWR VPWR _0453_ sky130_fd_sc_hd__or4_1
X_3530_ clknet_leaf_13_clk _0292_ _0103_ VGND VGND VPWR VPWR reg_file.registers\[11\]\[14\]
+ sky130_fd_sc_hd__dfrtp_2
XPHY_EDGE_ROW_26_Left_98 VGND VGND VPWR VPWR sky130_fd_sc_hd__decap_3
XFILLER_0_3_137 VPWR VGND VPWR VGND sky130_ef_sc_hd__decap_12
X_2412_ _0907_ VGND VGND VPWR VPWR _1010_ sky130_fd_sc_hd__inv_2
X_3392_ _1713_ VGND VGND VPWR VPWR _0174_ sky130_fd_sc_hd__inv_2
X_2274_ _0869_ _0871_ VGND VGND VPWR VPWR _0872_ sky130_fd_sc_hd__xnor2_1
X_2343_ _0938_ _0939_ VGND VGND VPWR VPWR _0941_ sky130_fd_sc_hd__and2_1
XTAP_TAPCELL_ROW_35_433 VGND VPWR sky130_fd_sc_hd__tapvpwrvgnd_1
Xclkbuf_leaf_17_clk clknet_1_1__leaf_clk VGND VGND VPWR VPWR clknet_leaf_17_clk sky130_fd_sc_hd__clkbuf_8
XFILLER_0_47_379 VPWR VGND VPWR VGND sky130_ef_sc_hd__decap_12
X_1989_ _0575_ _0586_ _0580_ VGND VGND VPWR VPWR _0587_ sky130_fd_sc_hd__a21oi_2
X_3659_ clknet_leaf_17_clk _0011_ VGND VGND VPWR VPWR display.counter\[13\] sky130_fd_sc_hd__dfxtp_1
XFILLER_0_61_393 VPWR VGND VPWR VGND sky130_ef_sc_hd__decap_12
XFILLER_0_21_279 VGND VGND VPWR VPWR sky130_fd_sc_hd__fill_1
XTAP_TAPCELL_ROW_49_547 VGND VPWR sky130_fd_sc_hd__tapvpwrvgnd_1
XFILLER_0_44_46 VGND VGND VPWR VPWR sky130_fd_sc_hd__decap_8
XFILLER_0_71_124 VPWR VGND VPWR VGND sky130_ef_sc_hd__decap_12
XFILLER_0_71_113 VGND VGND VPWR VPWR sky130_fd_sc_hd__decap_8
X_2892_ _0748_ _1462_ _0758_ _1456_ _0988_ VGND VGND VPWR VPWR _1463_ sky130_fd_sc_hd__a311oi_2
X_2961_ _1506_ VGND VGND VPWR VPWR _0257_ sky130_fd_sc_hd__clkbuf_1
XFILLER_0_44_349 VPWR VGND VPWR VGND sky130_ef_sc_hd__decap_12
XFILLER_0_44_305 VGND VGND VPWR VPWR sky130_fd_sc_hd__decap_3
XFILLER_0_37_390 VGND VGND VPWR VPWR sky130_fd_sc_hd__fill_2
XTAP_TAPCELL_ROW_32_414 VGND VPWR sky130_fd_sc_hd__tapvpwrvgnd_1
XFILLER_0_29_324 VPWR VGND VPWR VGND sky130_ef_sc_hd__decap_12
X_1843_ reg_file.registers\[5\]\[21\] _0493_ VGND VGND VPWR VPWR _0495_ sky130_fd_sc_hd__and2_1
X_1912_ _0531_ VGND VGND VPWR VPWR _0331_ sky130_fd_sc_hd__clkbuf_1
XFILLER_0_69_65 VGND VGND VPWR VPWR sky130_fd_sc_hd__fill_1
Xclkbuf_leaf_6_clk clknet_1_0__leaf_clk VGND VGND VPWR VPWR clknet_leaf_6_clk sky130_fd_sc_hd__clkbuf_8
X_1774_ _0441_ VGND VGND VPWR VPWR _0379_ sky130_fd_sc_hd__clkbuf_1
X_3444_ _1557_ _1721_ VGND VGND VPWR VPWR _1722_ sky130_fd_sc_hd__or2_1
X_3513_ clknet_leaf_21_clk _0275_ _0086_ VGND VGND VPWR VPWR reg_file.registers\[15\]\[29\]
+ sky130_fd_sc_hd__dfrtp_1
X_3375_ _1711_ VGND VGND VPWR VPWR _0159_ sky130_fd_sc_hd__inv_2
X_2257_ _0852_ _0854_ _0789_ VGND VGND VPWR VPWR _0855_ sky130_fd_sc_hd__o21a_1
X_2326_ _0879_ _0880_ _0923_ VGND VGND VPWR VPWR _0924_ sky130_fd_sc_hd__a21o_1
XFILLER_0_26_3 VPWR VGND VPWR VGND sky130_ef_sc_hd__decap_12
X_2188_ _0732_ VGND VGND VPWR VPWR _0786_ sky130_fd_sc_hd__buf_2
XFILLER_0_70_190 VGND VGND VPWR VPWR sky130_fd_sc_hd__decap_6
XFILLER_0_50_319 VGND VGND VPWR VPWR sky130_fd_sc_hd__decap_3
XFILLER_0_7_273 VGND VGND VPWR VPWR sky130_fd_sc_hd__decap_6
XTAP_TAPCELL_ROW_3_183 VGND VPWR sky130_fd_sc_hd__tapvpwrvgnd_1
XFILLER_0_14_27 VGND VGND VPWR VPWR sky130_fd_sc_hd__fill_1
XFILLER_0_53_113 VGND VGND VPWR VPWR sky130_fd_sc_hd__decap_4
XFILLER_0_30_15 VPWR VGND VPWR VGND sky130_ef_sc_hd__decap_12
XFILLER_0_39_35 VGND VGND VPWR VPWR sky130_fd_sc_hd__decap_3
XFILLER_0_1_449 VGND VGND VPWR VPWR sky130_fd_sc_hd__fill_2
XFILLER_0_1_405 VPWR VGND VPWR VGND sky130_ef_sc_hd__decap_12
X_2111_ _0579_ _0617_ _0614_ VGND VGND VPWR VPWR _0709_ sky130_fd_sc_hd__o21a_1
X_2042_ _0573_ _0639_ _0578_ VGND VGND VPWR VPWR _0640_ sky130_fd_sc_hd__a21o_1
X_3091_ _1578_ _1584_ _1375_ _1590_ VGND VGND VPWR VPWR _1591_ sky130_fd_sc_hd__a31o_1
X_3160_ _1652_ _1654_ _1655_ VGND VGND VPWR VPWR _1656_ sky130_fd_sc_hd__or3b_4
XFILLER_0_57_441 VGND VGND VPWR VPWR sky130_fd_sc_hd__decap_6
XPHY_EDGE_ROW_8_Right_8 VGND VGND VPWR VPWR sky130_fd_sc_hd__decap_3
X_2875_ _0752_ _1331_ _1448_ _1063_ VGND VGND VPWR VPWR _1449_ sky130_fd_sc_hd__a22o_1
XFILLER_0_44_113 VGND VGND VPWR VPWR sky130_fd_sc_hd__fill_1
X_2944_ reg_file.registers\[15\]\[19\] _1495_ VGND VGND VPWR VPWR _1498_ sky130_fd_sc_hd__and2_1
XFILLER_0_29_165 VGND VGND VPWR VPWR sky130_fd_sc_hd__decap_3
XFILLER_0_4_265 VPWR VGND VPWR VGND sky130_ef_sc_hd__decap_12
XFILLER_0_4_221 VPWR VGND VPWR VGND sky130_ef_sc_hd__decap_12
X_1826_ reg_file.registers\[5\]\[29\] _0483_ VGND VGND VPWR VPWR _0486_ sky130_fd_sc_hd__and2_1
XFILLER_0_17_305 VGND VGND VPWR VPWR sky130_fd_sc_hd__decap_4
XPHY_EDGE_ROW_39_Right_39 VGND VGND VPWR VPWR sky130_fd_sc_hd__decap_3
XFILLER_0_40_363 VGND VGND VPWR VPWR sky130_fd_sc_hd__fill_1
XFILLER_0_40_341 VPWR VGND VPWR VGND sky130_ef_sc_hd__decap_12
X_1757_ reg_file.registers\[2\]\[14\] VGND VGND VPWR VPWR _0433_ sky130_fd_sc_hd__clkbuf_1
X_3427_ _1718_ VGND VGND VPWR VPWR _0204_ sky130_fd_sc_hd__inv_2
X_3358_ _1708_ VGND VGND VPWR VPWR _0145_ sky130_fd_sc_hd__inv_2
XTAP_TAPCELL_ROW_68_697 VGND VPWR sky130_fd_sc_hd__tapvpwrvgnd_1
XFILLER_0_67_216 VGND VGND VPWR VPWR sky130_fd_sc_hd__fill_2
X_2309_ reg_file.registers\[11\]\[16\] _0693_ _0697_ reg_file.registers\[10\]\[16\]
+ VGND VGND VPWR VPWR _0907_ sky130_fd_sc_hd__a22o_1
XFILLER_0_29_90 VGND VGND VPWR VPWR sky130_fd_sc_hd__fill_2
XTAP_TAPCELL_ROW_0_153 VGND VPWR sky130_fd_sc_hd__tapvpwrvgnd_1
XPHY_EDGE_ROW_13_Left_85 VGND VGND VPWR VPWR sky130_fd_sc_hd__decap_3
X_3289_ _1698_ VGND VGND VPWR VPWR _0086_ sky130_fd_sc_hd__inv_2
XTAP_TAPCELL_ROW_51_564 VGND VPWR sky130_fd_sc_hd__tapvpwrvgnd_1
XPHY_EDGE_ROW_48_Right_48 VGND VGND VPWR VPWR sky130_fd_sc_hd__decap_3
XFILLER_0_35_113 VGND VGND VPWR VPWR sky130_fd_sc_hd__fill_1
XPHY_EDGE_ROW_57_Right_57 VGND VGND VPWR VPWR sky130_fd_sc_hd__decap_3
XTAP_TAPCELL_ROW_8_220 VGND VPWR sky130_fd_sc_hd__tapvpwrvgnd_1
XTAP_TAPCELL_ROW_59_631 VGND VPWR sky130_fd_sc_hd__tapvpwrvgnd_1
XPHY_EDGE_ROW_66_Right_66 VGND VGND VPWR VPWR sky130_fd_sc_hd__decap_3
XFILLER_0_25_15 VGND VGND VPWR VPWR sky130_fd_sc_hd__decap_4
X_2660_ _1002_ _1252_ VGND VGND VPWR VPWR _1253_ sky130_fd_sc_hd__nor2_1
XFILLER_0_54_411 VGND VGND VPWR VPWR sky130_fd_sc_hd__decap_8
XFILLER_0_41_116 VPWR VGND VPWR VGND sky130_ef_sc_hd__decap_12
XFILLER_0_26_157 VGND VGND VPWR VPWR sky130_fd_sc_hd__fill_1
XTAP_TAPCELL_ROW_14_266 VGND VPWR sky130_fd_sc_hd__tapvpwrvgnd_1
XFILLER_0_14_319 VGND VGND VPWR VPWR sky130_fd_sc_hd__decap_3
X_2591_ _1018_ _1009_ _1186_ VGND VGND VPWR VPWR _1187_ sky130_fd_sc_hd__o21ai_1
XFILLER_0_22_374 VGND VGND VPWR VPWR sky130_fd_sc_hd__fill_1
XFILLER_0_22_363 VGND VGND VPWR VPWR sky130_fd_sc_hd__fill_1
XFILLER_0_5_69 VPWR VGND VPWR VGND sky130_ef_sc_hd__decap_12
XFILLER_0_1_279 VGND VGND VPWR VPWR sky130_fd_sc_hd__fill_1
X_3212_ display.counter\[16\] _1682_ display.counter\[17\] VGND VGND VPWR VPWR _1685_
+ sky130_fd_sc_hd__a21oi_1
XFILLER_0_66_55 VPWR VGND VPWR VGND sky130_ef_sc_hd__decap_12
X_3143_ _1340_ _1394_ _1639_ VGND VGND VPWR VPWR _1640_ sky130_fd_sc_hd__o21ai_1
X_2025_ reg_file.registers\[2\]\[11\] _0557_ VGND VGND VPWR VPWR _0623_ sky130_fd_sc_hd__and2_1
X_3074_ _1570_ _1576_ _1329_ VGND VGND VPWR VPWR _1577_ sky130_fd_sc_hd__a21o_1
XTAP_TAPCELL_ROW_65_678 VGND VPWR sky130_fd_sc_hd__tapvpwrvgnd_1
XFILLER_0_45_422 VGND VGND VPWR VPWR sky130_fd_sc_hd__decap_4
XFILLER_0_15_92 VGND VGND VPWR VPWR sky130_fd_sc_hd__decap_4
XFILLER_0_17_102 VGND VGND VPWR VPWR sky130_fd_sc_hd__fill_2
X_2927_ reg_file.registers\[15\]\[27\] _1484_ VGND VGND VPWR VPWR _1489_ sky130_fd_sc_hd__and2_1
X_1809_ imem.address\[5\] _0457_ _0458_ _0455_ VGND VGND VPWR VPWR _0471_ sky130_fd_sc_hd__or4bb_1
X_2858_ _1435_ VGND VGND VPWR VPWR _0289_ sky130_fd_sc_hd__clkbuf_1
X_2789_ _1064_ _1371_ _1372_ _1374_ VGND VGND VPWR VPWR _1375_ sky130_fd_sc_hd__a22o_1
XFILLER_0_13_352 VGND VGND VPWR VPWR sky130_fd_sc_hd__decap_3
XFILLER_0_40_182 VPWR VGND VPWR VGND sky130_ef_sc_hd__decap_12
XTAP_TAPCELL_ROW_56_601 VGND VPWR sky130_fd_sc_hd__tapvpwrvgnd_1
XFILLER_0_11_39 VPWR VGND VPWR VGND sky130_ef_sc_hd__decap_12
XTAP_TAPCELL_ROW_11_247 VGND VPWR sky130_fd_sc_hd__tapvpwrvgnd_1
XTAP_TAPCELL_ROW_62_648 VGND VPWR sky130_fd_sc_hd__tapvpwrvgnd_1
XFILLER_0_52_35 VGND VGND VPWR VPWR sky130_fd_sc_hd__fill_1
X_2574_ _1162_ _1169_ _1013_ VGND VGND VPWR VPWR _1170_ sky130_fd_sc_hd__mux2_1
X_2712_ _1303_ _1161_ _1013_ VGND VGND VPWR VPWR _1304_ sky130_fd_sc_hd__mux2_1
X_2643_ _0949_ _0953_ _1236_ VGND VGND VPWR VPWR _1237_ sky130_fd_sc_hd__or3_1
XFILLER_0_10_355 VGND VGND VPWR VPWR sky130_fd_sc_hd__decap_8
XFILLER_0_10_377 VGND VGND VPWR VPWR sky130_fd_sc_hd__fill_2
X_2008_ _0605_ VGND VGND VPWR VPWR _0606_ sky130_fd_sc_hd__buf_6
X_3126_ _1557_ _1391_ _1558_ _1624_ VGND VGND VPWR VPWR _1625_ sky130_fd_sc_hd__a31o_1
X_3057_ _0922_ _0880_ _1153_ VGND VGND VPWR VPWR _1560_ sky130_fd_sc_hd__mux2_1
XFILLER_0_60_244 VGND VGND VPWR VPWR sky130_fd_sc_hd__decap_8
XFILLER_0_5_393 VPWR VGND VPWR VGND sky130_ef_sc_hd__decap_12
XFILLER_0_13_193 VPWR VGND VPWR VGND sky130_ef_sc_hd__decap_12
XTAP_TAPCELL_ROW_24_350 VGND VPWR sky130_fd_sc_hd__tapvpwrvgnd_1
XFILLER_0_22_27 VGND VGND VPWR VPWR sky130_fd_sc_hd__fill_1
XFILLER_0_51_299 VGND VGND VPWR VPWR sky130_fd_sc_hd__fill_2
XPHY_EDGE_ROW_47_Left_119 VGND VGND VPWR VPWR sky130_fd_sc_hd__decap_3
XFILLER_0_24_414 VGND VGND VPWR VPWR sky130_fd_sc_hd__decap_6
XFILLER_0_47_57 VGND VGND VPWR VPWR sky130_fd_sc_hd__fill_1
X_2290_ reg_file.registers\[11\]\[19\] _0790_ _0791_ reg_file.registers\[10\]\[19\]
+ VGND VGND VPWR VPWR _0888_ sky130_fd_sc_hd__a22o_1
XFILLER_0_63_12 VGND VGND VPWR VPWR sky130_fd_sc_hd__fill_1
XPHY_EDGE_ROW_56_Left_128 VGND VGND VPWR VPWR sky130_fd_sc_hd__decap_3
XFILLER_0_2_15 VPWR VGND VPWR VGND sky130_ef_sc_hd__decap_12
XFILLER_0_59_388 VGND VGND VPWR VPWR sky130_fd_sc_hd__decap_4
XPHY_EDGE_ROW_65_Left_137 VGND VGND VPWR VPWR sky130_fd_sc_hd__decap_3
XFILLER_0_56_3 VPWR VGND VPWR VGND sky130_ef_sc_hd__decap_12
X_2557_ _1152_ VGND VGND VPWR VPWR _1153_ sky130_fd_sc_hd__clkbuf_4
X_2626_ _1215_ _1220_ _1108_ VGND VGND VPWR VPWR _1221_ sky130_fd_sc_hd__mux2_1
XFILLER_0_42_244 VGND VGND VPWR VPWR sky130_fd_sc_hd__decap_8
XTAP_TAPCELL_ROW_30_397 VGND VPWR sky130_fd_sc_hd__tapvpwrvgnd_1
XFILLER_0_2_363 VGND VGND VPWR VPWR sky130_fd_sc_hd__fill_1
XFILLER_0_10_141 VPWR VGND VPWR VGND sky130_ef_sc_hd__decap_12
X_2488_ reg_file.registers\[11\]\[5\] _1071_ _1073_ reg_file.registers\[10\]\[5\]
+ VGND VGND VPWR VPWR _1085_ sky130_fd_sc_hd__a22o_1
XFILLER_0_65_303 VGND VGND VPWR VPWR sky130_fd_sc_hd__fill_1
X_3109_ _1468_ _0408_ _1593_ _1607_ VGND VGND VPWR VPWR _1608_ sky130_fd_sc_hd__a2bb2o_2
XFILLER_0_33_277 VGND VGND VPWR VPWR sky130_fd_sc_hd__decap_3
XFILLER_0_18_274 VGND VGND VPWR VPWR sky130_fd_sc_hd__fill_1
XTAP_TAPCELL_ROW_21_320 VGND VPWR sky130_fd_sc_hd__tapvpwrvgnd_1
XPHY_EDGE_ROW_1_Left_73 VGND VGND VPWR VPWR sky130_fd_sc_hd__decap_3
XFILLER_0_17_27 VPWR VGND VPWR VGND sky130_ef_sc_hd__decap_12
X_1790_ imem.address\[13\] imem.address\[12\] imem.address\[11\] imem.address\[10\]
+ VGND VGND VPWR VPWR _0452_ sky130_fd_sc_hd__or4_1
X_3460_ clknet_leaf_7_clk _0229_ _0040_ VGND VGND VPWR VPWR imem.address\[15\] sky130_fd_sc_hd__dfrtp_1
XFILLER_0_58_45 VGND VGND VPWR VPWR sky130_fd_sc_hd__fill_1
X_2411_ _0894_ _1008_ _0995_ VGND VGND VPWR VPWR _1009_ sky130_fd_sc_hd__mux2_1
X_3391_ _1713_ VGND VGND VPWR VPWR _0173_ sky130_fd_sc_hd__inv_2
XFILLER_0_3_149 VPWR VGND VPWR VGND sky130_ef_sc_hd__decap_12
XFILLER_0_3_105 VGND VGND VPWR VPWR sky130_fd_sc_hd__decap_6
XFILLER_0_12_417 VGND VGND VPWR VPWR sky130_fd_sc_hd__decap_3
X_2273_ _0870_ VGND VGND VPWR VPWR _0871_ sky130_fd_sc_hd__inv_2
X_2342_ _0938_ _0939_ VGND VGND VPWR VPWR _0940_ sky130_fd_sc_hd__nor2_1
XFILLER_0_47_325 VGND VGND VPWR VPWR sky130_fd_sc_hd__decap_6
XTAP_TAPCELL_ROW_35_434 VGND VPWR sky130_fd_sc_hd__tapvpwrvgnd_1
XFILLER_0_62_306 VGND VGND VPWR VPWR sky130_fd_sc_hd__fill_2
XFILLER_0_30_203 VGND VGND VPWR VPWR sky130_fd_sc_hd__decap_8
XFILLER_0_7_444 VGND VGND VPWR VPWR sky130_fd_sc_hd__decap_4
X_1988_ reg_file.registers\[5\]\[24\] _0564_ _0568_ reg_file.registers\[15\]\[24\]
+ _0585_ VGND VGND VPWR VPWR _0586_ sky130_fd_sc_hd__a221o_1
X_3589_ clknet_leaf_3_clk _0351_ _0162_ VGND VGND VPWR VPWR reg_file.registers\[5\]\[9\]
+ sky130_fd_sc_hd__dfrtp_1
X_2609_ _1203_ _0988_ _1204_ VGND VGND VPWR VPWR _1205_ sky130_fd_sc_hd__nor3_1
X_3658_ clknet_leaf_17_clk _0010_ VGND VGND VPWR VPWR display.counter\[12\] sky130_fd_sc_hd__dfxtp_1
XFILLER_0_65_133 VGND VGND VPWR VPWR sky130_fd_sc_hd__fill_2
XFILLER_0_65_111 VGND VGND VPWR VPWR sky130_fd_sc_hd__fill_1
XFILLER_0_61_383 VGND VGND VPWR VPWR sky130_fd_sc_hd__decap_8
XFILLER_0_46_380 VPWR VGND VPWR VGND sky130_ef_sc_hd__decap_12
XFILLER_0_21_236 VGND VGND VPWR VPWR sky130_fd_sc_hd__fill_1
XTAP_TAPCELL_ROW_49_548 VGND VPWR sky130_fd_sc_hd__tapvpwrvgnd_1
XFILLER_0_28_37 VGND VGND VPWR VPWR sky130_fd_sc_hd__fill_1
XFILLER_0_28_15 VGND VGND VPWR VPWR sky130_fd_sc_hd__decap_8
X_2960_ reg_file.registers\[15\]\[11\] _1483_ VGND VGND VPWR VPWR _1506_ sky130_fd_sc_hd__and2_1
XFILLER_0_71_169 VPWR VGND VPWR VGND sky130_ef_sc_hd__decap_12
XFILLER_0_71_136 VGND VGND VPWR VPWR sky130_fd_sc_hd__decap_4
X_2891_ _0740_ _0746_ VGND VGND VPWR VPWR _1462_ sky130_fd_sc_hd__nand2_1
X_1773_ reg_file.registers\[2\]\[6\] VGND VGND VPWR VPWR _0441_ sky130_fd_sc_hd__clkbuf_1
XTAP_TAPCELL_ROW_32_415 VGND VPWR sky130_fd_sc_hd__tapvpwrvgnd_1
XFILLER_0_29_358 VPWR VGND VPWR VGND sky130_ef_sc_hd__decap_12
X_1842_ _0494_ VGND VGND VPWR VPWR _0364_ sky130_fd_sc_hd__clkbuf_1
X_1911_ reg_file.registers\[10\]\[21\] _0528_ VGND VGND VPWR VPWR _0531_ sky130_fd_sc_hd__and2_1
XFILLER_0_69_99 VPWR VGND VPWR VGND sky130_ef_sc_hd__decap_12
XFILLER_0_69_55 VGND VGND VPWR VPWR sky130_fd_sc_hd__fill_1
X_3374_ _1711_ VGND VGND VPWR VPWR _0158_ sky130_fd_sc_hd__inv_2
X_3443_ _1720_ _1721_ VGND VGND VPWR VPWR _0406_ sky130_fd_sc_hd__nor2_1
X_3512_ clknet_leaf_20_clk _0274_ _0085_ VGND VGND VPWR VPWR reg_file.registers\[15\]\[28\]
+ sky130_fd_sc_hd__dfrtp_1
X_2187_ net19 VGND VGND VPWR VPWR _0785_ sky130_fd_sc_hd__buf_2
X_2256_ _0794_ _0853_ VGND VGND VPWR VPWR _0854_ sky130_fd_sc_hd__nor2_1
X_2325_ _0873_ _0922_ VGND VGND VPWR VPWR _0923_ sky130_fd_sc_hd__and2b_1
XFILLER_0_19_3 VPWR VGND VPWR VGND sky130_ef_sc_hd__decap_12
XTAP_TAPCELL_ROW_54_584 VGND VPWR sky130_fd_sc_hd__tapvpwrvgnd_1
XFILLER_0_53_103 VGND VGND VPWR VPWR sky130_fd_sc_hd__decap_8
XFILLER_0_30_27 VGND VGND VPWR VPWR sky130_fd_sc_hd__fill_1
XFILLER_0_1_417 VPWR VGND VPWR VGND sky130_ef_sc_hd__decap_12
X_2110_ _0706_ _0707_ VGND VGND VPWR VPWR _0708_ sky130_fd_sc_hd__nor2_1
X_3090_ _1559_ _1589_ VGND VGND VPWR VPWR _1590_ sky130_fd_sc_hd__or2_1
X_2041_ reg_file.registers\[5\]\[13\] _0563_ _0567_ reg_file.registers\[15\]\[13\]
+ _0638_ VGND VGND VPWR VPWR _0639_ sky130_fd_sc_hd__a221o_1
X_2943_ _1497_ VGND VGND VPWR VPWR _0266_ sky130_fd_sc_hd__clkbuf_1
X_2874_ _1446_ _1447_ VGND VGND VPWR VPWR _1448_ sky130_fd_sc_hd__xnor2_1
XFILLER_0_40_353 VGND VGND VPWR VPWR sky130_fd_sc_hd__decap_3
X_1756_ _0432_ VGND VGND VPWR VPWR _0388_ sky130_fd_sc_hd__clkbuf_1
XFILLER_0_32_309 VGND VGND VPWR VPWR sky130_fd_sc_hd__decap_6
X_1825_ _0485_ VGND VGND VPWR VPWR _0372_ sky130_fd_sc_hd__clkbuf_1
XFILLER_0_25_361 VGND VGND VPWR VPWR sky130_fd_sc_hd__fill_1
XFILLER_0_4_277 VPWR VGND VPWR VGND sky130_ef_sc_hd__decap_12
XFILLER_0_4_233 VPWR VGND VPWR VGND sky130_ef_sc_hd__decap_12
XFILLER_0_40_386 VGND VGND VPWR VPWR sky130_fd_sc_hd__decap_8
X_2308_ _0781_ _0898_ VGND VGND VPWR VPWR _0906_ sky130_fd_sc_hd__xor2_1
X_3426_ _1718_ VGND VGND VPWR VPWR _0203_ sky130_fd_sc_hd__inv_2
X_3357_ _1708_ VGND VGND VPWR VPWR _0144_ sky130_fd_sc_hd__inv_2
XTAP_TAPCELL_ROW_68_698 VGND VPWR sky130_fd_sc_hd__tapvpwrvgnd_1
X_2239_ _0835_ _0836_ VGND VGND VPWR VPWR _0837_ sky130_fd_sc_hd__nand2_1
XTAP_TAPCELL_ROW_0_154 VGND VPWR sky130_fd_sc_hd__tapvpwrvgnd_1
X_3288_ _1698_ VGND VGND VPWR VPWR _0085_ sky130_fd_sc_hd__inv_2
XTAP_TAPCELL_ROW_51_565 VGND VPWR sky130_fd_sc_hd__tapvpwrvgnd_1
XFILLER_0_35_169 VPWR VGND VPWR VGND sky130_ef_sc_hd__decap_12
XFILLER_0_0_81 VGND VGND VPWR VPWR sky130_fd_sc_hd__decap_3
XFILLER_0_43_180 VGND VGND VPWR VPWR sky130_fd_sc_hd__decap_6
XFILLER_0_8_3 VPWR VGND VPWR VGND sky130_ef_sc_hd__decap_12
XTAP_TAPCELL_ROW_8_221 VGND VPWR sky130_fd_sc_hd__tapvpwrvgnd_1
XFILLER_0_66_250 VGND VGND VPWR VPWR sky130_fd_sc_hd__fill_2
XFILLER_0_41_15 VGND VGND VPWR VPWR sky130_fd_sc_hd__fill_2
XFILLER_0_41_128 VPWR VGND VPWR VGND sky130_ef_sc_hd__decap_12
XFILLER_0_34_191 VGND VGND VPWR VPWR sky130_fd_sc_hd__fill_2
X_2590_ _1018_ _1001_ VGND VGND VPWR VPWR _1186_ sky130_fd_sc_hd__nand2_1
XFILLER_0_26_147 VGND VGND VPWR VPWR sky130_fd_sc_hd__decap_6
XFILLER_0_1_225 VPWR VGND VPWR VGND sky130_ef_sc_hd__decap_12
XTAP_TAPCELL_ROW_14_267 VGND VPWR sky130_fd_sc_hd__tapvpwrvgnd_1
XFILLER_0_14_309 VGND VGND VPWR VPWR sky130_fd_sc_hd__decap_4
XFILLER_0_66_67 VPWR VGND VPWR VGND sky130_ef_sc_hd__decap_12
X_3142_ _1638_ _1075_ _0988_ VGND VGND VPWR VPWR _1639_ sky130_fd_sc_hd__a21o_1
XFILLER_0_5_15 VPWR VGND VPWR VGND sky130_ef_sc_hd__decap_12
X_3211_ display.counter\[16\] display.counter\[17\] _1682_ VGND VGND VPWR VPWR _1684_
+ sky130_fd_sc_hd__and3_1
XTAP_TAPCELL_ROW_65_679 VGND VPWR sky130_fd_sc_hd__tapvpwrvgnd_1
X_2024_ _0621_ _0617_ _0614_ VGND VGND VPWR VPWR _0622_ sky130_fd_sc_hd__or3_4
XFILLER_0_49_217 VGND VGND VPWR VPWR sky130_fd_sc_hd__fill_1
X_3073_ _1199_ _0991_ _1574_ _1575_ VGND VGND VPWR VPWR _1576_ sky130_fd_sc_hd__o31ai_1
X_2857_ reg_file.registers\[11\]\[11\] _1434_ _1376_ VGND VGND VPWR VPWR _1435_ sky130_fd_sc_hd__mux2_1
XFILLER_0_15_60 VPWR VGND VPWR VGND sky130_ef_sc_hd__decap_12
XFILLER_0_15_82 VGND VGND VPWR VPWR sky130_fd_sc_hd__decap_6
XFILLER_0_17_169 VGND VGND VPWR VPWR sky130_fd_sc_hd__decap_4
X_2926_ _1488_ VGND VGND VPWR VPWR _0274_ sky130_fd_sc_hd__clkbuf_1
X_1808_ imem.address\[5\] _0455_ _0457_ _0458_ VGND VGND VPWR VPWR _0470_ sky130_fd_sc_hd__or4b_1
XFILLER_0_40_194 VGND VGND VPWR VPWR sky130_fd_sc_hd__fill_2
X_2788_ _0752_ _1373_ VGND VGND VPWR VPWR _1374_ sky130_fd_sc_hd__nand2_1
XFILLER_0_32_139 VGND VGND VPWR VPWR sky130_fd_sc_hd__fill_1
X_1739_ reg_file.registers\[2\]\[23\] VGND VGND VPWR VPWR _0424_ sky130_fd_sc_hd__clkbuf_1
XFILLER_0_13_342 VGND VGND VPWR VPWR sky130_fd_sc_hd__fill_1
XFILLER_0_13_397 VGND VGND VPWR VPWR sky130_fd_sc_hd__fill_1
XFILLER_0_13_386 VGND VGND VPWR VPWR sky130_fd_sc_hd__decap_6
XTAP_TAPCELL_ROW_56_602 VGND VPWR sky130_fd_sc_hd__tapvpwrvgnd_1
X_3409_ _1714_ VGND VGND VPWR VPWR _1717_ sky130_fd_sc_hd__buf_4
XFILLER_0_8_391 VPWR VGND VPWR VGND sky130_ef_sc_hd__decap_12
XFILLER_0_31_150 VPWR VGND VPWR VGND sky130_ef_sc_hd__decap_12
XFILLER_0_36_26 VGND VGND VPWR VPWR sky130_fd_sc_hd__fill_2
XFILLER_0_36_15 VGND VGND VPWR VPWR sky130_fd_sc_hd__decap_8
XTAP_TAPCELL_ROW_19_304 VGND VPWR sky130_fd_sc_hd__tapvpwrvgnd_1
XTAP_TAPCELL_ROW_62_649 VGND VPWR sky130_fd_sc_hd__tapvpwrvgnd_1
XFILLER_0_46_209 VGND VGND VPWR VPWR sky130_fd_sc_hd__decap_4
X_2711_ _1300_ _1302_ _1003_ VGND VGND VPWR VPWR _1303_ sky130_fd_sc_hd__mux2_1
XFILLER_0_39_250 VPWR VGND VPWR VGND sky130_ef_sc_hd__decap_12
XFILLER_0_27_445 VGND VGND VPWR VPWR sky130_fd_sc_hd__decap_3
XTAP_TAPCELL_ROW_27_370 VGND VPWR sky130_fd_sc_hd__tapvpwrvgnd_1
X_2573_ _1165_ _1168_ net46 VGND VGND VPWR VPWR _1169_ sky130_fd_sc_hd__mux2_1
XFILLER_0_22_183 VGND VGND VPWR VPWR sky130_fd_sc_hd__fill_2
X_2642_ _1235_ _0936_ _0954_ _0957_ VGND VGND VPWR VPWR _1236_ sky130_fd_sc_hd__o211a_1
X_3125_ _1459_ _1588_ _1623_ _1559_ VGND VGND VPWR VPWR _1624_ sky130_fd_sc_hd__a211o_1
X_2007_ _0604_ _0597_ _0600_ _0594_ VGND VGND VPWR VPWR _0605_ sky130_fd_sc_hd__or4_4
X_3056_ _1559_ VGND VGND VPWR VPWR _0408_ sky130_fd_sc_hd__inv_2
XFILLER_0_9_111 VGND VGND VPWR VPWR sky130_fd_sc_hd__fill_1
XFILLER_0_18_401 VGND VGND VPWR VPWR sky130_fd_sc_hd__decap_3
X_2909_ reg_file.registers\[11\]\[1\] _1476_ _1058_ VGND VGND VPWR VPWR _1477_ sky130_fd_sc_hd__mux2_1
XFILLER_0_36_253 VGND VGND VPWR VPWR sky130_fd_sc_hd__decap_4
XTAP_TAPCELL_ROW_24_351 VGND VPWR sky130_fd_sc_hd__tapvpwrvgnd_1
XFILLER_0_24_426 VGND VGND VPWR VPWR sky130_fd_sc_hd__decap_3
XFILLER_0_63_35 VGND VGND VPWR VPWR sky130_fd_sc_hd__fill_1
XFILLER_0_2_27 VGND VGND VPWR VPWR sky130_fd_sc_hd__fill_1
XFILLER_0_27_253 VGND VGND VPWR VPWR sky130_fd_sc_hd__decap_8
XFILLER_0_12_83 VGND VGND VPWR VPWR sky130_fd_sc_hd__fill_1
X_2487_ _1068_ _1081_ _1083_ VGND VGND VPWR VPWR _1084_ sky130_fd_sc_hd__a21oi_1
X_2556_ net56 VGND VGND VPWR VPWR _1152_ sky130_fd_sc_hd__inv_2
X_2625_ _1219_ VGND VGND VPWR VPWR _1220_ sky130_fd_sc_hd__inv_2
XFILLER_0_42_278 VPWR VGND VPWR VGND sky130_ef_sc_hd__decap_12
XTAP_TAPCELL_ROW_30_398 VGND VPWR sky130_fd_sc_hd__tapvpwrvgnd_1
XFILLER_0_10_153 VPWR VGND VPWR VGND sky130_ef_sc_hd__decap_12
XFILLER_0_49_3 VGND VGND VPWR VPWR sky130_fd_sc_hd__decap_8
X_3108_ _0989_ _1603_ _1606_ _0415_ VGND VGND VPWR VPWR _1607_ sky130_fd_sc_hd__a31o_1
XFILLER_0_10_197 VPWR VGND VPWR VGND sky130_ef_sc_hd__decap_12
X_3039_ imem.address\[10\] _1522_ VGND VGND VPWR VPWR _0224_ sky130_fd_sc_hd__xor2_1
XFILLER_0_65_337 VGND VGND VPWR VPWR sky130_fd_sc_hd__decap_4
XFILLER_0_53_90 VGND VGND VPWR VPWR sky130_fd_sc_hd__decap_4
XTAP_TAPCELL_ROW_21_321 VGND VPWR sky130_fd_sc_hd__tapvpwrvgnd_1
XFILLER_0_33_223 VGND VGND VPWR VPWR sky130_fd_sc_hd__fill_1
XFILLER_0_17_39 VGND VGND VPWR VPWR sky130_fd_sc_hd__decap_8
XFILLER_0_64_381 VGND VGND VPWR VPWR sky130_fd_sc_hd__fill_2
XFILLER_0_58_68 VGND VGND VPWR VPWR sky130_fd_sc_hd__decap_4
X_2410_ reg_file.registers\[11\]\[19\] _0694_ _1007_ VGND VGND VPWR VPWR _1008_ sky130_fd_sc_hd__a21oi_1
X_3390_ _1710_ VGND VGND VPWR VPWR _1713_ sky130_fd_sc_hd__buf_4
X_2341_ reg_file.registers\[11\]\[25\] _0693_ _0698_ reg_file.registers\[10\]\[25\]
+ VGND VGND VPWR VPWR _0939_ sky130_fd_sc_hd__a22o_1
X_2272_ reg_file.registers\[11\]\[22\] _0693_ _0698_ reg_file.registers\[10\]\[22\]
+ VGND VGND VPWR VPWR _0870_ sky130_fd_sc_hd__a22oi_4
XFILLER_0_59_197 VGND VGND VPWR VPWR sky130_fd_sc_hd__fill_2
XTAP_TAPCELL_ROW_35_435 VGND VPWR sky130_fd_sc_hd__tapvpwrvgnd_1
XFILLER_0_7_423 VPWR VGND VPWR VGND sky130_ef_sc_hd__decap_12
XFILLER_0_30_237 VPWR VGND VPWR VGND sky130_ef_sc_hd__decap_12
X_3657_ clknet_leaf_17_clk _0009_ VGND VGND VPWR VPWR display.counter\[11\] sky130_fd_sc_hd__dfxtp_1
XFILLER_0_15_223 VGND VGND VPWR VPWR sky130_fd_sc_hd__fill_1
XFILLER_0_15_278 VGND VGND VPWR VPWR sky130_fd_sc_hd__fill_2
X_1987_ reg_file.registers\[2\]\[24\] _0559_ VGND VGND VPWR VPWR _0585_ sky130_fd_sc_hd__and2_1
X_3588_ clknet_leaf_5_clk _0350_ _0161_ VGND VGND VPWR VPWR reg_file.registers\[5\]\[8\]
+ sky130_fd_sc_hd__dfrtp_1
X_2539_ _1128_ _1135_ VGND VGND VPWR VPWR _1136_ sky130_fd_sc_hd__or2_1
X_2608_ _1202_ _0962_ VGND VGND VPWR VPWR _1204_ sky130_fd_sc_hd__nor2_1
XFILLER_0_3_81 VPWR VGND VPWR VGND sky130_ef_sc_hd__decap_12
XFILLER_0_65_178 VGND VGND VPWR VPWR sky130_fd_sc_hd__decap_6
XFILLER_0_65_167 VGND VGND VPWR VPWR sky130_fd_sc_hd__fill_1
XFILLER_0_46_392 VPWR VGND VPWR VGND sky130_ef_sc_hd__decap_12
XFILLER_0_0_109 VGND VGND VPWR VPWR sky130_fd_sc_hd__decap_3
XTAP_TAPCELL_ROW_49_549 VGND VPWR sky130_fd_sc_hd__tapvpwrvgnd_1
X_2890_ _1215_ VGND VGND VPWR VPWR _1461_ sky130_fd_sc_hd__inv_2
XFILLER_0_29_337 VGND VGND VPWR VPWR sky130_fd_sc_hd__decap_4
XFILLER_0_8_209 VPWR VGND VPWR VGND sky130_ef_sc_hd__decap_12
X_1910_ _0530_ VGND VGND VPWR VPWR _0332_ sky130_fd_sc_hd__clkbuf_1
X_1772_ _0440_ VGND VGND VPWR VPWR _0380_ sky130_fd_sc_hd__clkbuf_1
X_1841_ reg_file.registers\[5\]\[22\] _0493_ VGND VGND VPWR VPWR _0494_ sky130_fd_sc_hd__and2_1
XFILLER_0_4_415 VGND VGND VPWR VPWR sky130_fd_sc_hd__decap_4
XFILLER_0_8_15 VPWR VGND VPWR VGND sky130_ef_sc_hd__decap_12
X_3511_ clknet_leaf_21_clk _0273_ _0084_ VGND VGND VPWR VPWR reg_file.registers\[15\]\[27\]
+ sky130_fd_sc_hd__dfrtp_1
X_3373_ _1711_ VGND VGND VPWR VPWR _0157_ sky130_fd_sc_hd__inv_2
X_3442_ _1580_ _1688_ VGND VGND VPWR VPWR _1721_ sky130_fd_sc_hd__nor2_1
X_2324_ reg_file.registers\[11\]\[20\] _0862_ _0863_ reg_file.registers\[10\]\[20\]
+ VGND VGND VPWR VPWR _0922_ sky130_fd_sc_hd__a22o_1
X_2255_ reg_file.registers\[11\]\[14\] _0693_ _0698_ reg_file.registers\[10\]\[14\]
+ VGND VGND VPWR VPWR _0853_ sky130_fd_sc_hd__a22oi_2
X_2186_ _0776_ _0783_ _0647_ VGND VGND VPWR VPWR _0784_ sky130_fd_sc_hd__a21o_1
XFILLER_0_18_82 VGND VGND VPWR VPWR sky130_fd_sc_hd__fill_2
XFILLER_0_18_93 VGND VGND VPWR VPWR sky130_fd_sc_hd__decap_6
XFILLER_0_47_167 VGND VGND VPWR VPWR sky130_fd_sc_hd__fill_1
XFILLER_0_11_281 VGND VGND VPWR VPWR sky130_fd_sc_hd__decap_8
XFILLER_0_11_292 VGND VGND VPWR VPWR sky130_fd_sc_hd__decap_3
XFILLER_0_66_421 VPWR VGND VPWR VGND sky130_ef_sc_hd__decap_12
XTAP_TAPCELL_ROW_54_585 VGND VPWR sky130_fd_sc_hd__tapvpwrvgnd_1
XFILLER_0_14_29 VPWR VGND VPWR VGND sky130_ef_sc_hd__decap_12
XFILLER_0_38_156 VPWR VGND VPWR VGND sky130_ef_sc_hd__decap_12
XFILLER_0_34_362 VGND VGND VPWR VPWR sky130_fd_sc_hd__fill_2
XFILLER_0_39_15 VPWR VGND VPWR VGND sky130_ef_sc_hd__decap_12
XFILLER_0_1_429 VPWR VGND VPWR VGND sky130_ef_sc_hd__decap_12
X_2040_ reg_file.registers\[2\]\[13\] _0557_ VGND VGND VPWR VPWR _0638_ sky130_fd_sc_hd__and2_1
XFILLER_0_71_57 VPWR VGND VPWR VGND sky130_ef_sc_hd__decap_12
XFILLER_0_69_281 VGND VGND VPWR VPWR sky130_fd_sc_hd__decap_8
X_2873_ _0708_ _0773_ VGND VGND VPWR VPWR _1447_ sky130_fd_sc_hd__and2b_1
X_2942_ reg_file.registers\[15\]\[20\] _1495_ VGND VGND VPWR VPWR _1497_ sky130_fd_sc_hd__and2_1
X_1755_ reg_file.registers\[2\]\[15\] VGND VGND VPWR VPWR _0432_ sky130_fd_sc_hd__clkbuf_1
X_1824_ reg_file.registers\[5\]\[30\] _0483_ VGND VGND VPWR VPWR _0485_ sky130_fd_sc_hd__and2_1
XFILLER_0_4_289 VPWR VGND VPWR VGND sky130_ef_sc_hd__decap_12
XFILLER_0_4_245 VGND VGND VPWR VPWR sky130_fd_sc_hd__decap_6
X_2238_ _0817_ _0832_ _0834_ VGND VGND VPWR VPWR _0836_ sky130_fd_sc_hd__a21o_1
X_2307_ _0903_ _0904_ VGND VGND VPWR VPWR _0905_ sky130_fd_sc_hd__nand2_1
X_3425_ _1718_ VGND VGND VPWR VPWR _0202_ sky130_fd_sc_hd__inv_2
XFILLER_0_31_3 VPWR VGND VPWR VGND sky130_ef_sc_hd__decap_12
X_3356_ _1708_ VGND VGND VPWR VPWR _0143_ sky130_fd_sc_hd__inv_2
X_3287_ _1698_ VGND VGND VPWR VPWR _0084_ sky130_fd_sc_hd__inv_2
XTAP_TAPCELL_ROW_68_699 VGND VPWR sky130_fd_sc_hd__tapvpwrvgnd_1
X_2169_ _0761_ _0762_ _0766_ VGND VGND VPWR VPWR _0767_ sky130_fd_sc_hd__o21ai_1
XFILLER_0_48_421 VGND VGND VPWR VPWR sky130_fd_sc_hd__decap_8
XTAP_TAPCELL_ROW_0_144 VGND VPWR sky130_fd_sc_hd__tapvpwrvgnd_1
XTAP_TAPCELL_ROW_0_155 VGND VPWR sky130_fd_sc_hd__tapvpwrvgnd_1
XFILLER_0_63_424 VPWR VGND VPWR VGND sky130_ef_sc_hd__decap_12
XTAP_TAPCELL_ROW_51_566 VGND VPWR sky130_fd_sc_hd__tapvpwrvgnd_1
XFILLER_0_50_129 VGND VGND VPWR VPWR sky130_fd_sc_hd__decap_8
XFILLER_0_16_373 VGND VGND VPWR VPWR sky130_fd_sc_hd__decap_3
XFILLER_0_43_192 VGND VGND VPWR VPWR sky130_fd_sc_hd__fill_2
XTAP_TAPCELL_ROW_8_222 VGND VPWR sky130_fd_sc_hd__tapvpwrvgnd_1
XFILLER_0_39_432 VPWR VGND VPWR VGND sky130_ef_sc_hd__decap_12
XTAP_TAPCELL_ROW_14_268 VGND VPWR sky130_fd_sc_hd__tapvpwrvgnd_1
XFILLER_0_1_237 VPWR VGND VPWR VGND sky130_ef_sc_hd__decap_12
XFILLER_0_66_79 VGND VGND VPWR VPWR sky130_fd_sc_hd__decap_4
X_3141_ _1069_ _1074_ VGND VGND VPWR VPWR _1638_ sky130_fd_sc_hd__nand2_1
XFILLER_0_5_27 VPWR VGND VPWR VGND sky130_ef_sc_hd__decap_12
X_3210_ display.counter\[16\] _1682_ VGND VGND VPWR VPWR _0014_ sky130_fd_sc_hd__xor2_1
X_2023_ _0620_ VGND VGND VPWR VPWR _0621_ sky130_fd_sc_hd__inv_2
X_3072_ _1199_ _0610_ VGND VGND VPWR VPWR _1575_ sky130_fd_sc_hd__or2_1
XFILLER_0_15_72 VGND VGND VPWR VPWR sky130_fd_sc_hd__decap_6
X_1807_ imem.address\[9\] imem.address\[8\] imem.address\[7\] imem.address\[6\] VGND
+ VGND VPWR VPWR _0469_ sky130_fd_sc_hd__nor4_2
XFILLER_0_57_295 VGND VGND VPWR VPWR sky130_fd_sc_hd__decap_3
X_2856_ _1032_ _1243_ _1433_ _1063_ VGND VGND VPWR VPWR _1434_ sky130_fd_sc_hd__a2bb2o_1
XFILLER_0_9_337 VGND VGND VPWR VPWR sky130_fd_sc_hd__fill_2
XFILLER_0_9_348 VPWR VGND VPWR VGND sky130_ef_sc_hd__decap_12
X_2925_ reg_file.registers\[15\]\[28\] _1484_ VGND VGND VPWR VPWR _1488_ sky130_fd_sc_hd__and2_1
X_3408_ _1716_ VGND VGND VPWR VPWR _0187_ sky130_fd_sc_hd__inv_2
XFILLER_0_40_151 VPWR VGND VPWR VGND sky130_ef_sc_hd__decap_12
X_2787_ _1247_ _1241_ _0990_ VGND VGND VPWR VPWR _1373_ sky130_fd_sc_hd__mux2_1
XFILLER_0_0_281 VPWR VGND VPWR VGND sky130_ef_sc_hd__decap_12
X_1738_ _0423_ VGND VGND VPWR VPWR _0397_ sky130_fd_sc_hd__clkbuf_1
X_3339_ _1706_ VGND VGND VPWR VPWR _0128_ sky130_fd_sc_hd__inv_2
XTAP_TAPCELL_ROW_56_603 VGND VPWR sky130_fd_sc_hd__tapvpwrvgnd_1
XFILLER_0_48_284 VPWR VGND VPWR VGND sky130_ef_sc_hd__decap_12
XFILLER_0_51_449 VGND VGND VPWR VPWR sky130_fd_sc_hd__fill_2
XFILLER_0_51_405 VGND VGND VPWR VPWR sky130_fd_sc_hd__fill_1
XFILLER_0_31_162 VGND VGND VPWR VPWR sky130_fd_sc_hd__decap_6
XFILLER_0_8_381 VGND VGND VPWR VPWR sky130_fd_sc_hd__fill_2
XFILLER_0_52_15 VPWR VGND VPWR VGND sky130_ef_sc_hd__decap_12
XTAP_TAPCELL_ROW_19_305 VGND VPWR sky130_fd_sc_hd__tapvpwrvgnd_1
XFILLER_0_52_59 VGND VGND VPWR VPWR sky130_fd_sc_hd__fill_1
X_2710_ _1155_ _0792_ _1301_ VGND VGND VPWR VPWR _1302_ sky130_fd_sc_hd__o21ai_1
XFILLER_0_39_262 VGND VGND VPWR VPWR sky130_fd_sc_hd__decap_8
XFILLER_0_27_413 VPWR VGND VPWR VGND sky130_ef_sc_hd__decap_12
XTAP_TAPCELL_ROW_27_371 VGND VPWR sky130_fd_sc_hd__tapvpwrvgnd_1
XFILLER_0_6_307 VGND VGND VPWR VPWR sky130_fd_sc_hd__fill_1
X_2572_ _1166_ _1167_ _1155_ VGND VGND VPWR VPWR _1168_ sky130_fd_sc_hd__mux2_1
XFILLER_0_22_173 VGND VGND VPWR VPWR sky130_fd_sc_hd__decap_3
X_2641_ _0933_ _1192_ _0938_ _1193_ VGND VGND VPWR VPWR _1235_ sky130_fd_sc_hd__a22o_1
X_3124_ _0410_ _1441_ VGND VGND VPWR VPWR _1623_ sky130_fd_sc_hd__and2b_1
X_3055_ _1557_ _1558_ VGND VGND VPWR VPWR _1559_ sky130_fd_sc_hd__and2b_1
X_2006_ _0602_ _0556_ _0603_ VGND VGND VPWR VPWR _0604_ sky130_fd_sc_hd__o21a_4
XFILLER_0_26_82 VGND VGND VPWR VPWR sky130_fd_sc_hd__fill_2
XFILLER_0_9_167 VGND VGND VPWR VPWR sky130_fd_sc_hd__fill_1
XFILLER_0_18_424 VPWR VGND VPWR VGND sky130_ef_sc_hd__decap_12
X_2908_ _1200_ _1389_ _1475_ VGND VGND VPWR VPWR _1476_ sky130_fd_sc_hd__a21bo_1
X_2839_ _1418_ VGND VGND VPWR VPWR _1419_ sky130_fd_sc_hd__inv_2
XFILLER_0_33_449 VGND VGND VPWR VPWR sky130_fd_sc_hd__fill_2
XFILLER_0_33_427 VGND VGND VPWR VPWR sky130_fd_sc_hd__fill_1
XFILLER_0_5_384 VGND VGND VPWR VPWR sky130_fd_sc_hd__fill_2
XFILLER_0_68_313 VGND VGND VPWR VPWR sky130_fd_sc_hd__fill_1
XFILLER_0_36_287 VGND VGND VPWR VPWR sky130_fd_sc_hd__fill_1
XFILLER_0_36_232 VPWR VGND VPWR VGND sky130_ef_sc_hd__decap_12
XFILLER_0_22_29 VPWR VGND VPWR VGND sky130_ef_sc_hd__decap_12
XFILLER_0_51_279 VGND VGND VPWR VPWR sky130_fd_sc_hd__fill_1
XFILLER_0_47_37 VGND VGND VPWR VPWR sky130_fd_sc_hd__decap_3
XFILLER_0_59_335 VGND VGND VPWR VPWR sky130_fd_sc_hd__fill_1
XFILLER_0_59_313 VGND VGND VPWR VPWR sky130_fd_sc_hd__fill_2
X_2624_ _1014_ _1216_ _1218_ VGND VGND VPWR VPWR _1219_ sky130_fd_sc_hd__o21ai_1
XTAP_TAPCELL_ROW_30_399 VGND VPWR sky130_fd_sc_hd__tapvpwrvgnd_1
XFILLER_0_30_408 VGND VGND VPWR VPWR sky130_fd_sc_hd__decap_3
X_3673_ clknet_leaf_15_clk _0415_ VGND VGND VPWR VPWR net9 sky130_fd_sc_hd__dfxtp_1
XFILLER_0_27_276 VGND VGND VPWR VPWR sky130_fd_sc_hd__decap_4
XFILLER_0_2_321 VPWR VGND VPWR VGND sky130_ef_sc_hd__decap_12
XFILLER_0_15_449 VGND VGND VPWR VPWR sky130_fd_sc_hd__fill_2
X_2486_ _1068_ _1082_ VGND VGND VPWR VPWR _1083_ sky130_fd_sc_hd__and2b_1
XFILLER_0_63_6 VGND VGND VPWR VPWR sky130_fd_sc_hd__decap_6
XFILLER_0_2_365 VPWR VGND VPWR VGND sky130_ef_sc_hd__decap_12
XFILLER_0_10_121 VPWR VGND VPWR VGND sky130_ef_sc_hd__decap_12
XFILLER_0_10_165 VPWR VGND VPWR VGND sky130_ef_sc_hd__decap_12
X_2555_ _1151_ VGND VGND VPWR VPWR _0308_ sky130_fd_sc_hd__clkbuf_1
X_3038_ _1523_ _1551_ VGND VGND VPWR VPWR _0225_ sky130_fd_sc_hd__nor2_1
X_3107_ display.digit_sel\[1\] _1557_ display.digit_sel\[0\] VGND VGND VPWR VPWR _0415_
+ sky130_fd_sc_hd__nand3_2
XTAP_TAPCELL_ROW_21_322 VGND VPWR sky130_fd_sc_hd__tapvpwrvgnd_1
XFILLER_0_5_181 VPWR VGND VPWR VGND sky130_ef_sc_hd__decap_12
XFILLER_0_24_235 VGND VGND VPWR VPWR sky130_fd_sc_hd__fill_1
X_2271_ _0868_ _0675_ VGND VGND VPWR VPWR _0869_ sky130_fd_sc_hd__xnor2_2
X_2340_ _0678_ _0937_ VGND VGND VPWR VPWR _0938_ sky130_fd_sc_hd__or2_4
XFILLER_0_55_360 VGND VGND VPWR VPWR sky130_fd_sc_hd__decap_8
XTAP_TAPCELL_ROW_35_436 VGND VPWR sky130_fd_sc_hd__tapvpwrvgnd_1
XFILLER_0_7_435 VGND VGND VPWR VPWR sky130_fd_sc_hd__fill_1
X_1986_ net49 _0583_ VGND VGND VPWR VPWR _0584_ sky130_fd_sc_hd__nor2_1
XFILLER_0_70_363 VGND VGND VPWR VPWR sky130_fd_sc_hd__fill_1
Xclkbuf_leaf_9_clk clknet_1_0__leaf_clk VGND VGND VPWR VPWR clknet_leaf_9_clk sky130_fd_sc_hd__clkbuf_8
XFILLER_0_61_3 VPWR VGND VPWR VGND sky130_ef_sc_hd__decap_12
X_3587_ clknet_leaf_5_clk _0349_ _0160_ VGND VGND VPWR VPWR reg_file.registers\[5\]\[7\]
+ sky130_fd_sc_hd__dfrtp_1
XFILLER_0_30_249 VGND VGND VPWR VPWR sky130_fd_sc_hd__decap_3
X_3656_ clknet_leaf_17_clk _0008_ VGND VGND VPWR VPWR display.counter\[10\] sky130_fd_sc_hd__dfxtp_1
XFILLER_0_11_430 VGND VGND VPWR VPWR sky130_fd_sc_hd__fill_2
X_2607_ _1202_ net30 VGND VGND VPWR VPWR _1203_ sky130_fd_sc_hd__and2_4
X_2538_ _1131_ _1134_ _1019_ VGND VGND VPWR VPWR _1135_ sky130_fd_sc_hd__mux2_1
X_2469_ _0973_ _1061_ _0964_ VGND VGND VPWR VPWR _1066_ sky130_fd_sc_hd__o21ai_1
XFILLER_0_2_195 VGND VGND VPWR VPWR sky130_fd_sc_hd__fill_1
XFILLER_0_65_113 VPWR VGND VPWR VGND sky130_ef_sc_hd__decap_12
XFILLER_0_38_305 VGND VGND VPWR VPWR sky130_fd_sc_hd__decap_3
XFILLER_0_3_93 VPWR VGND VPWR VGND sky130_ef_sc_hd__decap_12
XFILLER_0_44_27 VGND VGND VPWR VPWR sky130_fd_sc_hd__fill_1
XFILLER_0_60_37 VGND VGND VPWR VPWR sky130_fd_sc_hd__fill_2
XFILLER_0_56_135 VGND VGND VPWR VPWR sky130_fd_sc_hd__decap_4
XFILLER_0_56_102 VPWR VGND VPWR VGND sky130_ef_sc_hd__decap_12
X_1840_ _0482_ VGND VGND VPWR VPWR _0493_ sky130_fd_sc_hd__clkbuf_2
X_1771_ reg_file.registers\[2\]\[7\] VGND VGND VPWR VPWR _0440_ sky130_fd_sc_hd__clkbuf_1
XTAP_TAPCELL_ROW_40_472 VGND VPWR sky130_fd_sc_hd__tapvpwrvgnd_1
XFILLER_0_37_393 VGND VGND VPWR VPWR sky130_fd_sc_hd__decap_3
X_3441_ _1584_ _1688_ _1578_ VGND VGND VPWR VPWR _1720_ sky130_fd_sc_hd__o21a_1
XFILLER_0_8_27 VGND VGND VPWR VPWR sky130_fd_sc_hd__fill_1
X_3510_ clknet_leaf_21_clk _0272_ _0083_ VGND VGND VPWR VPWR reg_file.registers\[15\]\[26\]
+ sky130_fd_sc_hd__dfrtp_1
X_3372_ _1711_ VGND VGND VPWR VPWR _0156_ sky130_fd_sc_hd__inv_2
X_2254_ _0781_ _0784_ _0788_ VGND VGND VPWR VPWR _0852_ sky130_fd_sc_hd__a21oi_1
X_2323_ _0879_ _0880_ VGND VGND VPWR VPWR _0921_ sky130_fd_sc_hd__or2_1
XFILLER_0_18_61 VGND VGND VPWR VPWR sky130_fd_sc_hd__fill_1
XFILLER_0_20_293 VGND VGND VPWR VPWR sky130_fd_sc_hd__decap_3
XFILLER_0_47_113 VPWR VGND VPWR VGND sky130_ef_sc_hd__decap_12
X_2185_ _0574_ _0782_ _0579_ VGND VGND VPWR VPWR _0783_ sky130_fd_sc_hd__a21oi_1
XFILLER_0_34_82 VGND VGND VPWR VPWR sky130_fd_sc_hd__fill_2
XFILLER_0_34_60 VGND VGND VPWR VPWR sky130_fd_sc_hd__fill_2
XFILLER_0_55_190 VGND VGND VPWR VPWR sky130_fd_sc_hd__fill_2
XFILLER_0_50_70 VPWR VGND VPWR VGND sky130_ef_sc_hd__decap_12
X_1969_ _0566_ VGND VGND VPWR VPWR _0567_ sky130_fd_sc_hd__buf_2
XFILLER_0_70_182 VGND VGND VPWR VPWR sky130_fd_sc_hd__decap_4
XFILLER_0_43_374 VGND VGND VPWR VPWR sky130_fd_sc_hd__decap_6
X_3639_ clknet_leaf_20_clk _0401_ _0212_ VGND VGND VPWR VPWR reg_file.registers\[2\]\[28\]
+ sky130_fd_sc_hd__dfrtp_1
XFILLER_0_66_433 VPWR VGND VPWR VGND sky130_ef_sc_hd__decap_12
XTAP_TAPCELL_ROW_54_586 VGND VPWR sky130_fd_sc_hd__tapvpwrvgnd_1
XFILLER_0_38_168 VGND VGND VPWR VPWR sky130_fd_sc_hd__fill_2
XFILLER_0_19_393 VPWR VGND VPWR VGND sky130_ef_sc_hd__decap_12
XFILLER_0_39_27 VGND VGND VPWR VPWR sky130_fd_sc_hd__decap_8
XFILLER_0_71_69 VPWR VGND VPWR VGND sky130_ef_sc_hd__decap_12
X_2872_ _0712_ _0768_ _0769_ VGND VGND VPWR VPWR _1446_ sky130_fd_sc_hd__o21a_1
XFILLER_0_29_157 VGND VGND VPWR VPWR sky130_fd_sc_hd__decap_8
X_2941_ _1496_ VGND VGND VPWR VPWR _0267_ sky130_fd_sc_hd__clkbuf_1
X_1823_ _0484_ VGND VGND VPWR VPWR _0373_ sky130_fd_sc_hd__clkbuf_1
XTAP_TAPCELL_ROW_17_288 VGND VPWR sky130_fd_sc_hd__tapvpwrvgnd_1
X_3424_ _1718_ VGND VGND VPWR VPWR _0201_ sky130_fd_sc_hd__inv_2
X_1754_ _0431_ VGND VGND VPWR VPWR _0389_ sky130_fd_sc_hd__clkbuf_1
X_2237_ _0817_ _0832_ _0834_ VGND VGND VPWR VPWR _0835_ sky130_fd_sc_hd__nand3_1
X_2306_ _0900_ _0902_ VGND VGND VPWR VPWR _0904_ sky130_fd_sc_hd__or2_1
XFILLER_0_29_71 VGND VGND VPWR VPWR sky130_fd_sc_hd__decap_3
XFILLER_0_24_3 VPWR VGND VPWR VGND sky130_ef_sc_hd__decap_12
X_3355_ _1708_ VGND VGND VPWR VPWR _0142_ sky130_fd_sc_hd__inv_2
X_3286_ _1698_ VGND VGND VPWR VPWR _0083_ sky130_fd_sc_hd__inv_2
XFILLER_0_67_208 VGND VGND VPWR VPWR sky130_fd_sc_hd__decap_8
X_2168_ _0761_ _0762_ _0757_ VGND VGND VPWR VPWR _0766_ sky130_fd_sc_hd__a21o_1
X_2099_ _0696_ VGND VGND VPWR VPWR _0697_ sky130_fd_sc_hd__clkbuf_4
XFILLER_0_45_70 VPWR VGND VPWR VGND sky130_ef_sc_hd__decap_12
XTAP_TAPCELL_ROW_0_156 VGND VPWR sky130_fd_sc_hd__tapvpwrvgnd_1
XTAP_TAPCELL_ROW_0_145 VGND VPWR sky130_fd_sc_hd__tapvpwrvgnd_1
XFILLER_0_63_436 VPWR VGND VPWR VGND sky130_ef_sc_hd__decap_12
XTAP_TAPCELL_ROW_51_567 VGND VPWR sky130_fd_sc_hd__tapvpwrvgnd_1
XFILLER_0_50_119 VGND VGND VPWR VPWR sky130_fd_sc_hd__decap_4
XFILLER_0_9_81 VPWR VGND VPWR VGND sky130_ef_sc_hd__decap_12
XFILLER_0_16_363 VGND VGND VPWR VPWR sky130_fd_sc_hd__fill_1
XPHY_EDGE_ROW_17_Right_17 VGND VGND VPWR VPWR sky130_fd_sc_hd__decap_3
XFILLER_0_31_377 VPWR VGND VPWR VGND sky130_ef_sc_hd__decap_12
XPHY_EDGE_ROW_26_Right_26 VGND VGND VPWR VPWR sky130_fd_sc_hd__decap_3
XTAP_TAPCELL_ROW_8_223 VGND VPWR sky130_fd_sc_hd__tapvpwrvgnd_1
XFILLER_0_66_230 VPWR VGND VPWR VGND sky130_ef_sc_hd__decap_12
XFILLER_0_39_444 VGND VGND VPWR VPWR sky130_fd_sc_hd__decap_4
XPHY_EDGE_ROW_35_Right_35 VGND VGND VPWR VPWR sky130_fd_sc_hd__decap_3
XTAP_TAPCELL_ROW_14_269 VGND VPWR sky130_fd_sc_hd__tapvpwrvgnd_1
XFILLER_0_19_190 VPWR VGND VPWR VGND sky130_ef_sc_hd__decap_12
XFILLER_0_1_205 VPWR VGND VPWR VGND sky130_ef_sc_hd__decap_12
XFILLER_0_1_249 VPWR VGND VPWR VGND sky130_ef_sc_hd__decap_12
X_3071_ _1572_ _1573_ _1014_ VGND VGND VPWR VPWR _1574_ sky130_fd_sc_hd__mux2_1
X_3140_ _0477_ _0408_ VGND VGND VPWR VPWR _1637_ sky130_fd_sc_hd__nor2_1
XPHY_EDGE_ROW_44_Right_44 VGND VGND VPWR VPWR sky130_fd_sc_hd__decap_3
XFILLER_0_5_39 VPWR VGND VPWR VGND sky130_ef_sc_hd__decap_12
XFILLER_0_57_252 VGND VGND VPWR VPWR sky130_fd_sc_hd__fill_1
X_2022_ _0572_ _0619_ net23 VGND VGND VPWR VPWR _0620_ sky130_fd_sc_hd__a21oi_1
XPHY_EDGE_ROW_53_Right_53 VGND VGND VPWR VPWR sky130_fd_sc_hd__decap_3
X_1806_ _0448_ _0451_ _0454_ VGND VGND VPWR VPWR _0468_ sky130_fd_sc_hd__nor3_4
XFILLER_0_60_417 VGND VGND VPWR VPWR sky130_fd_sc_hd__decap_3
X_2855_ _0816_ _1432_ VGND VGND VPWR VPWR _1433_ sky130_fd_sc_hd__xnor2_1
XFILLER_0_45_447 VGND VGND VPWR VPWR sky130_fd_sc_hd__fill_1
X_2786_ _0680_ _1016_ _1053_ _1332_ VGND VGND VPWR VPWR _1372_ sky130_fd_sc_hd__a31o_1
XFILLER_0_25_182 VGND VGND VPWR VPWR sky130_fd_sc_hd__decap_3
XPHY_EDGE_ROW_17_Left_89 VGND VGND VPWR VPWR sky130_fd_sc_hd__decap_3
X_2924_ _1487_ VGND VGND VPWR VPWR _0275_ sky130_fd_sc_hd__clkbuf_1
X_3338_ _1706_ VGND VGND VPWR VPWR _0127_ sky130_fd_sc_hd__inv_2
X_3407_ _1716_ VGND VGND VPWR VPWR _0186_ sky130_fd_sc_hd__inv_2
XPHY_EDGE_ROW_62_Right_62 VGND VGND VPWR VPWR sky130_fd_sc_hd__decap_3
XFILLER_0_40_163 VGND VGND VPWR VPWR sky130_fd_sc_hd__decap_4
XFILLER_0_40_141 VGND VGND VPWR VPWR sky130_fd_sc_hd__decap_3
XFILLER_0_40_130 VGND VGND VPWR VPWR sky130_fd_sc_hd__decap_8
XFILLER_0_0_293 VPWR VGND VPWR VGND sky130_ef_sc_hd__decap_12
X_1737_ reg_file.registers\[2\]\[24\] VGND VGND VPWR VPWR _0423_ sky130_fd_sc_hd__clkbuf_1
XTAP_TAPCELL_ROW_56_604 VGND VPWR sky130_fd_sc_hd__tapvpwrvgnd_1
XFILLER_0_56_91 VGND VGND VPWR VPWR sky130_fd_sc_hd__fill_2
X_3269_ _1697_ VGND VGND VPWR VPWR _0067_ sky130_fd_sc_hd__inv_2
XPHY_EDGE_ROW_71_Right_71 VGND VGND VPWR VPWR sky130_fd_sc_hd__decap_3
XTAP_TAPCELL_ROW_64_670 VGND VPWR sky130_fd_sc_hd__tapvpwrvgnd_1
XFILLER_0_48_296 VGND VGND VPWR VPWR sky130_fd_sc_hd__decap_4
XFILLER_0_36_447 VGND VGND VPWR VPWR sky130_fd_sc_hd__fill_1
XFILLER_0_52_27 VGND VGND VPWR VPWR sky130_fd_sc_hd__fill_1
XTAP_TAPCELL_ROW_27_372 VGND VPWR sky130_fd_sc_hd__tapvpwrvgnd_1
XTAP_TAPCELL_ROW_19_306 VGND VPWR sky130_fd_sc_hd__tapvpwrvgnd_1
XFILLER_0_27_425 VPWR VGND VPWR VGND sky130_ef_sc_hd__decap_12
XFILLER_0_14_108 VPWR VGND VPWR VGND sky130_ef_sc_hd__decap_12
X_2640_ _1234_ VGND VGND VPWR VPWR _0306_ sky130_fd_sc_hd__clkbuf_1
X_2571_ reg_file.registers\[11\]\[6\] _0790_ _0791_ reg_file.registers\[10\]\[6\]
+ VGND VGND VPWR VPWR _1167_ sky130_fd_sc_hd__a22o_1
XFILLER_0_50_450 VGND VGND VPWR VPWR sky130_fd_sc_hd__fill_1
XFILLER_0_10_314 VGND VGND VPWR VPWR sky130_fd_sc_hd__decap_3
XFILLER_0_10_325 VGND VGND VPWR VPWR sky130_fd_sc_hd__fill_1
X_2005_ _0463_ _0466_ VGND VGND VPWR VPWR _0603_ sky130_fd_sc_hd__nor2_1
X_3123_ _1064_ _1420_ _1421_ _1200_ _1184_ VGND VGND VPWR VPWR _1622_ sky130_fd_sc_hd__a32o_1
X_3054_ display.digit_sel\[1\] display.digit_sel\[0\] VGND VGND VPWR VPWR _1558_ sky130_fd_sc_hd__nor2_1
XTAP_TAPCELL_ROW_61_640 VGND VPWR sky130_fd_sc_hd__tapvpwrvgnd_1
X_2907_ _0728_ _0735_ _1474_ _0988_ VGND VGND VPWR VPWR _1475_ sky130_fd_sc_hd__a211o_1
XFILLER_0_9_113 VPWR VGND VPWR VGND sky130_ef_sc_hd__decap_12
XFILLER_0_18_436 VPWR VGND VPWR VGND sky130_ef_sc_hd__decap_12
X_2769_ _1014_ _1018_ _1052_ VGND VGND VPWR VPWR _1357_ sky130_fd_sc_hd__and3_1
X_2838_ _0807_ _0808_ VGND VGND VPWR VPWR _1418_ sky130_fd_sc_hd__nand2_1
XFILLER_0_33_417 VGND VGND VPWR VPWR sky130_fd_sc_hd__fill_1
XFILLER_0_51_225 VPWR VGND VPWR VGND sky130_ef_sc_hd__decap_12
XFILLER_0_36_266 VGND VGND VPWR VPWR sky130_fd_sc_hd__decap_4
XFILLER_0_36_244 VGND VGND VPWR VPWR sky130_fd_sc_hd__decap_8
XFILLER_0_36_211 VGND VGND VPWR VPWR sky130_fd_sc_hd__decap_3
XFILLER_0_24_406 VGND VGND VPWR VPWR sky130_fd_sc_hd__fill_1
XFILLER_0_2_29 VPWR VGND VPWR VGND sky130_ef_sc_hd__decap_12
X_2623_ _0742_ _1217_ VGND VGND VPWR VPWR _1218_ sky130_fd_sc_hd__or2_1
X_3672_ clknet_leaf_15_clk _0414_ VGND VGND VPWR VPWR net8 sky130_fd_sc_hd__dfxtp_1
X_2554_ reg_file.registers\[11\]\[30\] _1150_ _1059_ VGND VGND VPWR VPWR _1151_ sky130_fd_sc_hd__mux2_1
XFILLER_0_2_333 VPWR VGND VPWR VGND sky130_ef_sc_hd__decap_12
XFILLER_0_12_41 VPWR VGND VPWR VGND sky130_ef_sc_hd__decap_12
XFILLER_0_12_85 VPWR VGND VPWR VGND sky130_ef_sc_hd__decap_12
XFILLER_0_15_428 VGND VGND VPWR VPWR sky130_fd_sc_hd__fill_1
X_2485_ reg_file.registers\[11\]\[4\] _1070_ _1072_ reg_file.registers\[10\]\[4\]
+ VGND VGND VPWR VPWR _1082_ sky130_fd_sc_hd__a22o_1
XPHY_EDGE_ROW_34_Left_106 VGND VGND VPWR VPWR sky130_fd_sc_hd__decap_3
XFILLER_0_2_377 VPWR VGND VPWR VGND sky130_ef_sc_hd__decap_12
XFILLER_0_10_133 VGND VGND VPWR VPWR sky130_fd_sc_hd__decap_6
XFILLER_0_10_177 VPWR VGND VPWR VGND sky130_ef_sc_hd__decap_12
X_3037_ imem.address\[10\] _1522_ imem.address\[11\] VGND VGND VPWR VPWR _1551_ sky130_fd_sc_hd__a21oi_1
XPHY_EDGE_ROW_43_Left_115 VGND VGND VPWR VPWR sky130_fd_sc_hd__decap_3
XTAP_TAPCELL_ROW_38_456 VGND VPWR sky130_fd_sc_hd__tapvpwrvgnd_1
XFILLER_0_37_82 VGND VGND VPWR VPWR sky130_fd_sc_hd__decap_4
XFILLER_0_37_71 VGND VGND VPWR VPWR sky130_fd_sc_hd__fill_1
X_3106_ _1604_ _1199_ _1605_ VGND VGND VPWR VPWR _1606_ sky130_fd_sc_hd__or3_1
XFILLER_0_33_225 VPWR VGND VPWR VGND sky130_ef_sc_hd__decap_12
XTAP_TAPCELL_ROW_21_323 VGND VPWR sky130_fd_sc_hd__tapvpwrvgnd_1
XPHY_EDGE_ROW_52_Left_124 VGND VGND VPWR VPWR sky130_fd_sc_hd__decap_3
XFILLER_0_5_193 VPWR VGND VPWR VGND sky130_ef_sc_hd__decap_12
XFILLER_0_68_155 VPWR VGND VPWR VGND sky130_ef_sc_hd__decap_12
XPHY_EDGE_ROW_61_Left_133 VGND VGND VPWR VPWR sky130_fd_sc_hd__decap_3
XFILLER_0_56_339 VPWR VGND VPWR VGND sky130_ef_sc_hd__decap_12
XFILLER_0_49_380 VPWR VGND VPWR VGND sky130_ef_sc_hd__decap_12
XFILLER_0_33_29 VGND VGND VPWR VPWR sky130_fd_sc_hd__decap_3
XFILLER_0_71_309 VPWR VGND VPWR VGND sky130_ef_sc_hd__decap_12
XPHY_EDGE_ROW_70_Left_142 VGND VGND VPWR VPWR sky130_fd_sc_hd__decap_3
XFILLER_0_24_247 VGND VGND VPWR VPWR sky130_fd_sc_hd__decap_4
XFILLER_0_58_15 VPWR VGND VPWR VGND sky130_ef_sc_hd__decap_12
X_2270_ _0859_ _0668_ VGND VGND VPWR VPWR _0868_ sky130_fd_sc_hd__nand2_1
XFILLER_0_59_133 VGND VGND VPWR VPWR sky130_fd_sc_hd__fill_2
XFILLER_0_59_111 VGND VGND VPWR VPWR sky130_fd_sc_hd__fill_1
XTAP_TAPCELL_ROW_35_437 VGND VPWR sky130_fd_sc_hd__tapvpwrvgnd_1
XFILLER_0_55_372 VPWR VGND VPWR VGND sky130_ef_sc_hd__decap_12
XFILLER_0_23_73 VGND VGND VPWR VPWR sky130_fd_sc_hd__fill_1
XFILLER_0_15_225 VPWR VGND VPWR VGND sky130_ef_sc_hd__decap_12
X_1985_ reg_file.registers\[2\]\[25\] _0559_ _0582_ VGND VGND VPWR VPWR _0583_ sky130_fd_sc_hd__a21oi_1
X_3586_ clknet_leaf_5_clk _0348_ _0159_ VGND VGND VPWR VPWR reg_file.registers\[5\]\[6\]
+ sky130_fd_sc_hd__dfrtp_1
X_3655_ clknet_leaf_17_clk _0026_ VGND VGND VPWR VPWR display.counter\[9\] sky130_fd_sc_hd__dfxtp_1
XFILLER_0_2_141 VPWR VGND VPWR VGND sky130_ef_sc_hd__decap_12
X_2537_ _1132_ _1133_ _1069_ VGND VGND VPWR VPWR _1134_ sky130_fd_sc_hd__mux2_1
X_2606_ _1201_ _0963_ VGND VGND VPWR VPWR _1202_ sky130_fd_sc_hd__nor2_1
XFILLER_0_54_3 VGND VGND VPWR VPWR sky130_fd_sc_hd__decap_8
X_2468_ _1064_ VGND VGND VPWR VPWR _1065_ sky130_fd_sc_hd__clkbuf_4
X_2399_ _0871_ _0993_ _0996_ VGND VGND VPWR VPWR _0997_ sky130_fd_sc_hd__mux2_1
XFILLER_0_65_125 VGND VGND VPWR VPWR sky130_fd_sc_hd__decap_8
XFILLER_0_61_375 VGND VGND VPWR VPWR sky130_fd_sc_hd__fill_1
XFILLER_0_53_309 VGND VGND VPWR VPWR sky130_fd_sc_hd__decap_4
XFILLER_0_28_29 VGND VGND VPWR VPWR sky130_fd_sc_hd__decap_8
XPHY_EDGE_ROW_5_Left_77 VGND VGND VPWR VPWR sky130_fd_sc_hd__decap_3
XFILLER_0_69_431 VPWR VGND VPWR VGND sky130_ef_sc_hd__decap_12
XFILLER_0_56_114 VGND VGND VPWR VPWR sky130_fd_sc_hd__fill_1
X_1770_ _0439_ VGND VGND VPWR VPWR _0381_ sky130_fd_sc_hd__clkbuf_1
XFILLER_0_69_69 VGND VGND VPWR VPWR sky130_fd_sc_hd__fill_2
X_3371_ _1711_ VGND VGND VPWR VPWR _0155_ sky130_fd_sc_hd__inv_2
XFILLER_0_52_397 VGND VGND VPWR VPWR sky130_fd_sc_hd__decap_4
XTAP_TAPCELL_ROW_40_473 VGND VPWR sky130_fd_sc_hd__tapvpwrvgnd_1
X_3440_ display.digit_sel\[0\] _1688_ VGND VGND VPWR VPWR _0405_ sky130_fd_sc_hd__xnor2_1
X_2253_ _0849_ _0850_ _0789_ _0793_ _0796_ VGND VGND VPWR VPWR _0851_ sky130_fd_sc_hd__o2111a_1
X_2184_ reg_file.registers\[5\]\[14\] _0564_ _0567_ reg_file.registers\[15\]\[14\]
+ _0643_ VGND VGND VPWR VPWR _0782_ sky130_fd_sc_hd__a221o_1
X_2322_ _0896_ _0916_ _0919_ VGND VGND VPWR VPWR _0920_ sky130_fd_sc_hd__o21a_1
XTAP_TAPCELL_ROW_48_540 VGND VPWR sky130_fd_sc_hd__tapvpwrvgnd_1
XFILLER_0_47_125 VGND VGND VPWR VPWR sky130_fd_sc_hd__decap_4
XFILLER_0_62_128 VGND VGND VPWR VPWR sky130_fd_sc_hd__fill_2
X_1968_ _0565_ VGND VGND VPWR VPWR _0566_ sky130_fd_sc_hd__clkbuf_4
XFILLER_0_50_82 VGND VGND VPWR VPWR sky130_fd_sc_hd__fill_2
XFILLER_0_50_60 VGND VGND VPWR VPWR sky130_fd_sc_hd__decap_4
XFILLER_0_47_169 VGND VGND VPWR VPWR sky130_fd_sc_hd__decap_6
XFILLER_0_43_331 VGND VGND VPWR VPWR sky130_fd_sc_hd__fill_1
XFILLER_0_28_383 VGND VGND VPWR VPWR sky130_fd_sc_hd__fill_1
XFILLER_0_28_361 VGND VGND VPWR VPWR sky130_fd_sc_hd__decap_3
X_1899_ _0524_ VGND VGND VPWR VPWR _0337_ sky130_fd_sc_hd__clkbuf_1
XFILLER_0_11_261 VPWR VGND VPWR VGND sky130_ef_sc_hd__decap_12
X_3569_ clknet_leaf_18_clk _0331_ _0142_ VGND VGND VPWR VPWR reg_file.registers\[10\]\[21\]
+ sky130_fd_sc_hd__dfrtp_1
X_3638_ clknet_leaf_20_clk _0400_ _0211_ VGND VGND VPWR VPWR reg_file.registers\[2\]\[27\]
+ sky130_fd_sc_hd__dfrtp_1
XTAP_TAPCELL_ROW_3_176 VGND VPWR sky130_fd_sc_hd__tapvpwrvgnd_1
XFILLER_0_66_445 VGND VGND VPWR VPWR sky130_fd_sc_hd__decap_3
XTAP_TAPCELL_ROW_54_587 VGND VPWR sky130_fd_sc_hd__tapvpwrvgnd_1
XFILLER_0_53_117 VGND VGND VPWR VPWR sky130_fd_sc_hd__fill_1
XFILLER_0_71_15 VPWR VGND VPWR VGND sky130_ef_sc_hd__decap_12
X_2940_ reg_file.registers\[15\]\[21\] _1495_ VGND VGND VPWR VPWR _1496_ sky130_fd_sc_hd__and2_1
X_2871_ _1445_ VGND VGND VPWR VPWR _0286_ sky130_fd_sc_hd__clkbuf_1
X_1753_ reg_file.registers\[2\]\[16\] VGND VGND VPWR VPWR _0431_ sky130_fd_sc_hd__clkbuf_1
XFILLER_0_29_169 VGND VGND VPWR VPWR sky130_fd_sc_hd__decap_3
X_1822_ reg_file.registers\[5\]\[31\] _0483_ VGND VGND VPWR VPWR _0484_ sky130_fd_sc_hd__and2_1
XTAP_TAPCELL_ROW_17_289 VGND VPWR sky130_fd_sc_hd__tapvpwrvgnd_1
X_3423_ _1718_ VGND VGND VPWR VPWR _0200_ sky130_fd_sc_hd__inv_2
X_3354_ _1708_ VGND VGND VPWR VPWR _0141_ sky130_fd_sc_hd__inv_2
XFILLER_0_20_85 VGND VGND VPWR VPWR sky130_fd_sc_hd__decap_3
X_2167_ _0764_ VGND VGND VPWR VPWR _0765_ sky130_fd_sc_hd__inv_2
X_2236_ reg_file.registers\[11\]\[9\] _0692_ _0833_ VGND VGND VPWR VPWR _0834_ sky130_fd_sc_hd__a21oi_2
XFILLER_0_45_82 VGND VGND VPWR VPWR sky130_fd_sc_hd__decap_4
X_2305_ _0900_ _0902_ VGND VGND VPWR VPWR _0903_ sky130_fd_sc_hd__nand2_1
XFILLER_0_17_3 VPWR VGND VPWR VGND sky130_ef_sc_hd__decap_12
X_3285_ _1698_ VGND VGND VPWR VPWR _0082_ sky130_fd_sc_hd__inv_2
X_2098_ _0695_ _0691_ VGND VGND VPWR VPWR _0696_ sky130_fd_sc_hd__nor2_1
XFILLER_0_61_70 VGND VGND VPWR VPWR sky130_fd_sc_hd__fill_2
XTAP_TAPCELL_ROW_0_157 VGND VPWR sky130_fd_sc_hd__tapvpwrvgnd_1
XTAP_TAPCELL_ROW_0_146 VGND VPWR sky130_fd_sc_hd__tapvpwrvgnd_1
XFILLER_0_31_301 VGND VGND VPWR VPWR sky130_fd_sc_hd__fill_1
XFILLER_0_9_93 VPWR VGND VPWR VGND sky130_ef_sc_hd__decap_12
XFILLER_0_16_353 VGND VGND VPWR VPWR sky130_fd_sc_hd__fill_1
XTAP_TAPCELL_ROW_59_624 VGND VPWR sky130_fd_sc_hd__tapvpwrvgnd_1
XFILLER_0_31_389 VGND VGND VPWR VPWR sky130_fd_sc_hd__decap_3
XTAP_TAPCELL_ROW_67_690 VGND VPWR sky130_fd_sc_hd__tapvpwrvgnd_1
XFILLER_0_66_253 VGND VGND VPWR VPWR sky130_fd_sc_hd__decap_4
XFILLER_0_66_242 VGND VGND VPWR VPWR sky130_fd_sc_hd__decap_8
XFILLER_0_54_426 VPWR VGND VPWR VGND sky130_ef_sc_hd__decap_12
XFILLER_0_34_183 VGND VGND VPWR VPWR sky130_fd_sc_hd__decap_8
XFILLER_0_22_345 VGND VGND VPWR VPWR sky130_fd_sc_hd__fill_1
XFILLER_0_1_217 VGND VGND VPWR VPWR sky130_fd_sc_hd__decap_6
X_3070_ _1173_ _1180_ _1004_ VGND VGND VPWR VPWR _1573_ sky130_fd_sc_hd__mux2_1
X_2021_ reg_file.registers\[5\]\[7\] _0562_ _0566_ reg_file.registers\[15\]\[7\] _0618_
+ VGND VGND VPWR VPWR _0619_ sky130_fd_sc_hd__a221o_1
XPHY_EDGE_ROW_8_Left_80 VGND VGND VPWR VPWR sky130_fd_sc_hd__decap_3
XFILLER_0_49_209 VGND VGND VPWR VPWR sky130_fd_sc_hd__decap_8
XFILLER_0_45_426 VGND VGND VPWR VPWR sky130_fd_sc_hd__fill_1
XFILLER_0_15_96 VGND VGND VPWR VPWR sky130_fd_sc_hd__fill_1
X_2923_ reg_file.registers\[15\]\[29\] _1484_ VGND VGND VPWR VPWR _1487_ sky130_fd_sc_hd__and2_1
X_1805_ _0461_ _0463_ _0466_ VGND VGND VPWR VPWR _0467_ sky130_fd_sc_hd__nor3_2
X_2854_ _0818_ _0819_ _0821_ _1431_ VGND VGND VPWR VPWR _1432_ sky130_fd_sc_hd__a22oi_1
X_2785_ _1368_ _1370_ VGND VGND VPWR VPWR _1371_ sky130_fd_sc_hd__xnor2_1
XFILLER_0_31_73 VPWR VGND VPWR VGND sky130_ef_sc_hd__decap_12
XFILLER_0_31_51 VGND VGND VPWR VPWR sky130_fd_sc_hd__fill_1
X_1736_ _0422_ VGND VGND VPWR VPWR _0398_ sky130_fd_sc_hd__clkbuf_1
X_3337_ _1706_ VGND VGND VPWR VPWR _0126_ sky130_fd_sc_hd__inv_2
X_3406_ _1716_ VGND VGND VPWR VPWR _0185_ sky130_fd_sc_hd__inv_2
XFILLER_0_40_197 VGND VGND VPWR VPWR sky130_fd_sc_hd__decap_8
XTAP_TAPCELL_ROW_64_671 VGND VPWR sky130_fd_sc_hd__tapvpwrvgnd_1
XTAP_TAPCELL_ROW_56_605 VGND VPWR sky130_fd_sc_hd__tapvpwrvgnd_1
X_2219_ _0811_ _0634_ VGND VGND VPWR VPWR _0817_ sky130_fd_sc_hd__nand2_1
X_3268_ _1692_ VGND VGND VPWR VPWR _1697_ sky130_fd_sc_hd__buf_4
X_3199_ _1676_ _1677_ VGND VGND VPWR VPWR _0009_ sky130_fd_sc_hd__nor2_1
XFILLER_0_63_245 VGND VGND VPWR VPWR sky130_fd_sc_hd__fill_2
XFILLER_0_63_223 VGND VGND VPWR VPWR sky130_fd_sc_hd__fill_1
XFILLER_0_48_253 VPWR VGND VPWR VGND sky130_ef_sc_hd__decap_12
XFILLER_0_48_231 VGND VGND VPWR VPWR sky130_fd_sc_hd__decap_8
XFILLER_0_36_415 VGND VGND VPWR VPWR sky130_fd_sc_hd__decap_4
XFILLER_0_31_175 VPWR VGND VPWR VGND sky130_ef_sc_hd__decap_12
XFILLER_0_31_131 VPWR VGND VPWR VGND sky130_ef_sc_hd__decap_12
XFILLER_0_6_3 VPWR VGND VPWR VGND sky130_ef_sc_hd__decap_12
XTAP_TAPCELL_ROW_19_307 VGND VPWR sky130_fd_sc_hd__tapvpwrvgnd_1
XTAP_TAPCELL_ROW_27_373 VGND VPWR sky130_fd_sc_hd__tapvpwrvgnd_1
X_2570_ reg_file.registers\[11\]\[7\] _0790_ _0791_ reg_file.registers\[10\]\[7\]
+ VGND VGND VPWR VPWR _1166_ sky130_fd_sc_hd__a22o_1
XFILLER_0_54_245 VGND VGND VPWR VPWR sky130_fd_sc_hd__fill_1
XFILLER_0_27_437 VGND VGND VPWR VPWR sky130_fd_sc_hd__decap_8
XFILLER_0_22_153 VPWR VGND VPWR VGND sky130_ef_sc_hd__decap_12
XFILLER_0_6_309 VPWR VGND VPWR VGND sky130_ef_sc_hd__decap_12
X_3122_ _1294_ _1064_ _1619_ _0750_ _1620_ VGND VGND VPWR VPWR _1621_ sky130_fd_sc_hd__a221o_1
XFILLER_0_22_197 VGND VGND VPWR VPWR sky130_fd_sc_hd__decap_6
XFILLER_0_10_304 VGND VGND VPWR VPWR sky130_fd_sc_hd__decap_4
X_2004_ reg_file.registers\[15\]\[0\] _0588_ _0590_ reg_file.registers\[5\]\[0\] _0601_
+ VGND VGND VPWR VPWR _0602_ sky130_fd_sc_hd__a221o_1
X_3053_ display.digit_sel\[2\] VGND VGND VPWR VPWR _1557_ sky130_fd_sc_hd__buf_2
XTAP_TAPCELL_ROW_61_641 VGND VPWR sky130_fd_sc_hd__tapvpwrvgnd_1
X_2906_ _0728_ _0735_ VGND VGND VPWR VPWR _1474_ sky130_fd_sc_hd__nor2_1
XFILLER_0_42_94 VGND VGND VPWR VPWR sky130_fd_sc_hd__decap_8
XFILLER_0_42_83 VGND VGND VPWR VPWR sky130_fd_sc_hd__fill_1
XFILLER_0_9_125 VPWR VGND VPWR VGND sky130_ef_sc_hd__decap_12
XFILLER_0_9_169 VPWR VGND VPWR VGND sky130_ef_sc_hd__decap_12
XFILLER_0_18_448 VGND VGND VPWR VPWR sky130_fd_sc_hd__decap_3
X_2768_ _1049_ _1051_ _1003_ VGND VGND VPWR VPWR _1356_ sky130_fd_sc_hd__mux2_1
X_2837_ _0801_ _0802_ VGND VGND VPWR VPWR _1417_ sky130_fd_sc_hd__and2_1
X_2699_ reg_file.registers\[11\]\[26\] _1291_ _1059_ VGND VGND VPWR VPWR _1292_ sky130_fd_sc_hd__mux2_1
XFILLER_0_5_364 VPWR VGND VPWR VGND sky130_ef_sc_hd__decap_12
XFILLER_0_67_80 VGND VGND VPWR VPWR sky130_fd_sc_hd__decap_3
XFILLER_0_6_83 VGND VGND VPWR VPWR sky130_fd_sc_hd__fill_1
XFILLER_0_59_337 VGND VGND VPWR VPWR sky130_fd_sc_hd__decap_6
XFILLER_0_59_326 VGND VGND VPWR VPWR sky130_fd_sc_hd__fill_2
XFILLER_0_67_381 VGND VGND VPWR VPWR sky130_fd_sc_hd__decap_8
XFILLER_0_42_204 VGND VGND VPWR VPWR sky130_fd_sc_hd__decap_8
XFILLER_0_27_223 VGND VGND VPWR VPWR sky130_fd_sc_hd__fill_1
XFILLER_0_6_139 VGND VGND VPWR VPWR sky130_fd_sc_hd__fill_1
XFILLER_0_12_53 VPWR VGND VPWR VGND sky130_ef_sc_hd__decap_12
X_2622_ _1088_ _1093_ _1017_ VGND VGND VPWR VPWR _1217_ sky130_fd_sc_hd__mux2_1
X_3671_ clknet_leaf_13_clk _0413_ VGND VGND VPWR VPWR net7 sky130_fd_sc_hd__dfxtp_1
X_2553_ _1065_ _1062_ _1066_ _1110_ _1149_ VGND VGND VPWR VPWR _1150_ sky130_fd_sc_hd__a311o_1
XFILLER_0_2_389 VPWR VGND VPWR VGND sky130_ef_sc_hd__decap_12
XFILLER_0_2_345 VPWR VGND VPWR VGND sky130_ef_sc_hd__decap_12
XFILLER_0_2_301 VGND VGND VPWR VPWR sky130_fd_sc_hd__decap_6
XFILLER_0_12_97 VPWR VGND VPWR VGND sky130_ef_sc_hd__decap_12
X_2484_ reg_file.registers\[11\]\[3\] _1070_ _1072_ reg_file.registers\[10\]\[3\]
+ VGND VGND VPWR VPWR _1081_ sky130_fd_sc_hd__a22o_1
X_3105_ _1568_ _1574_ _0991_ VGND VGND VPWR VPWR _1605_ sky130_fd_sc_hd__mux2_1
XFILLER_0_10_189 VGND VGND VPWR VPWR sky130_fd_sc_hd__decap_6
X_3036_ _1524_ _1550_ VGND VGND VPWR VPWR _0226_ sky130_fd_sc_hd__nor2_1
XFILLER_0_65_329 VGND VGND VPWR VPWR sky130_fd_sc_hd__decap_6
XTAP_TAPCELL_ROW_38_457 VGND VPWR sky130_fd_sc_hd__tapvpwrvgnd_1
XFILLER_0_33_237 VPWR VGND VPWR VGND sky130_ef_sc_hd__decap_12
XFILLER_0_5_161 VGND VGND VPWR VPWR sky130_fd_sc_hd__decap_6
XTAP_TAPCELL_ROW_21_324 VGND VPWR sky130_fd_sc_hd__tapvpwrvgnd_1
XFILLER_0_41_281 VPWR VGND VPWR VGND sky130_ef_sc_hd__decap_12
XFILLER_0_68_167 VGND VGND VPWR VPWR sky130_fd_sc_hd__decap_3
XFILLER_0_68_134 VGND VGND VPWR VPWR sky130_fd_sc_hd__decap_3
XFILLER_0_64_362 VGND VGND VPWR VPWR sky130_fd_sc_hd__fill_2
XFILLER_0_56_329 VGND VGND VPWR VPWR sky130_fd_sc_hd__decap_3
XFILLER_0_64_373 VGND VGND VPWR VPWR sky130_fd_sc_hd__decap_8
XFILLER_0_58_27 VGND VGND VPWR VPWR sky130_fd_sc_hd__fill_1
XFILLER_0_20_421 VGND VGND VPWR VPWR sky130_fd_sc_hd__decap_4
XFILLER_0_58_49 VGND VGND VPWR VPWR sky130_fd_sc_hd__fill_1
XTAP_TAPCELL_ROW_35_438 VGND VPWR sky130_fd_sc_hd__tapvpwrvgnd_1
XFILLER_0_70_321 VPWR VGND VPWR VGND sky130_ef_sc_hd__decap_12
XFILLER_0_55_384 VGND VGND VPWR VPWR sky130_fd_sc_hd__decap_8
X_3654_ clknet_leaf_17_clk _0025_ VGND VGND VPWR VPWR display.counter\[8\] sky130_fd_sc_hd__dfxtp_1
XFILLER_0_15_237 VGND VGND VPWR VPWR sky130_fd_sc_hd__decap_4
X_1984_ reg_file.registers\[5\]\[25\] _0564_ _0568_ reg_file.registers\[15\]\[25\]
+ VGND VGND VPWR VPWR _0582_ sky130_fd_sc_hd__a22o_1
XPHY_EDGE_ROW_21_Left_93 VGND VGND VPWR VPWR sky130_fd_sc_hd__decap_3
XFILLER_0_70_365 VPWR VGND VPWR VGND sky130_ef_sc_hd__decap_12
X_3585_ clknet_leaf_5_clk _0347_ _0158_ VGND VGND VPWR VPWR reg_file.registers\[5\]\[5\]
+ sky130_fd_sc_hd__dfrtp_1
X_2467_ _1063_ VGND VGND VPWR VPWR _1064_ sky130_fd_sc_hd__clkbuf_4
XFILLER_0_2_197 VPWR VGND VPWR VGND sky130_ef_sc_hd__decap_12
XFILLER_0_2_153 VPWR VGND VPWR VGND sky130_ef_sc_hd__decap_12
X_2536_ reg_file.registers\[11\]\[25\] _1114_ _1115_ reg_file.registers\[10\]\[25\]
+ VGND VGND VPWR VPWR _1133_ sky130_fd_sc_hd__a22o_1
X_2605_ _0700_ VGND VGND VPWR VPWR _1201_ sky130_fd_sc_hd__inv_2
X_2398_ _0995_ VGND VGND VPWR VPWR _0996_ sky130_fd_sc_hd__clkbuf_4
XFILLER_0_47_3 VGND VGND VPWR VPWR sky130_fd_sc_hd__decap_4
XFILLER_0_3_51 VGND VGND VPWR VPWR sky130_fd_sc_hd__decap_4
X_3019_ imem.address\[22\] _1530_ VGND VGND VPWR VPWR _0236_ sky130_fd_sc_hd__xor2_1
XFILLER_0_46_351 VGND VGND VPWR VPWR sky130_fd_sc_hd__decap_3
XFILLER_0_38_329 VGND VGND VPWR VPWR sky130_fd_sc_hd__fill_1
XFILLER_0_61_321 VGND VGND VPWR VPWR sky130_fd_sc_hd__fill_2
XFILLER_0_46_373 VGND VGND VPWR VPWR sky130_fd_sc_hd__fill_1
XFILLER_0_69_443 VGND VGND VPWR VPWR sky130_fd_sc_hd__decap_4
XFILLER_0_44_29 VGND VGND VPWR VPWR sky130_fd_sc_hd__decap_3
XFILLER_0_71_107 VGND VGND VPWR VPWR sky130_fd_sc_hd__decap_4
XTAP_TAPCELL_ROW_40_474 VGND VPWR sky130_fd_sc_hd__tapvpwrvgnd_1
XTAP_TAPCELL_ROW_32_408 VGND VPWR sky130_fd_sc_hd__tapvpwrvgnd_1
XFILLER_0_4_407 VGND VGND VPWR VPWR sky130_fd_sc_hd__fill_1
XFILLER_0_8_29 VPWR VGND VPWR VGND sky130_ef_sc_hd__decap_12
XFILLER_0_69_15 VPWR VGND VPWR VGND sky130_ef_sc_hd__decap_12
X_3370_ _1711_ VGND VGND VPWR VPWR _0154_ sky130_fd_sc_hd__inv_2
X_2321_ _0890_ _0918_ _0891_ VGND VGND VPWR VPWR _0919_ sky130_fd_sc_hd__o21ba_1
XFILLER_0_20_262 VGND VGND VPWR VPWR sky130_fd_sc_hd__decap_6
XTAP_TAPCELL_ROW_48_541 VGND VPWR sky130_fd_sc_hd__tapvpwrvgnd_1
X_2252_ _0801_ _0802_ _0807_ VGND VGND VPWR VPWR _0850_ sky130_fd_sc_hd__and3_1
X_2183_ _0776_ _0780_ VGND VGND VPWR VPWR _0781_ sky130_fd_sc_hd__nand2_2
XFILLER_0_18_41 VPWR VGND VPWR VGND sky130_ef_sc_hd__decap_12
XFILLER_0_7_223 VGND VGND VPWR VPWR sky130_fd_sc_hd__fill_1
X_1967_ _0455_ net59 _0469_ _0474_ VGND VGND VPWR VPWR _0565_ sky130_fd_sc_hd__and4b_1
XFILLER_0_43_354 VGND VGND VPWR VPWR sky130_fd_sc_hd__fill_2
XFILLER_0_43_321 VGND VGND VPWR VPWR sky130_fd_sc_hd__fill_1
X_1898_ reg_file.registers\[10\]\[27\] _0519_ VGND VGND VPWR VPWR _0524_ sky130_fd_sc_hd__and2_1
X_3637_ clknet_leaf_20_clk _0399_ _0210_ VGND VGND VPWR VPWR reg_file.registers\[2\]\[26\]
+ sky130_fd_sc_hd__dfrtp_1
X_3499_ clknet_leaf_4_clk _0261_ _0072_ VGND VGND VPWR VPWR reg_file.registers\[15\]\[15\]
+ sky130_fd_sc_hd__dfrtp_1
X_2519_ reg_file.registers\[11\]\[18\] _1114_ _1115_ reg_file.registers\[10\]\[18\]
+ VGND VGND VPWR VPWR _1116_ sky130_fd_sc_hd__a22o_1
XFILLER_0_11_273 VGND VGND VPWR VPWR sky130_fd_sc_hd__decap_6
X_3568_ clknet_leaf_18_clk _0330_ _0141_ VGND VGND VPWR VPWR reg_file.registers\[10\]\[20\]
+ sky130_fd_sc_hd__dfrtp_2
XTAP_TAPCELL_ROW_3_177 VGND VPWR sky130_fd_sc_hd__tapvpwrvgnd_1
XTAP_TAPCELL_ROW_54_588 VGND VPWR sky130_fd_sc_hd__tapvpwrvgnd_1
XFILLER_0_38_137 VGND VGND VPWR VPWR sky130_fd_sc_hd__decap_3
XFILLER_0_34_321 VGND VGND VPWR VPWR sky130_fd_sc_hd__decap_8
XFILLER_0_34_365 VPWR VGND VPWR VGND sky130_ef_sc_hd__decap_12
XFILLER_0_71_27 VGND VGND VPWR VPWR sky130_fd_sc_hd__fill_1
X_2870_ reg_file.registers\[11\]\[8\] _1444_ _1376_ VGND VGND VPWR VPWR _1445_ sky130_fd_sc_hd__mux2_1
Xclkbuf_leaf_10_clk clknet_1_1__leaf_clk VGND VGND VPWR VPWR clknet_leaf_10_clk sky130_fd_sc_hd__clkbuf_8
X_1821_ _0482_ VGND VGND VPWR VPWR _0483_ sky130_fd_sc_hd__buf_2
XFILLER_0_40_324 VPWR VGND VPWR VGND sky130_ef_sc_hd__decap_12
XFILLER_0_37_181 VGND VGND VPWR VPWR sky130_fd_sc_hd__decap_8
X_1752_ _0430_ VGND VGND VPWR VPWR _0390_ sky130_fd_sc_hd__clkbuf_1
XFILLER_0_25_376 VPWR VGND VPWR VGND sky130_ef_sc_hd__decap_12
X_3422_ _1718_ VGND VGND VPWR VPWR _0199_ sky130_fd_sc_hd__inv_2
X_2304_ reg_file.registers\[11\]\[17\] _0693_ _0901_ VGND VGND VPWR VPWR _0902_ sky130_fd_sc_hd__a21oi_2
XFILLER_0_0_421 VPWR VGND VPWR VGND sky130_ef_sc_hd__decap_12
X_3353_ _1704_ VGND VGND VPWR VPWR _1708_ sky130_fd_sc_hd__buf_4
X_3284_ _1698_ VGND VGND VPWR VPWR _0081_ sky130_fd_sc_hd__inv_2
X_2166_ _0761_ _0763_ VGND VGND VPWR VPWR _0764_ sky130_fd_sc_hd__xnor2_1
X_2097_ net17 VGND VGND VPWR VPWR _0695_ sky130_fd_sc_hd__inv_2
X_2235_ reg_file.registers\[10\]\[9\] net19 _0732_ VGND VGND VPWR VPWR _0833_ sky130_fd_sc_hd__and3_1
XTAP_TAPCELL_ROW_0_158 VGND VPWR sky130_fd_sc_hd__tapvpwrvgnd_1
XTAP_TAPCELL_ROW_0_147 VGND VPWR sky130_fd_sc_hd__tapvpwrvgnd_1
XFILLER_0_63_449 VGND VGND VPWR VPWR sky130_fd_sc_hd__fill_2
X_2999_ imem.address\[26\] imem.address\[25\] _1532_ VGND VGND VPWR VPWR _1533_ sky130_fd_sc_hd__and3_1
XFILLER_0_48_435 VPWR VGND VPWR VGND sky130_ef_sc_hd__decap_12
XPHY_EDGE_ROW_3_Right_3 VGND VGND VPWR VPWR sky130_fd_sc_hd__decap_3
XFILLER_0_0_41 VPWR VGND VPWR VGND sky130_ef_sc_hd__decap_12
XFILLER_0_0_85 VPWR VGND VPWR VGND sky130_ef_sc_hd__decap_12
XFILLER_0_31_346 VGND VGND VPWR VPWR sky130_fd_sc_hd__decap_6
XFILLER_0_3_281 VPWR VGND VPWR VGND sky130_ef_sc_hd__decap_12
XFILLER_0_16_365 VGND VGND VPWR VPWR sky130_fd_sc_hd__decap_8
XTAP_TAPCELL_ROW_59_625 VGND VPWR sky130_fd_sc_hd__tapvpwrvgnd_1
Xclkbuf_1_1__f_clk clknet_0_clk VGND VGND VPWR VPWR clknet_1_1__leaf_clk sky130_fd_sc_hd__clkbuf_16
XTAP_TAPCELL_ROW_67_691 VGND VPWR sky130_fd_sc_hd__tapvpwrvgnd_1
XFILLER_0_54_438 VPWR VGND VPWR VGND sky130_ef_sc_hd__decap_12
X_2020_ reg_file.registers\[2\]\[7\] _0557_ VGND VGND VPWR VPWR _0618_ sky130_fd_sc_hd__and2_1
XFILLER_0_57_276 VGND VGND VPWR VPWR sky130_fd_sc_hd__decap_4
XFILLER_0_57_221 VGND VGND VPWR VPWR sky130_fd_sc_hd__decap_3
X_2853_ _0837_ _1399_ _0840_ VGND VGND VPWR VPWR _1431_ sky130_fd_sc_hd__o21bai_1
XFILLER_0_45_449 VGND VGND VPWR VPWR sky130_fd_sc_hd__fill_2
X_2922_ _1486_ VGND VGND VPWR VPWR _0276_ sky130_fd_sc_hd__clkbuf_1
XTAP_TAPCELL_ROW_13_260 VGND VPWR sky130_fd_sc_hd__tapvpwrvgnd_1
X_1804_ _0448_ _0465_ net58 VGND VGND VPWR VPWR _0466_ sky130_fd_sc_hd__nor3_4
X_2784_ _0892_ _0893_ _1369_ VGND VGND VPWR VPWR _1370_ sky130_fd_sc_hd__a21oi_1
XFILLER_0_31_85 VPWR VGND VPWR VGND sky130_ef_sc_hd__decap_12
X_1735_ reg_file.registers\[2\]\[25\] VGND VGND VPWR VPWR _0422_ sky130_fd_sc_hd__clkbuf_1
XFILLER_0_13_335 VGND VGND VPWR VPWR sky130_fd_sc_hd__fill_1
X_3336_ _1706_ VGND VGND VPWR VPWR _0125_ sky130_fd_sc_hd__inv_2
X_3405_ _1714_ VGND VGND VPWR VPWR _1716_ sky130_fd_sc_hd__buf_1
X_3267_ _1696_ VGND VGND VPWR VPWR _0066_ sky130_fd_sc_hd__inv_2
X_2149_ reg_file.registers\[11\]\[3\] _0691_ _0697_ reg_file.registers\[10\]\[3\]
+ VGND VGND VPWR VPWR _0747_ sky130_fd_sc_hd__a22o_1
XTAP_TAPCELL_ROW_56_606 VGND VPWR sky130_fd_sc_hd__tapvpwrvgnd_1
X_2218_ _0814_ _0815_ VGND VGND VPWR VPWR _0816_ sky130_fd_sc_hd__xor2_2
X_3198_ display.counter\[10\] _1674_ display.counter\[11\] VGND VGND VPWR VPWR _1677_
+ sky130_fd_sc_hd__a21oi_1
XFILLER_0_63_279 VGND VGND VPWR VPWR sky130_fd_sc_hd__fill_1
XFILLER_0_48_265 VGND VGND VPWR VPWR sky130_fd_sc_hd__decap_8
XFILLER_0_31_187 VPWR VGND VPWR VGND sky130_ef_sc_hd__decap_12
XTAP_TAPCELL_ROW_19_308 VGND VPWR sky130_fd_sc_hd__tapvpwrvgnd_1
XFILLER_0_54_224 VGND VGND VPWR VPWR sky130_fd_sc_hd__fill_1
XFILLER_0_27_449 VGND VGND VPWR VPWR sky130_fd_sc_hd__fill_2
XTAP_TAPCELL_ROW_27_374 VGND VPWR sky130_fd_sc_hd__tapvpwrvgnd_1
XFILLER_0_22_165 VGND VGND VPWR VPWR sky130_fd_sc_hd__decap_8
X_3121_ _1128_ _1187_ _1305_ _1306_ _1332_ VGND VGND VPWR VPWR _1620_ sky130_fd_sc_hd__o2111a_1
X_3052_ _0458_ _0479_ VGND VGND VPWR VPWR _0216_ sky130_fd_sc_hd__xnor2_1
X_2003_ reg_file.registers\[2\]\[0\] net39 net60 reg_file.registers\[10\]\[0\] VGND
+ VGND VPWR VPWR _0601_ sky130_fd_sc_hd__a22o_1
XFILLER_0_26_85 VPWR VGND VPWR VGND sky130_ef_sc_hd__decap_12
X_2905_ _1473_ VGND VGND VPWR VPWR _0280_ sky130_fd_sc_hd__clkbuf_1
XTAP_TAPCELL_ROW_61_642 VGND VPWR sky130_fd_sc_hd__tapvpwrvgnd_1
X_2836_ _1416_ VGND VGND VPWR VPWR _0292_ sky130_fd_sc_hd__clkbuf_1
XFILLER_0_9_137 VPWR VGND VPWR VGND sky130_ef_sc_hd__decap_12
XFILLER_0_53_290 VGND VGND VPWR VPWR sky130_fd_sc_hd__fill_1
X_2767_ _1107_ _1353_ _1354_ _1332_ VGND VGND VPWR VPWR _1355_ sky130_fd_sc_hd__o211a_1
X_2698_ _0750_ _1267_ _1277_ _1288_ _1290_ VGND VGND VPWR VPWR _1291_ sky130_fd_sc_hd__a221o_1
XFILLER_0_5_376 VGND VGND VPWR VPWR sky130_fd_sc_hd__decap_8
XFILLER_0_13_110 VGND VGND VPWR VPWR sky130_fd_sc_hd__fill_2
XFILLER_0_13_143 VGND VGND VPWR VPWR sky130_fd_sc_hd__fill_1
X_3319_ _1691_ VGND VGND VPWR VPWR _1704_ sky130_fd_sc_hd__buf_2
Xrebuffer40 net55 VGND VGND VPWR VPWR net56 sky130_fd_sc_hd__dlymetal6s2s_1
XTAP_TAPCELL_ROW_24_344 VGND VPWR sky130_fd_sc_hd__tapvpwrvgnd_1
XFILLER_0_59_305 VGND VGND VPWR VPWR sky130_fd_sc_hd__decap_8
XFILLER_0_67_393 VPWR VGND VPWR VGND sky130_ef_sc_hd__decap_12
X_3670_ clknet_leaf_12_clk _0412_ VGND VGND VPWR VPWR net6 sky130_fd_sc_hd__dfxtp_1
XFILLER_0_27_235 VPWR VGND VPWR VGND sky130_ef_sc_hd__decap_12
XFILLER_0_12_65 VPWR VGND VPWR VGND sky130_ef_sc_hd__decap_12
X_2483_ _1075_ _1079_ _1018_ VGND VGND VPWR VPWR _1080_ sky130_fd_sc_hd__mux2_1
X_2621_ _1097_ _1101_ _1017_ VGND VGND VPWR VPWR _1216_ sky130_fd_sc_hd__mux2_1
X_2552_ _1108_ _1127_ _1136_ _1148_ VGND VGND VPWR VPWR _1149_ sky130_fd_sc_hd__o211a_1
XFILLER_0_2_357 VGND VGND VPWR VPWR sky130_fd_sc_hd__decap_6
X_3035_ imem.address\[12\] _1523_ VGND VGND VPWR VPWR _1550_ sky130_fd_sc_hd__nor2_1
X_3104_ reg_file.registers\[5\]\[4\] VGND VGND VPWR VPWR _1604_ sky130_fd_sc_hd__inv_2
XFILLER_0_58_371 VPWR VGND VPWR VGND sky130_ef_sc_hd__decap_12
XTAP_TAPCELL_ROW_38_458 VGND VPWR sky130_fd_sc_hd__tapvpwrvgnd_1
X_2819_ _0845_ _1400_ _0804_ VGND VGND VPWR VPWR _1401_ sky130_fd_sc_hd__o21a_1
XFILLER_0_41_260 VPWR VGND VPWR VGND sky130_ef_sc_hd__decap_12
XFILLER_0_33_249 VGND VGND VPWR VPWR sky130_fd_sc_hd__decap_3
XFILLER_0_18_246 VGND VGND VPWR VPWR sky130_fd_sc_hd__fill_1
XTAP_TAPCELL_ROW_21_325 VGND VPWR sky130_fd_sc_hd__tapvpwrvgnd_1
XFILLER_0_41_293 VGND VGND VPWR VPWR sky130_fd_sc_hd__decap_4
XFILLER_0_64_352 VGND VGND VPWR VPWR sky130_fd_sc_hd__decap_6
XFILLER_0_49_393 VGND VGND VPWR VPWR sky130_fd_sc_hd__decap_8
XFILLER_0_59_157 VGND VGND VPWR VPWR sky130_fd_sc_hd__decap_4
XFILLER_0_47_319 VGND VGND VPWR VPWR sky130_fd_sc_hd__fill_1
XTAP_TAPCELL_ROW_35_439 VGND VPWR sky130_fd_sc_hd__tapvpwrvgnd_1
XFILLER_0_70_377 VPWR VGND VPWR VGND sky130_ef_sc_hd__decap_12
XFILLER_0_70_333 VPWR VGND VPWR VGND sky130_ef_sc_hd__decap_12
XFILLER_0_67_190 VGND VGND VPWR VPWR sky130_fd_sc_hd__fill_2
X_2604_ _1199_ _0610_ VGND VGND VPWR VPWR _1200_ sky130_fd_sc_hd__nor2_2
XFILLER_0_30_219 VPWR VGND VPWR VGND sky130_ef_sc_hd__decap_12
XFILLER_0_2_121 VPWR VGND VPWR VGND sky130_ef_sc_hd__decap_12
X_3653_ clknet_leaf_17_clk _0024_ VGND VGND VPWR VPWR display.counter\[7\] sky130_fd_sc_hd__dfxtp_1
XFILLER_0_7_449 VGND VGND VPWR VPWR sky130_fd_sc_hd__fill_2
XFILLER_0_15_205 VPWR VGND VPWR VGND sky130_ef_sc_hd__decap_12
X_1983_ _0575_ _0577_ _0580_ VGND VGND VPWR VPWR _0581_ sky130_fd_sc_hd__a21oi_2
X_2466_ _0560_ _0476_ VGND VGND VPWR VPWR _1063_ sky130_fd_sc_hd__nor2_4
X_3584_ clknet_leaf_3_clk _0346_ _0157_ VGND VGND VPWR VPWR reg_file.registers\[5\]\[4\]
+ sky130_fd_sc_hd__dfrtp_4
XFILLER_0_2_165 VPWR VGND VPWR VGND sky130_ef_sc_hd__decap_12
X_2535_ reg_file.registers\[11\]\[26\] _1114_ _1115_ reg_file.registers\[10\]\[26\]
+ VGND VGND VPWR VPWR _1132_ sky130_fd_sc_hd__a22o_1
XFILLER_0_64_93 VGND VGND VPWR VPWR sky130_fd_sc_hd__fill_1
X_3018_ _1531_ _1543_ VGND VGND VPWR VPWR _0237_ sky130_fd_sc_hd__nor2_1
X_2397_ _0994_ VGND VGND VPWR VPWR _0995_ sky130_fd_sc_hd__clkbuf_4
XFILLER_0_65_105 VGND VGND VPWR VPWR sky130_fd_sc_hd__decap_6
XFILLER_0_46_363 VGND VGND VPWR VPWR sky130_fd_sc_hd__fill_1
XFILLER_0_46_341 VGND VGND VPWR VPWR sky130_fd_sc_hd__fill_1
XFILLER_0_61_344 VPWR VGND VPWR VGND sky130_ef_sc_hd__decap_12
XFILLER_0_14_260 VGND VGND VPWR VPWR sky130_fd_sc_hd__fill_2
XFILLER_0_14_293 VGND VGND VPWR VPWR sky130_fd_sc_hd__fill_1
XFILLER_0_60_18 VGND VGND VPWR VPWR sky130_fd_sc_hd__fill_1
XTAP_TAPCELL_ROW_32_409 VGND VPWR sky130_fd_sc_hd__tapvpwrvgnd_1
XFILLER_0_69_27 VGND VGND VPWR VPWR sky130_fd_sc_hd__decap_8
XFILLER_0_56_149 VGND VGND VPWR VPWR sky130_fd_sc_hd__fill_1
XFILLER_0_52_333 VPWR VGND VPWR VGND sky130_ef_sc_hd__decap_12
XTAP_TAPCELL_ROW_40_475 VGND VPWR sky130_fd_sc_hd__tapvpwrvgnd_1
XFILLER_0_4_419 VGND VGND VPWR VPWR sky130_fd_sc_hd__fill_1
X_2251_ _0776_ _0805_ _0848_ VGND VGND VPWR VPWR _0849_ sky130_fd_sc_hd__o21a_1
X_2320_ _0892_ _0917_ VGND VGND VPWR VPWR _0918_ sky130_fd_sc_hd__nand2_1
XFILLER_0_20_285 VGND VGND VPWR VPWR sky130_fd_sc_hd__decap_8
XTAP_TAPCELL_ROW_48_542 VGND VPWR sky130_fd_sc_hd__tapvpwrvgnd_1
X_2182_ _0574_ _0777_ _0779_ VGND VGND VPWR VPWR _0780_ sky130_fd_sc_hd__a21oi_1
XFILLER_0_18_53 VGND VGND VPWR VPWR sky130_fd_sc_hd__decap_8
XFILLER_0_55_160 VGND VGND VPWR VPWR sky130_fd_sc_hd__fill_1
X_1966_ _0563_ VGND VGND VPWR VPWR _0564_ sky130_fd_sc_hd__clkbuf_4
XFILLER_0_70_141 VGND VGND VPWR VPWR sky130_fd_sc_hd__fill_1
XFILLER_0_43_344 VGND VGND VPWR VPWR sky130_fd_sc_hd__decap_3
X_3567_ clknet_leaf_15_clk _0329_ _0140_ VGND VGND VPWR VPWR reg_file.registers\[10\]\[19\]
+ sky130_fd_sc_hd__dfrtp_1
XFILLER_0_3_441 VGND VGND VPWR VPWR sky130_fd_sc_hd__decap_6
XFILLER_0_7_279 VGND VGND VPWR VPWR sky130_fd_sc_hd__fill_1
X_1897_ _0523_ VGND VGND VPWR VPWR _0338_ sky130_fd_sc_hd__clkbuf_1
X_3636_ clknet_leaf_20_clk _0398_ _0209_ VGND VGND VPWR VPWR reg_file.registers\[2\]\[25\]
+ sky130_fd_sc_hd__dfrtp_1
X_2449_ _0731_ _0711_ _1046_ VGND VGND VPWR VPWR _1047_ sky130_fd_sc_hd__o21ai_1
X_3498_ clknet_leaf_1_clk _0260_ _0071_ VGND VGND VPWR VPWR reg_file.registers\[15\]\[14\]
+ sky130_fd_sc_hd__dfrtp_1
X_2518_ _1073_ VGND VGND VPWR VPWR _1115_ sky130_fd_sc_hd__buf_2
XTAP_TAPCELL_ROW_3_178 VGND VPWR sky130_fd_sc_hd__tapvpwrvgnd_1
XTAP_TAPCELL_ROW_54_589 VGND VPWR sky130_fd_sc_hd__tapvpwrvgnd_1
XPHY_EDGE_ROW_49_Left_121 VGND VGND VPWR VPWR sky130_fd_sc_hd__decap_3
XFILLER_0_38_149 VGND VGND VPWR VPWR sky130_fd_sc_hd__fill_2
XFILLER_0_34_377 VGND VGND VPWR VPWR sky130_fd_sc_hd__decap_3
XFILLER_0_19_352 VGND VGND VPWR VPWR sky130_fd_sc_hd__fill_1
XFILLER_0_19_374 VGND VGND VPWR VPWR sky130_fd_sc_hd__fill_1
XPHY_EDGE_ROW_58_Left_130 VGND VGND VPWR VPWR sky130_fd_sc_hd__decap_3
XFILLER_0_69_230 VGND VGND VPWR VPWR sky130_fd_sc_hd__fill_1
X_1820_ _0447_ _0481_ VGND VGND VPWR VPWR _0482_ sky130_fd_sc_hd__or2_2
XFILLER_0_57_447 VGND VGND VPWR VPWR sky130_fd_sc_hd__fill_1
XTAP_TAPCELL_ROW_45_512 VGND VPWR sky130_fd_sc_hd__tapvpwrvgnd_1
XFILLER_0_52_185 VGND VGND VPWR VPWR sky130_fd_sc_hd__decap_3
XFILLER_0_52_163 VGND VGND VPWR VPWR sky130_fd_sc_hd__decap_8
XFILLER_0_52_130 VGND VGND VPWR VPWR sky130_fd_sc_hd__decap_8
XFILLER_0_40_336 VGND VGND VPWR VPWR sky130_fd_sc_hd__fill_1
X_1751_ reg_file.registers\[2\]\[17\] VGND VGND VPWR VPWR _0430_ sky130_fd_sc_hd__clkbuf_1
X_3421_ _1718_ VGND VGND VPWR VPWR _0198_ sky130_fd_sc_hd__inv_2
XFILLER_0_25_388 VGND VGND VPWR VPWR sky130_fd_sc_hd__decap_4
XFILLER_0_25_355 VGND VGND VPWR VPWR sky130_fd_sc_hd__fill_1
X_2234_ _0622_ _0823_ _0830_ _0831_ VGND VGND VPWR VPWR _0832_ sky130_fd_sc_hd__a2bb2o_1
X_2303_ reg_file.registers\[10\]\[17\] _0785_ _0786_ VGND VGND VPWR VPWR _0901_ sky130_fd_sc_hd__and3_1
X_3352_ _1707_ VGND VGND VPWR VPWR _0140_ sky130_fd_sc_hd__inv_2
X_3283_ _1698_ VGND VGND VPWR VPWR _0080_ sky130_fd_sc_hd__inv_2
XFILLER_0_0_433 VPWR VGND VPWR VGND sky130_ef_sc_hd__decap_12
X_2165_ _0762_ VGND VGND VPWR VPWR _0763_ sky130_fd_sc_hd__inv_2
XFILLER_0_48_414 VGND VGND VPWR VPWR sky130_fd_sc_hd__decap_6
XTAP_TAPCELL_ROW_0_159 VGND VPWR sky130_fd_sc_hd__tapvpwrvgnd_1
XTAP_TAPCELL_ROW_0_148 VGND VPWR sky130_fd_sc_hd__tapvpwrvgnd_1
X_2096_ _0693_ VGND VGND VPWR VPWR _0694_ sky130_fd_sc_hd__clkbuf_4
X_1949_ _0550_ VGND VGND VPWR VPWR _0313_ sky130_fd_sc_hd__clkbuf_1
X_2998_ imem.address\[24\] _1531_ VGND VGND VPWR VPWR _1532_ sky130_fd_sc_hd__and2_1
XFILLER_0_48_447 VGND VGND VPWR VPWR sky130_fd_sc_hd__decap_4
XFILLER_0_0_53 VGND VGND VPWR VPWR sky130_fd_sc_hd__decap_3
XFILLER_0_0_97 VPWR VGND VPWR VGND sky130_ef_sc_hd__decap_12
XFILLER_0_9_51 VGND VGND VPWR VPWR sky130_fd_sc_hd__decap_4
XTAP_TAPCELL_ROW_16_280 VGND VPWR sky130_fd_sc_hd__tapvpwrvgnd_1
XFILLER_0_16_300 VGND VGND VPWR VPWR sky130_fd_sc_hd__decap_8
XFILLER_0_16_322 VGND VGND VPWR VPWR sky130_fd_sc_hd__decap_3
XFILLER_0_16_333 VPWR VGND VPWR VGND sky130_ef_sc_hd__decap_12
X_3619_ clknet_leaf_4_clk _0381_ _0192_ VGND VGND VPWR VPWR reg_file.registers\[2\]\[8\]
+ sky130_fd_sc_hd__dfrtp_1
XFILLER_0_43_163 VGND VGND VPWR VPWR sky130_fd_sc_hd__fill_1
XFILLER_0_31_369 VGND VGND VPWR VPWR sky130_fd_sc_hd__decap_4
XFILLER_0_3_293 VPWR VGND VPWR VGND sky130_ef_sc_hd__decap_12
XFILLER_0_16_388 VPWR VGND VPWR VGND sky130_ef_sc_hd__decap_12
XTAP_TAPCELL_ROW_59_626 VGND VPWR sky130_fd_sc_hd__tapvpwrvgnd_1
XTAP_TAPCELL_ROW_67_692 VGND VPWR sky130_fd_sc_hd__tapvpwrvgnd_1
XFILLER_0_34_174 VGND VGND VPWR VPWR sky130_fd_sc_hd__fill_2
XFILLER_0_34_141 VGND VGND VPWR VPWR sky130_fd_sc_hd__decap_8
XFILLER_0_57_211 VGND VGND VPWR VPWR sky130_fd_sc_hd__decap_3
XPHY_EDGE_ROW_13_Right_13 VGND VGND VPWR VPWR sky130_fd_sc_hd__decap_3
X_1803_ _0452_ _0453_ _0456_ _0464_ VGND VGND VPWR VPWR _0465_ sky130_fd_sc_hd__or4_1
X_2852_ _1430_ VGND VGND VPWR VPWR _0290_ sky130_fd_sc_hd__clkbuf_1
X_2783_ _1322_ _1323_ net31 VGND VGND VPWR VPWR _1369_ sky130_fd_sc_hd__o21a_1
X_2921_ reg_file.registers\[15\]\[30\] _1484_ VGND VGND VPWR VPWR _1486_ sky130_fd_sc_hd__and2_1
XPHY_EDGE_ROW_22_Right_22 VGND VGND VPWR VPWR sky130_fd_sc_hd__decap_3
XTAP_TAPCELL_ROW_13_261 VGND VPWR sky130_fd_sc_hd__tapvpwrvgnd_1
XFILLER_0_31_97 VPWR VGND VPWR VGND sky130_ef_sc_hd__decap_12
X_3404_ _1715_ VGND VGND VPWR VPWR _0184_ sky130_fd_sc_hd__inv_2
X_1734_ _0421_ VGND VGND VPWR VPWR _0399_ sky130_fd_sc_hd__clkbuf_1
X_3335_ _1706_ VGND VGND VPWR VPWR _0124_ sky130_fd_sc_hd__inv_2
XTAP_TAPCELL_ROW_56_607 VGND VPWR sky130_fd_sc_hd__tapvpwrvgnd_1
XFILLER_0_56_83 VGND VGND VPWR VPWR sky130_fd_sc_hd__fill_1
X_3266_ _1696_ VGND VGND VPWR VPWR _0065_ sky130_fd_sc_hd__inv_2
X_2217_ reg_file.registers\[11\]\[11\] _0790_ _0791_ reg_file.registers\[10\]\[11\]
+ VGND VGND VPWR VPWR _0815_ sky130_fd_sc_hd__a22o_1
XPHY_EDGE_ROW_31_Right_31 VGND VGND VPWR VPWR sky130_fd_sc_hd__decap_3
XFILLER_0_22_3 VPWR VGND VPWR VGND sky130_ef_sc_hd__decap_12
X_3197_ display.counter\[10\] display.counter\[11\] _1674_ VGND VGND VPWR VPWR _1676_
+ sky130_fd_sc_hd__and3_1
X_2148_ _0744_ _0745_ VGND VGND VPWR VPWR _0746_ sky130_fd_sc_hd__xor2_1
XFILLER_0_48_211 VGND VGND VPWR VPWR sky130_fd_sc_hd__fill_1
X_2079_ _0676_ _0669_ _0662_ VGND VGND VPWR VPWR _0677_ sky130_fd_sc_hd__nor3_4
XFILLER_0_63_225 VGND VGND VPWR VPWR sky130_fd_sc_hd__decap_6
XPHY_EDGE_ROW_40_Right_40 VGND VGND VPWR VPWR sky130_fd_sc_hd__decap_3
XFILLER_0_16_141 VGND VGND VPWR VPWR sky130_fd_sc_hd__decap_3
XFILLER_0_31_199 VPWR VGND VPWR VGND sky130_ef_sc_hd__decap_12
XTAP_TAPCELL_ROW_19_309 VGND VPWR sky130_fd_sc_hd__tapvpwrvgnd_1
XTAP_TAPCELL_ROW_27_375 VGND VPWR sky130_fd_sc_hd__tapvpwrvgnd_1
XFILLER_0_27_406 VGND VGND VPWR VPWR sky130_fd_sc_hd__decap_4
XFILLER_0_22_144 VGND VGND VPWR VPWR sky130_fd_sc_hd__decap_3
X_3051_ _0459_ _0479_ _1556_ VGND VGND VPWR VPWR _0217_ sky130_fd_sc_hd__o21a_1
X_3120_ _0990_ _1025_ _1019_ _1052_ _1618_ VGND VGND VPWR VPWR _1619_ sky130_fd_sc_hd__a41o_1
XTAP_TAPCELL_ROW_61_643 VGND VPWR sky130_fd_sc_hd__tapvpwrvgnd_1
X_2002_ reg_file.registers\[15\]\[1\] _0599_ _0561_ reg_file.registers\[5\]\[1\] _0555_
+ VGND VGND VPWR VPWR _0600_ sky130_fd_sc_hd__a221o_2
XFILLER_0_26_97 VGND VGND VPWR VPWR sky130_fd_sc_hd__decap_4
XFILLER_0_9_105 VGND VGND VPWR VPWR sky130_fd_sc_hd__decap_6
XFILLER_0_9_149 VPWR VGND VPWR VGND sky130_ef_sc_hd__decap_12
X_2904_ reg_file.registers\[11\]\[2\] _1472_ _1058_ VGND VGND VPWR VPWR _1473_ sky130_fd_sc_hd__mux2_1
XFILLER_0_45_247 VGND VGND VPWR VPWR sky130_fd_sc_hd__decap_4
XFILLER_0_45_225 VGND VGND VPWR VPWR sky130_fd_sc_hd__decap_8
XFILLER_0_42_85 VGND VGND VPWR VPWR sky130_fd_sc_hd__fill_1
X_2835_ reg_file.registers\[11\]\[14\] _1415_ _1376_ VGND VGND VPWR VPWR _1416_ sky130_fd_sc_hd__mux2_1
X_2766_ _0990_ _1189_ VGND VGND VPWR VPWR _1354_ sky130_fd_sc_hd__or2_1
XFILLER_0_13_133 VGND VGND VPWR VPWR sky130_fd_sc_hd__decap_6
XTAP_TAPCELL_ROW_69_710 VGND VPWR sky130_fd_sc_hd__tapvpwrvgnd_1
X_3318_ _1703_ VGND VGND VPWR VPWR _0110_ sky130_fd_sc_hd__inv_2
XFILLER_0_6_41 VPWR VGND VPWR VGND sky130_ef_sc_hd__decap_12
XFILLER_0_6_85 VPWR VGND VPWR VGND sky130_ef_sc_hd__decap_12
X_2697_ _1236_ _1289_ _1063_ VGND VGND VPWR VPWR _1290_ sky130_fd_sc_hd__and3b_1
X_3249_ _1695_ VGND VGND VPWR VPWR _0049_ sky130_fd_sc_hd__inv_2
Xrebuffer41 net56 VGND VGND VPWR VPWR net57 sky130_fd_sc_hd__dlygate4sd1_1
Xrebuffer30 net45 VGND VGND VPWR VPWR net46 sky130_fd_sc_hd__dlymetal6s2s_1
XFILLER_0_36_203 VGND VGND VPWR VPWR sky130_fd_sc_hd__decap_8
XTAP_TAPCELL_ROW_24_345 VGND VPWR sky130_fd_sc_hd__tapvpwrvgnd_1
XFILLER_0_32_431 VGND VGND VPWR VPWR sky130_fd_sc_hd__fill_1
X_2620_ _0742_ _1212_ _1214_ VGND VGND VPWR VPWR _1215_ sky130_fd_sc_hd__a21oi_1
XFILLER_0_12_77 VGND VGND VPWR VPWR sky130_fd_sc_hd__decap_6
XFILLER_0_50_250 VGND VGND VPWR VPWR sky130_fd_sc_hd__fill_2
X_2482_ _1078_ VGND VGND VPWR VPWR _1079_ sky130_fd_sc_hd__inv_2
X_2551_ net37 _0971_ _1140_ _1147_ VGND VGND VPWR VPWR _1148_ sky130_fd_sc_hd__o211a_1
X_3034_ imem.address\[13\] _1524_ VGND VGND VPWR VPWR _0227_ sky130_fd_sc_hd__xor2_1
XTAP_TAPCELL_ROW_38_459 VGND VPWR sky130_fd_sc_hd__tapvpwrvgnd_1
X_3103_ _0991_ _1015_ _1026_ _1597_ _1602_ VGND VGND VPWR VPWR _1603_ sky130_fd_sc_hd__a221o_1
XFILLER_0_58_383 VPWR VGND VPWR VGND sky130_ef_sc_hd__decap_12
XFILLER_0_58_350 VGND VGND VPWR VPWR sky130_fd_sc_hd__fill_1
XTAP_TAPCELL_ROW_21_326 VGND VPWR sky130_fd_sc_hd__tapvpwrvgnd_1
X_2818_ _0822_ _0837_ _1399_ VGND VGND VPWR VPWR _1400_ sky130_fd_sc_hd__nor3_1
XFILLER_0_41_272 VGND VGND VPWR VPWR sky130_fd_sc_hd__decap_3
XFILLER_0_33_206 VGND VGND VPWR VPWR sky130_fd_sc_hd__decap_3
X_2749_ _0988_ _1326_ VGND VGND VPWR VPWR _1338_ sky130_fd_sc_hd__nor2_1
XFILLER_0_1_391 VGND VGND VPWR VPWR sky130_fd_sc_hd__fill_1
XFILLER_0_49_350 VGND VGND VPWR VPWR sky130_fd_sc_hd__decap_6
XFILLER_0_64_342 VGND VGND VPWR VPWR sky130_fd_sc_hd__decap_4
XPHY_EDGE_ROW_30_Left_102 VGND VGND VPWR VPWR sky130_fd_sc_hd__decap_3
XFILLER_0_58_29 VPWR VGND VPWR VGND sky130_ef_sc_hd__decap_12
XFILLER_0_59_169 VGND VGND VPWR VPWR sky130_fd_sc_hd__fill_1
X_1982_ _0579_ VGND VGND VPWR VPWR _0580_ sky130_fd_sc_hd__buf_2
XFILLER_0_23_65 VGND VGND VPWR VPWR sky130_fd_sc_hd__decap_8
XFILLER_0_70_389 VPWR VGND VPWR VGND sky130_ef_sc_hd__decap_12
XFILLER_0_70_345 VGND VGND VPWR VPWR sky130_fd_sc_hd__decap_4
X_3583_ clknet_leaf_5_clk _0345_ _0156_ VGND VGND VPWR VPWR reg_file.registers\[5\]\[3\]
+ sky130_fd_sc_hd__dfrtp_1
X_2603_ _0590_ VGND VGND VPWR VPWR _1199_ sky130_fd_sc_hd__inv_2
XFILLER_0_2_133 VGND VGND VPWR VPWR sky130_fd_sc_hd__decap_6
X_3652_ clknet_leaf_17_clk _0023_ VGND VGND VPWR VPWR display.counter\[6\] sky130_fd_sc_hd__dfxtp_1
XFILLER_0_15_217 VGND VGND VPWR VPWR sky130_fd_sc_hd__decap_6
X_2534_ _1129_ _1130_ _1069_ VGND VGND VPWR VPWR _1131_ sky130_fd_sc_hd__mux2_1
X_2396_ _0731_ VGND VGND VPWR VPWR _0994_ sky130_fd_sc_hd__clkbuf_4
XFILLER_0_2_177 VPWR VGND VPWR VGND sky130_ef_sc_hd__decap_12
X_2465_ _0964_ _0973_ _1061_ VGND VGND VPWR VPWR _1062_ sky130_fd_sc_hd__or3_4
XFILLER_0_64_61 VGND VGND VPWR VPWR sky130_fd_sc_hd__decap_4
X_3017_ imem.address\[22\] _1530_ imem.address\[23\] VGND VGND VPWR VPWR _1543_ sky130_fd_sc_hd__a21oi_1
XFILLER_0_38_309 VPWR VGND VPWR VGND sky130_ef_sc_hd__decap_12
XFILLER_0_61_301 VGND VGND VPWR VPWR sky130_fd_sc_hd__decap_3
XFILLER_0_61_356 VPWR VGND VPWR VGND sky130_ef_sc_hd__decap_12
XPHY_EDGE_ROW_69_Right_69 VGND VGND VPWR VPWR sky130_fd_sc_hd__decap_3
XFILLER_0_56_139 VGND VGND VPWR VPWR sky130_fd_sc_hd__fill_1
XFILLER_0_52_345 VPWR VGND VPWR VGND sky130_ef_sc_hd__decap_12
XTAP_TAPCELL_ROW_40_476 VGND VPWR sky130_fd_sc_hd__tapvpwrvgnd_1
XFILLER_0_12_209 VPWR VGND VPWR VGND sky130_ef_sc_hd__decap_12
X_2250_ _0847_ VGND VGND VPWR VPWR _0848_ sky130_fd_sc_hd__inv_2
XTAP_TAPCELL_ROW_48_543 VGND VPWR sky130_fd_sc_hd__tapvpwrvgnd_1
X_2181_ _0574_ _0778_ _0579_ VGND VGND VPWR VPWR _0779_ sky130_fd_sc_hd__a21o_1
XFILLER_0_18_76 VGND VGND VPWR VPWR sky130_fd_sc_hd__decap_3
XFILLER_0_50_85 VPWR VGND VPWR VGND sky130_ef_sc_hd__decap_12
XFILLER_0_47_139 VGND VGND VPWR VPWR sky130_fd_sc_hd__fill_2
X_1965_ _0562_ VGND VGND VPWR VPWR _0563_ sky130_fd_sc_hd__buf_2
XFILLER_0_7_225 VPWR VGND VPWR VGND sky130_ef_sc_hd__decap_12
XFILLER_0_70_186 VGND VGND VPWR VPWR sky130_fd_sc_hd__fill_1
XFILLER_0_43_367 VGND VGND VPWR VPWR sky130_fd_sc_hd__fill_1
X_3497_ clknet_leaf_4_clk _0259_ _0070_ VGND VGND VPWR VPWR reg_file.registers\[15\]\[13\]
+ sky130_fd_sc_hd__dfrtp_1
X_3566_ clknet_leaf_14_clk _0328_ _0139_ VGND VGND VPWR VPWR reg_file.registers\[10\]\[18\]
+ sky130_fd_sc_hd__dfrtp_1
X_2517_ _1071_ VGND VGND VPWR VPWR _1114_ sky130_fd_sc_hd__buf_2
X_1896_ reg_file.registers\[10\]\[28\] _0519_ VGND VGND VPWR VPWR _0523_ sky130_fd_sc_hd__and2_1
X_3635_ clknet_leaf_20_clk _0397_ _0208_ VGND VGND VPWR VPWR reg_file.registers\[2\]\[24\]
+ sky130_fd_sc_hd__dfrtp_1
X_2448_ _0731_ _0707_ VGND VGND VPWR VPWR _1046_ sky130_fd_sc_hd__nand2_1
XFILLER_0_52_3 VPWR VGND VPWR VGND sky130_ef_sc_hd__decap_12
X_2379_ _0964_ _0973_ _0976_ VGND VGND VPWR VPWR _0977_ sky130_fd_sc_hd__o21ai_1
XTAP_TAPCELL_ROW_3_179 VGND VPWR sky130_fd_sc_hd__tapvpwrvgnd_1
XFILLER_0_46_194 VGND VGND VPWR VPWR sky130_fd_sc_hd__fill_2
XFILLER_0_46_150 VPWR VGND VPWR VGND sky130_ef_sc_hd__decap_12
XFILLER_0_71_29 VPWR VGND VPWR VGND sky130_ef_sc_hd__decap_12
XTAP_TAPCELL_ROW_45_513 VGND VPWR sky130_fd_sc_hd__tapvpwrvgnd_1
XFILLER_0_52_120 VGND VGND VPWR VPWR sky130_fd_sc_hd__decap_3
XFILLER_0_37_161 VGND VGND VPWR VPWR sky130_fd_sc_hd__decap_6
X_1750_ _0429_ VGND VGND VPWR VPWR _0391_ sky130_fd_sc_hd__clkbuf_1
X_3351_ _1707_ VGND VGND VPWR VPWR _0139_ sky130_fd_sc_hd__inv_2
X_3420_ _1714_ VGND VGND VPWR VPWR _1718_ sky130_fd_sc_hd__buf_4
XFILLER_0_0_445 VGND VGND VPWR VPWR sky130_fd_sc_hd__decap_3
X_2233_ _0448_ net27 _0454_ _0460_ VGND VGND VPWR VPWR _0831_ sky130_fd_sc_hd__or4_1
X_2164_ reg_file.registers\[11\]\[5\] _0691_ _0697_ reg_file.registers\[10\]\[5\]
+ VGND VGND VPWR VPWR _0762_ sky130_fd_sc_hd__a22o_1
X_2302_ _0655_ _0899_ _0884_ VGND VGND VPWR VPWR _0900_ sky130_fd_sc_hd__o21a_1
X_3282_ _1698_ VGND VGND VPWR VPWR _0079_ sky130_fd_sc_hd__inv_2
X_2095_ _0692_ VGND VGND VPWR VPWR _0693_ sky130_fd_sc_hd__buf_4
XFILLER_0_45_52 VGND VGND VPWR VPWR sky130_fd_sc_hd__decap_4
XTAP_TAPCELL_ROW_0_149 VGND VPWR sky130_fd_sc_hd__tapvpwrvgnd_1
X_1948_ reg_file.registers\[10\]\[3\] _0519_ VGND VGND VPWR VPWR _0550_ sky130_fd_sc_hd__or2b_1
X_2997_ imem.address\[23\] imem.address\[22\] _1530_ VGND VGND VPWR VPWR _1531_ sky130_fd_sc_hd__and3_1
XFILLER_0_61_62 VGND VGND VPWR VPWR sky130_fd_sc_hd__decap_8
X_1879_ _0513_ VGND VGND VPWR VPWR _0346_ sky130_fd_sc_hd__clkbuf_1
XFILLER_0_43_186 VGND VGND VPWR VPWR sky130_fd_sc_hd__fill_1
XFILLER_0_31_326 VGND VGND VPWR VPWR sky130_fd_sc_hd__decap_6
XTAP_TAPCELL_ROW_16_281 VGND VPWR sky130_fd_sc_hd__tapvpwrvgnd_1
XFILLER_0_16_345 VGND VGND VPWR VPWR sky130_fd_sc_hd__decap_8
X_3549_ clknet_leaf_10_clk _0311_ _0122_ VGND VGND VPWR VPWR reg_file.registers\[10\]\[1\]
+ sky130_fd_sc_hd__dfrtp_1
X_3618_ clknet_leaf_5_clk _0380_ _0191_ VGND VGND VPWR VPWR reg_file.registers\[2\]\[7\]
+ sky130_fd_sc_hd__dfrtp_1
XFILLER_0_43_197 VPWR VGND VPWR VGND sky130_ef_sc_hd__decap_12
XFILLER_0_3_261 VPWR VGND VPWR VGND sky130_ef_sc_hd__decap_12
XTAP_TAPCELL_ROW_8_216 VGND VPWR sky130_fd_sc_hd__tapvpwrvgnd_1
XTAP_TAPCELL_ROW_67_693 VGND VPWR sky130_fd_sc_hd__tapvpwrvgnd_1
XTAP_TAPCELL_ROW_59_627 VGND VPWR sky130_fd_sc_hd__tapvpwrvgnd_1
XFILLER_0_34_197 VPWR VGND VPWR VGND sky130_ef_sc_hd__decap_12
XFILLER_0_34_120 VPWR VGND VPWR VGND sky130_ef_sc_hd__decap_12
XFILLER_0_22_359 VGND VGND VPWR VPWR sky130_fd_sc_hd__decap_4
XFILLER_0_57_201 VGND VGND VPWR VPWR sky130_fd_sc_hd__decap_3
X_2920_ _1485_ VGND VGND VPWR VPWR _0277_ sky130_fd_sc_hd__clkbuf_1
XFILLER_0_15_88 VGND VGND VPWR VPWR sky130_fd_sc_hd__fill_1
X_1802_ imem.address\[5\] imem.address\[4\] imem.address\[3\] imem.address\[2\] VGND
+ VGND VPWR VPWR _0464_ sky130_fd_sc_hd__or4_1
X_2851_ reg_file.registers\[11\]\[12\] _1429_ _1376_ VGND VGND VPWR VPWR _1430_ sky130_fd_sc_hd__mux2_1
X_2782_ _0890_ _0891_ VGND VGND VPWR VPWR _1368_ sky130_fd_sc_hd__nor2_1
XFILLER_0_31_65 VGND VGND VPWR VPWR sky130_fd_sc_hd__fill_2
XFILLER_0_31_43 VGND VGND VPWR VPWR sky130_fd_sc_hd__decap_8
XFILLER_0_31_21 VGND VGND VPWR VPWR sky130_fd_sc_hd__fill_1
X_1733_ reg_file.registers\[2\]\[26\] VGND VGND VPWR VPWR _0421_ sky130_fd_sc_hd__clkbuf_1
XTAP_TAPCELL_ROW_13_262 VGND VPWR sky130_fd_sc_hd__tapvpwrvgnd_1
X_3334_ _1706_ VGND VGND VPWR VPWR _0123_ sky130_fd_sc_hd__inv_2
X_3403_ _1715_ VGND VGND VPWR VPWR _0183_ sky130_fd_sc_hd__inv_2
XFILLER_0_0_253 VPWR VGND VPWR VGND sky130_ef_sc_hd__decap_12
XFILLER_0_13_337 VGND VGND VPWR VPWR sky130_fd_sc_hd__fill_2
X_2147_ reg_file.registers\[11\]\[3\] _0725_ _0726_ reg_file.registers\[10\]\[3\]
+ VGND VGND VPWR VPWR _0745_ sky130_fd_sc_hd__a22o_1
X_3265_ _1696_ VGND VGND VPWR VPWR _0064_ sky130_fd_sc_hd__inv_2
X_2216_ _0798_ _0813_ VGND VGND VPWR VPWR _0814_ sky130_fd_sc_hd__or2b_1
X_3196_ display.counter\[10\] _1674_ VGND VGND VPWR VPWR _0008_ sky130_fd_sc_hd__xor2_1
XFILLER_0_15_3 VPWR VGND VPWR VGND sky130_ef_sc_hd__decap_12
XFILLER_0_63_204 VGND VGND VPWR VPWR sky130_fd_sc_hd__fill_1
X_2078_ _0672_ _0675_ VGND VGND VPWR VPWR _0676_ sky130_fd_sc_hd__or2b_1
XFILLER_0_71_281 VPWR VGND VPWR VGND sky130_ef_sc_hd__decap_12
XFILLER_0_16_153 VGND VGND VPWR VPWR sky130_fd_sc_hd__decap_6
XFILLER_0_16_197 VPWR VGND VPWR VGND sky130_ef_sc_hd__decap_12
XFILLER_0_54_237 VGND VGND VPWR VPWR sky130_fd_sc_hd__decap_8
XFILLER_0_39_278 VGND VGND VPWR VPWR sky130_fd_sc_hd__fill_2
XTAP_TAPCELL_ROW_10_232 VGND VPWR sky130_fd_sc_hd__tapvpwrvgnd_1
XFILLER_0_50_421 VGND VGND VPWR VPWR sky130_fd_sc_hd__fill_1
XFILLER_0_10_329 VGND VGND VPWR VPWR sky130_fd_sc_hd__fill_2
X_3050_ _0458_ net1 _0478_ _0457_ VGND VGND VPWR VPWR _1556_ sky130_fd_sc_hd__a31o_1
X_2001_ _0598_ VGND VGND VPWR VPWR _0599_ sky130_fd_sc_hd__clkbuf_4
XTAP_TAPCELL_ROW_61_644 VGND VPWR sky130_fd_sc_hd__tapvpwrvgnd_1
X_2903_ _0680_ _1016_ _0752_ _1254_ _1471_ VGND VGND VPWR VPWR _1472_ sky130_fd_sc_hd__a41o_1
X_2765_ _1350_ _1352_ _1014_ VGND VGND VPWR VPWR _1353_ sky130_fd_sc_hd__mux2_1
X_2834_ _1032_ _1413_ _1414_ _1064_ VGND VGND VPWR VPWR _1415_ sky130_fd_sc_hd__a2bb2o_1
XFILLER_0_13_167 VGND VGND VPWR VPWR sky130_fd_sc_hd__fill_1
X_2696_ _0936_ _0942_ _0954_ _0958_ VGND VGND VPWR VPWR _1289_ sky130_fd_sc_hd__a211o_1
XTAP_TAPCELL_ROW_69_711 VGND VPWR sky130_fd_sc_hd__tapvpwrvgnd_1
X_3317_ _1703_ VGND VGND VPWR VPWR _0109_ sky130_fd_sc_hd__inv_2
XFILLER_0_6_53 VPWR VGND VPWR VGND sky130_ef_sc_hd__decap_12
XFILLER_0_6_97 VPWR VGND VPWR VGND sky130_ef_sc_hd__decap_12
XFILLER_0_68_307 VGND VGND VPWR VPWR sky130_fd_sc_hd__fill_1
X_3248_ _1695_ VGND VGND VPWR VPWR _0048_ sky130_fd_sc_hd__inv_2
Xrebuffer42 _0468_ VGND VGND VPWR VPWR net59 sky130_fd_sc_hd__dlygate4sd1_1
Xrebuffer31 _0556_ VGND VGND VPWR VPWR net47 sky130_fd_sc_hd__dlygate4sd1_1
Xrebuffer20 net35 VGND VGND VPWR VPWR net36 sky130_fd_sc_hd__dlygate4sd1_1
X_3179_ display.counter\[3\] _1664_ VGND VGND VPWR VPWR _1666_ sky130_fd_sc_hd__and2_1
XTAP_TAPCELL_ROW_24_346 VGND VPWR sky130_fd_sc_hd__tapvpwrvgnd_1
XFILLER_0_32_421 VGND VGND VPWR VPWR sky130_fd_sc_hd__decap_6
XFILLER_0_4_3 VPWR VGND VPWR VGND sky130_ef_sc_hd__decap_12
XFILLER_0_63_19 VGND VGND VPWR VPWR sky130_fd_sc_hd__decap_3
XFILLER_0_35_281 VPWR VGND VPWR VGND sky130_ef_sc_hd__decap_12
X_2550_ _1022_ _1143_ _1146_ VGND VGND VPWR VPWR _1147_ sky130_fd_sc_hd__a21o_1
XFILLER_0_6_109 VPWR VGND VPWR VGND sky130_ef_sc_hd__decap_12
X_2481_ _1076_ _1077_ _1068_ VGND VGND VPWR VPWR _1078_ sky130_fd_sc_hd__mux2_1
X_3033_ _1525_ _1549_ VGND VGND VPWR VPWR _0228_ sky130_fd_sc_hd__nor2_1
XFILLER_0_37_53 VGND VGND VPWR VPWR sky130_fd_sc_hd__decap_3
X_3102_ _1033_ _1575_ _1601_ VGND VGND VPWR VPWR _1602_ sky130_fd_sc_hd__or3b_1
XFILLER_0_58_395 VGND VGND VPWR VPWR sky130_fd_sc_hd__decap_4
XFILLER_0_53_74 VGND VGND VPWR VPWR sky130_fd_sc_hd__fill_1
XTAP_TAPCELL_ROW_21_327 VGND VPWR sky130_fd_sc_hd__tapvpwrvgnd_1
X_2817_ _0708_ _0774_ _0828_ VGND VGND VPWR VPWR _1399_ sky130_fd_sc_hd__or3_2
X_2748_ _0872_ _0925_ _1336_ VGND VGND VPWR VPWR _1337_ sky130_fd_sc_hd__nand3b_1
X_2679_ _1000_ VGND VGND VPWR VPWR _1272_ sky130_fd_sc_hd__inv_2
XFILLER_0_14_421 VGND VGND VPWR VPWR sky130_fd_sc_hd__decap_8
XFILLER_0_49_340 VGND VGND VPWR VPWR sky130_fd_sc_hd__fill_1
XFILLER_0_64_321 VPWR VGND VPWR VGND sky130_ef_sc_hd__decap_12
XFILLER_0_32_251 VGND VGND VPWR VPWR sky130_fd_sc_hd__fill_1
XFILLER_0_24_207 VPWR VGND VPWR VGND sky130_ef_sc_hd__decap_12
XFILLER_0_17_281 VGND VGND VPWR VPWR sky130_fd_sc_hd__decap_4
XFILLER_0_67_181 VGND VGND VPWR VPWR sky130_fd_sc_hd__fill_2
XFILLER_0_55_310 VGND VGND VPWR VPWR sky130_fd_sc_hd__decap_8
XTAP_TAPCELL_ROW_43_496 VGND VPWR sky130_fd_sc_hd__tapvpwrvgnd_1
X_1981_ _0578_ VGND VGND VPWR VPWR _0579_ sky130_fd_sc_hd__buf_2
XFILLER_0_23_77 VGND VGND VPWR VPWR sky130_fd_sc_hd__decap_4
X_3582_ clknet_leaf_7_clk _0344_ _0155_ VGND VGND VPWR VPWR reg_file.registers\[5\]\[2\]
+ sky130_fd_sc_hd__dfrtp_1
X_2602_ _1108_ _1189_ _1195_ _1128_ _1197_ VGND VGND VPWR VPWR _1198_ sky130_fd_sc_hd__o221a_1
XFILLER_0_23_273 VGND VGND VPWR VPWR sky130_fd_sc_hd__decap_6
XFILLER_0_2_189 VGND VGND VPWR VPWR sky130_fd_sc_hd__decap_6
X_3651_ clknet_leaf_17_clk _0022_ VGND VGND VPWR VPWR display.counter\[5\] sky130_fd_sc_hd__dfxtp_1
X_2533_ reg_file.registers\[11\]\[23\] _1114_ _1115_ reg_file.registers\[10\]\[23\]
+ VGND VGND VPWR VPWR _1130_ sky130_fd_sc_hd__a22o_1
XFILLER_0_48_85 VGND VGND VPWR VPWR sky130_fd_sc_hd__fill_1
XFILLER_0_48_41 VPWR VGND VPWR VGND sky130_ef_sc_hd__decap_12
X_2464_ _0970_ _0971_ VGND VGND VPWR VPWR _1061_ sky130_fd_sc_hd__and2_1
X_2395_ reg_file.registers\[11\]\[23\] _0694_ _0992_ VGND VGND VPWR VPWR _0993_ sky130_fd_sc_hd__a21o_1
X_3016_ _1532_ _1542_ VGND VGND VPWR VPWR _0238_ sky130_fd_sc_hd__nor2_1
XTAP_TAPCELL_ROW_34_430 VGND VPWR sky130_fd_sc_hd__tapvpwrvgnd_1
XFILLER_0_61_368 VGND VGND VPWR VPWR sky130_fd_sc_hd__decap_3
XFILLER_0_61_335 VGND VGND VPWR VPWR sky130_fd_sc_hd__fill_1
XFILLER_0_46_365 VGND VGND VPWR VPWR sky130_fd_sc_hd__decap_8
XFILLER_0_46_321 VPWR VGND VPWR VGND sky130_ef_sc_hd__decap_12
XFILLER_0_69_413 VGND VGND VPWR VPWR sky130_fd_sc_hd__fill_2
XFILLER_0_56_118 VGND VGND VPWR VPWR sky130_fd_sc_hd__decap_3
XFILLER_0_64_195 VGND VGND VPWR VPWR sky130_fd_sc_hd__fill_1
XTAP_TAPCELL_ROW_40_477 VGND VPWR sky130_fd_sc_hd__tapvpwrvgnd_1
X_2180_ reg_file.registers\[15\]\[15\] _0599_ _0715_ reg_file.registers\[5\]\[15\]
+ _0645_ VGND VGND VPWR VPWR _0778_ sky130_fd_sc_hd__a221o_1
XFILLER_0_47_129 VGND VGND VPWR VPWR sky130_fd_sc_hd__fill_1
XFILLER_0_34_21 VGND VGND VPWR VPWR sky130_fd_sc_hd__fill_1
XPHY_EDGE_ROW_25_Left_97 VGND VGND VPWR VPWR sky130_fd_sc_hd__decap_3
XFILLER_0_18_99 VGND VGND VPWR VPWR sky130_fd_sc_hd__fill_1
X_1964_ _0561_ VGND VGND VPWR VPWR _0562_ sky130_fd_sc_hd__clkbuf_4
XFILLER_0_55_140 VGND VGND VPWR VPWR sky130_fd_sc_hd__decap_6
XFILLER_0_50_97 VGND VGND VPWR VPWR sky130_fd_sc_hd__fill_2
XFILLER_0_50_64 VGND VGND VPWR VPWR sky130_fd_sc_hd__fill_1
Xclkbuf_leaf_13_clk clknet_1_1__leaf_clk VGND VGND VPWR VPWR clknet_leaf_13_clk sky130_fd_sc_hd__clkbuf_8
XTAP_TAPCELL_ROW_31_400 VGND VPWR sky130_fd_sc_hd__tapvpwrvgnd_1
XFILLER_0_28_365 VGND VGND VPWR VPWR sky130_fd_sc_hd__decap_6
X_3634_ clknet_leaf_21_clk _0396_ _0207_ VGND VGND VPWR VPWR reg_file.registers\[2\]\[23\]
+ sky130_fd_sc_hd__dfrtp_1
XFILLER_0_7_237 VPWR VGND VPWR VGND sky130_ef_sc_hd__decap_12
X_1895_ _0522_ VGND VGND VPWR VPWR _0339_ sky130_fd_sc_hd__clkbuf_1
X_3496_ clknet_leaf_3_clk _0258_ _0069_ VGND VGND VPWR VPWR reg_file.registers\[15\]\[12\]
+ sky130_fd_sc_hd__dfrtp_1
X_2447_ _1044_ VGND VGND VPWR VPWR _1045_ sky130_fd_sc_hd__inv_2
X_2516_ _1111_ _1112_ _1068_ VGND VGND VPWR VPWR _1113_ sky130_fd_sc_hd__mux2_1
X_3565_ clknet_leaf_15_clk _0327_ _0138_ VGND VGND VPWR VPWR reg_file.registers\[10\]\[17\]
+ sky130_fd_sc_hd__dfrtp_1
XFILLER_0_11_298 VPWR VGND VPWR VGND sky130_ef_sc_hd__decap_12
XFILLER_0_45_3 VPWR VGND VPWR VGND sky130_ef_sc_hd__decap_12
X_2378_ _0970_ _0975_ VGND VGND VPWR VPWR _0976_ sky130_fd_sc_hd__nand2_1
XFILLER_0_61_110 VGND VGND VPWR VPWR sky130_fd_sc_hd__fill_2
XFILLER_0_46_162 VPWR VGND VPWR VGND sky130_ef_sc_hd__decap_12
XFILLER_0_34_335 VGND VGND VPWR VPWR sky130_fd_sc_hd__fill_2
XFILLER_0_57_405 VPWR VGND VPWR VGND sky130_ef_sc_hd__decap_12
XTAP_TAPCELL_ROW_45_514 VGND VPWR sky130_fd_sc_hd__tapvpwrvgnd_1
XFILLER_0_57_449 VGND VGND VPWR VPWR sky130_fd_sc_hd__fill_2
XTAP_TAPCELL_ROW_53_580 VGND VPWR sky130_fd_sc_hd__tapvpwrvgnd_1
XFILLER_0_37_195 VGND VGND VPWR VPWR sky130_fd_sc_hd__fill_1
XFILLER_0_25_335 VGND VGND VPWR VPWR sky130_fd_sc_hd__fill_1
XFILLER_0_25_313 VGND VGND VPWR VPWR sky130_fd_sc_hd__decap_4
X_2301_ _0776_ _0780_ _0898_ VGND VGND VPWR VPWR _0899_ sky130_fd_sc_hd__and3_1
X_3350_ _1707_ VGND VGND VPWR VPWR _0138_ sky130_fd_sc_hd__inv_2
X_2163_ _0759_ _0760_ _0614_ VGND VGND VPWR VPWR _0761_ sky130_fd_sc_hd__o21ai_2
X_2232_ _0574_ _0829_ VGND VGND VPWR VPWR _0830_ sky130_fd_sc_hd__nand2_1
X_3281_ _1698_ VGND VGND VPWR VPWR _0078_ sky130_fd_sc_hd__inv_2
Xclkbuf_leaf_2_clk clknet_1_0__leaf_clk VGND VGND VPWR VPWR clknet_leaf_2_clk sky130_fd_sc_hd__clkbuf_8
X_2094_ _0691_ VGND VGND VPWR VPWR _0692_ sky130_fd_sc_hd__buf_4
XTAP_TAPCELL_ROW_16_282 VGND VPWR sky130_fd_sc_hd__tapvpwrvgnd_1
X_2996_ imem.address\[21\] _1529_ VGND VGND VPWR VPWR _1530_ sky130_fd_sc_hd__and2_1
X_1947_ _0549_ VGND VGND VPWR VPWR _0314_ sky130_fd_sc_hd__clkbuf_1
X_3617_ clknet_leaf_5_clk _0379_ _0190_ VGND VGND VPWR VPWR reg_file.registers\[2\]\[6\]
+ sky130_fd_sc_hd__dfrtp_1
X_1878_ reg_file.registers\[5\]\[4\] _0504_ VGND VGND VPWR VPWR _0513_ sky130_fd_sc_hd__and2_1
XFILLER_0_28_195 VGND VGND VPWR VPWR sky130_fd_sc_hd__fill_1
XFILLER_0_28_184 VGND VGND VPWR VPWR sky130_fd_sc_hd__decap_8
X_3548_ clknet_leaf_10_clk _0310_ _0121_ VGND VGND VPWR VPWR reg_file.registers\[10\]\[0\]
+ sky130_fd_sc_hd__dfrtp_4
XTAP_TAPCELL_ROW_59_628 VGND VPWR sky130_fd_sc_hd__tapvpwrvgnd_1
XFILLER_0_3_273 VGND VGND VPWR VPWR sky130_fd_sc_hd__decap_6
XTAP_TAPCELL_ROW_8_217 VGND VPWR sky130_fd_sc_hd__tapvpwrvgnd_1
X_3479_ clknet_leaf_16_clk _0002_ VGND VGND VPWR VPWR net12 sky130_fd_sc_hd__dfxtp_1
XTAP_TAPCELL_ROW_67_694 VGND VPWR sky130_fd_sc_hd__tapvpwrvgnd_1
XFILLER_0_66_202 VGND VGND VPWR VPWR sky130_fd_sc_hd__fill_2
XFILLER_0_39_427 VGND VGND VPWR VPWR sky130_fd_sc_hd__fill_2
XFILLER_0_66_257 VGND VGND VPWR VPWR sky130_fd_sc_hd__fill_1
XFILLER_0_54_419 VGND VGND VPWR VPWR sky130_fd_sc_hd__fill_1
XFILLER_0_39_449 VGND VGND VPWR VPWR sky130_fd_sc_hd__fill_2
XFILLER_0_34_132 VGND VGND VPWR VPWR sky130_fd_sc_hd__fill_2
XFILLER_0_22_327 VPWR VGND VPWR VGND sky130_ef_sc_hd__decap_12
X_2850_ _1340_ _1221_ _1428_ VGND VGND VPWR VPWR _1429_ sky130_fd_sc_hd__o21ai_2
XFILLER_0_15_78 VGND VGND VPWR VPWR sky130_fd_sc_hd__fill_1
X_1801_ _0448_ _0462_ _0451_ VGND VGND VPWR VPWR _0463_ sky130_fd_sc_hd__nor3_4
XFILLER_0_53_441 VGND VGND VPWR VPWR sky130_fd_sc_hd__decap_6
X_2781_ _1367_ VGND VGND VPWR VPWR _0298_ sky130_fd_sc_hd__clkbuf_1
XFILLER_0_31_33 VGND VGND VPWR VPWR sky130_fd_sc_hd__fill_2
XFILLER_0_25_154 VGND VGND VPWR VPWR sky130_fd_sc_hd__fill_2
XTAP_TAPCELL_ROW_13_263 VGND VPWR sky130_fd_sc_hd__tapvpwrvgnd_1
X_1732_ _0420_ VGND VGND VPWR VPWR _0400_ sky130_fd_sc_hd__clkbuf_1
X_3333_ _1706_ VGND VGND VPWR VPWR _0122_ sky130_fd_sc_hd__inv_2
X_3264_ _1696_ VGND VGND VPWR VPWR _0063_ sky130_fd_sc_hd__inv_2
X_3402_ _1714_ VGND VGND VPWR VPWR _1715_ sky130_fd_sc_hd__buf_1
XFILLER_0_0_221 VGND VGND VPWR VPWR sky130_fd_sc_hd__decap_3
XFILLER_0_0_265 VPWR VGND VPWR VGND sky130_ef_sc_hd__decap_12
XPHY_EDGE_ROW_7_Right_7 VGND VGND VPWR VPWR sky130_fd_sc_hd__decap_3
XFILLER_0_21_393 VGND VGND VPWR VPWR sky130_fd_sc_hd__decap_6
X_2146_ _0741_ _0743_ net35 VGND VGND VPWR VPWR _0744_ sky130_fd_sc_hd__o21ai_1
X_2215_ _0811_ _0634_ _0628_ _0812_ VGND VGND VPWR VPWR _0813_ sky130_fd_sc_hd__a31o_1
X_2077_ _0574_ _0674_ _0579_ VGND VGND VPWR VPWR _0675_ sky130_fd_sc_hd__a21oi_2
X_3195_ _1674_ _1675_ VGND VGND VPWR VPWR _0026_ sky130_fd_sc_hd__nor2_1
XTAP_TAPCELL_ROW_64_664 VGND VPWR sky130_fd_sc_hd__tapvpwrvgnd_1
XFILLER_0_63_238 VGND VGND VPWR VPWR sky130_fd_sc_hd__fill_2
X_2979_ reg_file.registers\[15\]\[2\] _1514_ VGND VGND VPWR VPWR _1516_ sky130_fd_sc_hd__or2_1
XFILLER_0_48_279 VGND VGND VPWR VPWR sky130_fd_sc_hd__fill_2
XFILLER_0_48_224 VGND VGND VPWR VPWR sky130_fd_sc_hd__decap_4
XFILLER_0_36_419 VGND VGND VPWR VPWR sky130_fd_sc_hd__fill_1
XFILLER_0_16_132 VGND VGND VPWR VPWR sky130_fd_sc_hd__decap_8
XFILLER_0_71_293 VPWR VGND VPWR VGND sky130_ef_sc_hd__decap_12
XFILLER_0_31_113 VPWR VGND VPWR VGND sky130_ef_sc_hd__decap_12
XPHY_EDGE_ROW_12_Left_84 VGND VGND VPWR VPWR sky130_fd_sc_hd__decap_3
XFILLER_0_62_271 VGND VGND VPWR VPWR sky130_fd_sc_hd__fill_1
XFILLER_0_54_216 VGND VGND VPWR VPWR sky130_fd_sc_hd__decap_8
XTAP_TAPCELL_ROW_10_233 VGND VPWR sky130_fd_sc_hd__tapvpwrvgnd_1
X_2000_ _0455_ net26 _0469_ _0474_ VGND VGND VPWR VPWR _0598_ sky130_fd_sc_hd__and4b_1
XTAP_TAPCELL_ROW_18_300 VGND VPWR sky130_fd_sc_hd__tapvpwrvgnd_1
XTAP_TAPCELL_ROW_61_645 VGND VPWR sky130_fd_sc_hd__tapvpwrvgnd_1
X_2902_ _0722_ _0739_ _1470_ VGND VGND VPWR VPWR _1471_ sky130_fd_sc_hd__a21oi_1
X_2833_ _0796_ _1403_ VGND VGND VPWR VPWR _1414_ sky130_fd_sc_hd__xnor2_1
XFILLER_0_38_290 VGND VGND VPWR VPWR sky130_fd_sc_hd__fill_1
X_2764_ _1004_ _1047_ _1351_ VGND VGND VPWR VPWR _1352_ sky130_fd_sc_hd__a21o_1
X_2695_ _0990_ _1287_ VGND VGND VPWR VPWR _1288_ sky130_fd_sc_hd__nand2_1
XFILLER_0_5_335 VGND VGND VPWR VPWR sky130_fd_sc_hd__fill_1
X_3247_ _1695_ VGND VGND VPWR VPWR _0047_ sky130_fd_sc_hd__inv_2
X_3316_ _1703_ VGND VGND VPWR VPWR _0108_ sky130_fd_sc_hd__inv_2
XFILLER_0_6_65 VPWR VGND VPWR VGND sky130_ef_sc_hd__decap_12
Xrebuffer10 _0451_ VGND VGND VPWR VPWR net58 sky130_fd_sc_hd__dlygate4sd1_1
Xrebuffer43 _0466_ VGND VGND VPWR VPWR net60 sky130_fd_sc_hd__dlygate4sd1_1
X_2129_ reg_file.registers\[11\]\[1\] _0725_ _0726_ reg_file.registers\[10\]\[1\]
+ VGND VGND VPWR VPWR _0727_ sky130_fd_sc_hd__a22o_1
Xrebuffer32 net47 VGND VGND VPWR VPWR net48 sky130_fd_sc_hd__dlygate4sd1_1
Xrebuffer21 net36 VGND VGND VPWR VPWR net37 sky130_fd_sc_hd__dlygate4sd1_1
X_3178_ _1664_ _1665_ VGND VGND VPWR VPWR _0019_ sky130_fd_sc_hd__nor2_1
XTAP_TAPCELL_ROW_24_347 VGND VPWR sky130_fd_sc_hd__tapvpwrvgnd_1
XFILLER_0_8_195 VGND VGND VPWR VPWR sky130_fd_sc_hd__fill_1
X_2480_ reg_file.registers\[11\]\[1\] _1071_ _1073_ reg_file.registers\[10\]\[1\]
+ VGND VGND VPWR VPWR _1077_ sky130_fd_sc_hd__a22o_1
XFILLER_0_35_293 VGND VGND VPWR VPWR sky130_fd_sc_hd__decap_6
XFILLER_0_37_65 VGND VGND VPWR VPWR sky130_fd_sc_hd__decap_6
XFILLER_0_37_21 VGND VGND VPWR VPWR sky130_fd_sc_hd__fill_2
X_3101_ _1022_ _1598_ _1599_ _1600_ _1145_ VGND VGND VPWR VPWR _1601_ sky130_fd_sc_hd__a311o_1
X_3032_ imem.address\[13\] _1524_ imem.address\[14\] VGND VGND VPWR VPWR _1549_ sky130_fd_sc_hd__a21oi_1
XFILLER_0_58_363 VGND VGND VPWR VPWR sky130_fd_sc_hd__fill_1
X_2816_ _1398_ VGND VGND VPWR VPWR _0294_ sky130_fd_sc_hd__clkbuf_1
XFILLER_0_33_219 VGND VGND VPWR VPWR sky130_fd_sc_hd__decap_4
XFILLER_0_26_282 VGND VGND VPWR VPWR sky130_fd_sc_hd__decap_8
XFILLER_0_14_400 VGND VGND VPWR VPWR sky130_fd_sc_hd__decap_8
XFILLER_0_18_238 VGND VGND VPWR VPWR sky130_fd_sc_hd__decap_8
XFILLER_0_26_293 VGND VGND VPWR VPWR sky130_fd_sc_hd__decap_6
X_2747_ _0921_ _1325_ VGND VGND VPWR VPWR _1336_ sky130_fd_sc_hd__nand2_1
X_2678_ _1269_ _1270_ _1004_ VGND VGND VPWR VPWR _1271_ sky130_fd_sc_hd__mux2_1
XFILLER_0_1_393 VPWR VGND VPWR VGND sky130_ef_sc_hd__decap_12
XFILLER_0_64_333 VGND VGND VPWR VPWR sky130_fd_sc_hd__fill_2
XFILLER_0_64_300 VGND VGND VPWR VPWR sky130_fd_sc_hd__decap_8
XTAP_TAPCELL_ROW_37_450 VGND VPWR sky130_fd_sc_hd__tapvpwrvgnd_1
XFILLER_0_24_219 VPWR VGND VPWR VGND sky130_ef_sc_hd__decap_12
XFILLER_0_20_403 VGND VGND VPWR VPWR sky130_fd_sc_hd__decap_4
X_1980_ net22 VGND VGND VPWR VPWR _0578_ sky130_fd_sc_hd__buf_2
XTAP_TAPCELL_ROW_43_497 VGND VPWR sky130_fd_sc_hd__tapvpwrvgnd_1
X_3650_ clknet_leaf_17_clk _0021_ VGND VGND VPWR VPWR display.counter\[4\] sky130_fd_sc_hd__dfxtp_1
Xrebuffer1 _0554_ VGND VGND VPWR VPWR net17 sky130_fd_sc_hd__dlygate4sd1_1
X_3581_ clknet_leaf_5_clk _0343_ _0154_ VGND VGND VPWR VPWR reg_file.registers\[5\]\[1\]
+ sky130_fd_sc_hd__dfrtp_2
X_2601_ _1019_ _1021_ _1196_ _1145_ VGND VGND VPWR VPWR _1197_ sky130_fd_sc_hd__a211o_1
X_2463_ _1060_ VGND VGND VPWR VPWR _0309_ sky130_fd_sc_hd__clkbuf_1
X_2532_ reg_file.registers\[11\]\[24\] _1114_ _1115_ reg_file.registers\[10\]\[24\]
+ VGND VGND VPWR VPWR _1129_ sky130_fd_sc_hd__a22o_1
X_3015_ imem.address\[24\] _1531_ VGND VGND VPWR VPWR _1542_ sky130_fd_sc_hd__nor2_1
XFILLER_0_48_53 VGND VGND VPWR VPWR sky130_fd_sc_hd__decap_8
XFILLER_0_47_7 VGND VGND VPWR VPWR sky130_fd_sc_hd__fill_1
XFILLER_0_3_55 VGND VGND VPWR VPWR sky130_fd_sc_hd__fill_1
X_2394_ reg_file.registers\[10\]\[23\] _0785_ _0786_ VGND VGND VPWR VPWR _0992_ sky130_fd_sc_hd__and3_1
XFILLER_0_64_85 VGND VGND VPWR VPWR sky130_fd_sc_hd__fill_1
XFILLER_0_46_333 VGND VGND VPWR VPWR sky130_fd_sc_hd__decap_8
XTAP_TAPCELL_ROW_34_431 VGND VPWR sky130_fd_sc_hd__tapvpwrvgnd_1
XFILLER_0_14_285 VGND VGND VPWR VPWR sky130_fd_sc_hd__decap_4
XFILLER_0_69_447 VGND VGND VPWR VPWR sky130_fd_sc_hd__fill_1
XFILLER_0_64_141 VGND VGND VPWR VPWR sky130_fd_sc_hd__decap_4
XFILLER_0_52_314 VPWR VGND VPWR VGND sky130_ef_sc_hd__decap_12
XTAP_TAPCELL_ROW_40_478 VGND VPWR sky130_fd_sc_hd__tapvpwrvgnd_1
XPHY_EDGE_ROW_0_Left_72 VGND VGND VPWR VPWR sky130_fd_sc_hd__decap_3
XTAP_TAPCELL_ROW_31_401 VGND VPWR sky130_fd_sc_hd__tapvpwrvgnd_1
XFILLER_0_7_205 VPWR VGND VPWR VGND sky130_ef_sc_hd__decap_12
X_1963_ net26 _0469_ _0560_ VGND VGND VPWR VPWR _0561_ sky130_fd_sc_hd__and3_1
XFILLER_0_43_325 VGND VGND VPWR VPWR sky130_fd_sc_hd__decap_6
X_3633_ clknet_leaf_21_clk _0395_ _0206_ VGND VGND VPWR VPWR reg_file.registers\[2\]\[22\]
+ sky130_fd_sc_hd__dfrtp_1
XFILLER_0_7_249 VPWR VGND VPWR VGND sky130_ef_sc_hd__decap_12
X_1894_ reg_file.registers\[10\]\[29\] _0519_ VGND VGND VPWR VPWR _0522_ sky130_fd_sc_hd__and2_1
X_3495_ clknet_leaf_4_clk _0257_ _0068_ VGND VGND VPWR VPWR reg_file.registers\[15\]\[11\]
+ sky130_fd_sc_hd__dfrtp_1
X_2446_ _1039_ _1043_ _1014_ VGND VGND VPWR VPWR _1044_ sky130_fd_sc_hd__mux2_1
X_2515_ reg_file.registers\[11\]\[15\] _1071_ _1072_ reg_file.registers\[10\]\[15\]
+ VGND VGND VPWR VPWR _1112_ sky130_fd_sc_hd__a22o_1
X_3564_ clknet_leaf_13_clk _0326_ _0137_ VGND VGND VPWR VPWR reg_file.registers\[10\]\[16\]
+ sky130_fd_sc_hd__dfrtp_1
XFILLER_0_38_3 VGND VGND VPWR VPWR sky130_fd_sc_hd__decap_4
X_2377_ reg_file.registers\[11\]\[30\] _0694_ _0974_ VGND VGND VPWR VPWR _0975_ sky130_fd_sc_hd__a21o_1
XFILLER_0_66_417 VGND VGND VPWR VPWR sky130_fd_sc_hd__decap_3
XFILLER_0_46_174 VPWR VGND VPWR VGND sky130_ef_sc_hd__decap_12
XFILLER_0_69_244 VPWR VGND VPWR VGND sky130_ef_sc_hd__decap_12
XFILLER_0_57_417 VPWR VGND VPWR VGND sky130_ef_sc_hd__decap_12
XTAP_TAPCELL_ROW_45_515 VGND VPWR sky130_fd_sc_hd__tapvpwrvgnd_1
XTAP_TAPCELL_ROW_2_170 VGND VPWR sky130_fd_sc_hd__tapvpwrvgnd_1
XTAP_TAPCELL_ROW_53_581 VGND VPWR sky130_fd_sc_hd__tapvpwrvgnd_1
XFILLER_0_40_306 VGND VGND VPWR VPWR sky130_fd_sc_hd__fill_2
XFILLER_0_37_152 VGND VGND VPWR VPWR sky130_fd_sc_hd__fill_2
XFILLER_0_37_141 VGND VGND VPWR VPWR sky130_fd_sc_hd__decap_6
XFILLER_0_20_68 VGND VGND VPWR VPWR sky130_fd_sc_hd__decap_4
X_2231_ reg_file.registers\[15\]\[9\] _0599_ _0715_ reg_file.registers\[5\]\[9\] _0629_
+ VGND VGND VPWR VPWR _0829_ sky130_fd_sc_hd__a221o_1
X_2300_ _0575_ _0897_ _0579_ VGND VGND VPWR VPWR _0898_ sky130_fd_sc_hd__a21oi_1
X_3280_ _1698_ VGND VGND VPWR VPWR _0077_ sky130_fd_sc_hd__inv_2
X_2093_ _0690_ VGND VGND VPWR VPWR _0691_ sky130_fd_sc_hd__buf_2
X_2162_ _0578_ _0613_ VGND VGND VPWR VPWR _0760_ sky130_fd_sc_hd__nor2_1
XFILLER_0_45_21 VGND VGND VPWR VPWR sky130_fd_sc_hd__decap_4
X_2995_ imem.address\[20\] imem.address\[19\] _1528_ VGND VGND VPWR VPWR _1529_ sky130_fd_sc_hd__and3_1
XFILLER_0_61_75 VPWR VGND VPWR VGND sky130_ef_sc_hd__decap_12
XFILLER_0_28_152 VGND VGND VPWR VPWR sky130_fd_sc_hd__decap_3
XTAP_TAPCELL_ROW_16_283 VGND VPWR sky130_fd_sc_hd__tapvpwrvgnd_1
X_1946_ reg_file.registers\[10\]\[4\] _0539_ VGND VGND VPWR VPWR _0549_ sky130_fd_sc_hd__and2_1
X_1877_ _0512_ VGND VGND VPWR VPWR _0347_ sky130_fd_sc_hd__clkbuf_1
X_3616_ clknet_leaf_5_clk _0378_ _0189_ VGND VGND VPWR VPWR reg_file.registers\[2\]\[5\]
+ sky130_fd_sc_hd__dfrtp_1
XTAP_TAPCELL_ROW_8_218 VGND VPWR sky130_fd_sc_hd__tapvpwrvgnd_1
X_3547_ clknet_leaf_19_clk _0309_ _0120_ VGND VGND VPWR VPWR reg_file.registers\[11\]\[31\]
+ sky130_fd_sc_hd__dfrtp_1
XTAP_TAPCELL_ROW_59_629 VGND VPWR sky130_fd_sc_hd__tapvpwrvgnd_1
X_3478_ clknet_leaf_15_clk _0001_ VGND VGND VPWR VPWR net11 sky130_fd_sc_hd__dfxtp_1
X_2429_ _0951_ _0947_ _0996_ VGND VGND VPWR VPWR _1027_ sky130_fd_sc_hd__mux2_1
XTAP_TAPCELL_ROW_67_695 VGND VPWR sky130_fd_sc_hd__tapvpwrvgnd_1
XFILLER_0_30_350 VGND VGND VPWR VPWR sky130_fd_sc_hd__fill_1
XFILLER_0_22_339 VGND VGND VPWR VPWR sky130_fd_sc_hd__decap_6
X_1800_ _0447_ _0452_ _0453_ _0456_ VGND VGND VPWR VPWR _0462_ sky130_fd_sc_hd__or4_4
XFILLER_0_57_236 VGND VGND VPWR VPWR sky130_fd_sc_hd__decap_4
XFILLER_0_57_225 VGND VGND VPWR VPWR sky130_fd_sc_hd__decap_4
XFILLER_0_15_35 VGND VGND VPWR VPWR sky130_fd_sc_hd__fill_1
X_3401_ reset VGND VGND VPWR VPWR _1714_ sky130_fd_sc_hd__clkbuf_2
X_2780_ reg_file.registers\[11\]\[20\] _1366_ _1059_ VGND VGND VPWR VPWR _1367_ sky130_fd_sc_hd__mux2_1
XFILLER_0_25_199 VGND VGND VPWR VPWR sky130_fd_sc_hd__decap_6
XFILLER_0_25_166 VGND VGND VPWR VPWR sky130_fd_sc_hd__fill_2
X_1731_ reg_file.registers\[2\]\[27\] VGND VGND VPWR VPWR _0420_ sky130_fd_sc_hd__clkbuf_1
X_3332_ _1706_ VGND VGND VPWR VPWR _0121_ sky130_fd_sc_hd__inv_2
X_3263_ _1696_ VGND VGND VPWR VPWR _0062_ sky130_fd_sc_hd__inv_2
X_2214_ _0579_ _0625_ VGND VGND VPWR VPWR _0812_ sky130_fd_sc_hd__nor2_1
XFILLER_0_0_277 VGND VGND VPWR VPWR sky130_fd_sc_hd__decap_3
X_3194_ display.counter\[9\] _1672_ VGND VGND VPWR VPWR _1675_ sky130_fd_sc_hd__nor2_1
XTAP_TAPCELL_ROW_64_665 VGND VPWR sky130_fd_sc_hd__tapvpwrvgnd_1
XFILLER_0_56_75 VGND VGND VPWR VPWR sky130_fd_sc_hd__decap_8
X_2145_ _0742_ _0718_ VGND VGND VPWR VPWR _0743_ sky130_fd_sc_hd__and2_1
X_2076_ reg_file.registers\[5\]\[22\] _0564_ _0568_ reg_file.registers\[15\]\[22\]
+ _0673_ VGND VGND VPWR VPWR _0674_ sky130_fd_sc_hd__a221o_1
X_2978_ _1515_ VGND VGND VPWR VPWR _0249_ sky130_fd_sc_hd__clkbuf_1
X_1929_ _0540_ VGND VGND VPWR VPWR _0323_ sky130_fd_sc_hd__clkbuf_1
XFILLER_0_31_125 VGND VGND VPWR VPWR sky130_fd_sc_hd__fill_2
XFILLER_0_12_361 VGND VGND VPWR VPWR sky130_fd_sc_hd__decap_3
XFILLER_0_39_225 VGND VGND VPWR VPWR sky130_fd_sc_hd__decap_4
XFILLER_0_62_294 VGND VGND VPWR VPWR sky130_fd_sc_hd__decap_4
XFILLER_0_35_420 VGND VGND VPWR VPWR sky130_fd_sc_hd__fill_1
XTAP_TAPCELL_ROW_10_234 VGND VPWR sky130_fd_sc_hd__tapvpwrvgnd_1
XFILLER_0_10_309 VGND VGND VPWR VPWR sky130_fd_sc_hd__fill_2
XTAP_TAPCELL_ROW_18_301 VGND VPWR sky130_fd_sc_hd__tapvpwrvgnd_1
X_2901_ _0722_ _0739_ _1065_ VGND VGND VPWR VPWR _1470_ sky130_fd_sc_hd__o21ai_1
XTAP_TAPCELL_ROW_61_646 VGND VPWR sky130_fd_sc_hd__tapvpwrvgnd_1
X_2832_ _1410_ _1412_ _0990_ VGND VGND VPWR VPWR _1413_ sky130_fd_sc_hd__mux2_1
X_2763_ _1003_ _1042_ VGND VGND VPWR VPWR _1351_ sky130_fd_sc_hd__nor2_1
XFILLER_0_45_206 VPWR VGND VPWR VGND sky130_ef_sc_hd__decap_12
XFILLER_0_42_44 VGND VGND VPWR VPWR sky130_fd_sc_hd__decap_3
X_2694_ _1282_ _1286_ _1013_ VGND VGND VPWR VPWR _1287_ sky130_fd_sc_hd__mux2_1
XFILLER_0_13_147 VPWR VGND VPWR VGND sky130_ef_sc_hd__decap_12
XFILLER_0_13_169 VPWR VGND VPWR VGND sky130_ef_sc_hd__decap_12
XFILLER_0_67_74 VGND VGND VPWR VPWR sky130_fd_sc_hd__decap_3
Xrebuffer11 _0451_ VGND VGND VPWR VPWR net27 sky130_fd_sc_hd__buf_6
X_3246_ _1692_ VGND VGND VPWR VPWR _1695_ sky130_fd_sc_hd__buf_4
X_3315_ _1703_ VGND VGND VPWR VPWR _0107_ sky130_fd_sc_hd__inv_2
XFILLER_0_6_77 VGND VGND VPWR VPWR sky130_fd_sc_hd__decap_6
X_3177_ display.counter\[1\] display.counter\[0\] display.counter\[2\] VGND VGND VPWR
+ VPWR _1665_ sky130_fd_sc_hd__a21oi_1
XFILLER_0_20_3 VPWR VGND VPWR VGND sky130_ef_sc_hd__decap_12
XFILLER_0_68_309 VGND VGND VPWR VPWR sky130_fd_sc_hd__fill_1
X_2128_ _0695_ _0725_ VGND VGND VPWR VPWR _0726_ sky130_fd_sc_hd__nor2_1
Xrebuffer22 _0463_ VGND VGND VPWR VPWR net38 sky130_fd_sc_hd__dlygate4sd1_1
Xrebuffer33 net48 VGND VGND VPWR VPWR net49 sky130_fd_sc_hd__dlygate4sd1_1
X_2059_ reg_file.registers\[2\]\[18\] _0558_ VGND VGND VPWR VPWR _0657_ sky130_fd_sc_hd__and2_1
XTAP_TAPCELL_ROW_24_348 VGND VPWR sky130_fd_sc_hd__tapvpwrvgnd_1
XFILLER_0_51_209 VPWR VGND VPWR VGND sky130_ef_sc_hd__decap_12
XFILLER_0_8_141 VPWR VGND VPWR VGND sky130_ef_sc_hd__decap_12
XFILLER_0_35_261 VGND VGND VPWR VPWR sky130_fd_sc_hd__decap_3
XFILLER_0_23_401 VGND VGND VPWR VPWR sky130_fd_sc_hd__decap_3
XFILLER_0_10_139 VGND VGND VPWR VPWR sky130_fd_sc_hd__fill_1
X_3031_ _1526_ _1548_ VGND VGND VPWR VPWR _0229_ sky130_fd_sc_hd__nor2_1
X_3100_ _1153_ _0971_ _1019_ VGND VGND VPWR VPWR _1600_ sky130_fd_sc_hd__o21a_1
XFILLER_0_53_43 VGND VGND VPWR VPWR sky130_fd_sc_hd__fill_1
X_2815_ reg_file.registers\[11\]\[16\] _1397_ _1376_ VGND VGND VPWR VPWR _1398_ sky130_fd_sc_hd__mux2_1
XFILLER_0_5_111 VGND VGND VPWR VPWR sky130_fd_sc_hd__fill_1
X_2746_ _1335_ VGND VGND VPWR VPWR _0301_ sky130_fd_sc_hd__clkbuf_1
XFILLER_0_14_445 VGND VGND VPWR VPWR sky130_fd_sc_hd__decap_6
XFILLER_0_68_3 VPWR VGND VPWR VGND sky130_ef_sc_hd__decap_12
XFILLER_0_1_361 VPWR VGND VPWR VGND sky130_ef_sc_hd__decap_12
X_2677_ _0993_ _0934_ _0996_ VGND VGND VPWR VPWR _1270_ sky130_fd_sc_hd__mux2_1
X_3229_ _1693_ VGND VGND VPWR VPWR _0031_ sky130_fd_sc_hd__inv_2
XTAP_TAPCELL_ROW_37_451 VGND VPWR sky130_fd_sc_hd__tapvpwrvgnd_1
XFILLER_0_32_297 VGND VGND VPWR VPWR sky130_fd_sc_hd__decap_8
XFILLER_0_32_253 VPWR VGND VPWR VGND sky130_ef_sc_hd__decap_12
XTAP_TAPCELL_ROW_71_730 VGND VPWR sky130_fd_sc_hd__tapvpwrvgnd_1
XFILLER_0_23_35 VGND VGND VPWR VPWR sky130_fd_sc_hd__fill_1
Xrebuffer2 net17 VGND VGND VPWR VPWR net18 sky130_fd_sc_hd__dlymetal6s4s_1
X_3580_ clknet_leaf_5_clk _0342_ _0153_ VGND VGND VPWR VPWR reg_file.registers\[5\]\[0\]
+ sky130_fd_sc_hd__dfrtp_1
XTAP_TAPCELL_ROW_43_498 VGND VPWR sky130_fd_sc_hd__tapvpwrvgnd_1
X_2600_ _1019_ _1027_ VGND VGND VPWR VPWR _1196_ sky130_fd_sc_hd__nor2_1
X_2531_ _1107_ _1014_ VGND VGND VPWR VPWR _1128_ sky130_fd_sc_hd__nand2_2
X_2393_ _0990_ VGND VGND VPWR VPWR _0991_ sky130_fd_sc_hd__clkbuf_4
XFILLER_0_23_253 VGND VGND VPWR VPWR sky130_fd_sc_hd__fill_1
X_2462_ reg_file.registers\[11\]\[31\] _1057_ _1059_ VGND VGND VPWR VPWR _1060_ sky130_fd_sc_hd__mux2_1
X_3014_ imem.address\[25\] _1532_ VGND VGND VPWR VPWR _0239_ sky130_fd_sc_hd__xor2_1
XFILLER_0_58_194 VGND VGND VPWR VPWR sky130_fd_sc_hd__fill_2
XFILLER_0_14_253 VGND VGND VPWR VPWR sky130_fd_sc_hd__decap_4
X_2729_ _1319_ VGND VGND VPWR VPWR _0302_ sky130_fd_sc_hd__clkbuf_1
XPHY_EDGE_ROW_29_Right_29 VGND VGND VPWR VPWR sky130_fd_sc_hd__decap_3
XFILLER_0_52_326 VGND VGND VPWR VPWR sky130_fd_sc_hd__fill_1
XTAP_TAPCELL_ROW_40_479 VGND VPWR sky130_fd_sc_hd__tapvpwrvgnd_1
XPHY_EDGE_ROW_38_Right_38 VGND VGND VPWR VPWR sky130_fd_sc_hd__decap_3
XFILLER_0_37_367 VPWR VGND VPWR VGND sky130_ef_sc_hd__decap_12
XFILLER_0_20_234 VPWR VGND VPWR VGND sky130_ef_sc_hd__decap_12
XPHY_EDGE_ROW_47_Right_47 VGND VGND VPWR VPWR sky130_fd_sc_hd__decap_3
X_1962_ imem.address\[5\] _0457_ _0458_ _0455_ VGND VGND VPWR VPWR _0560_ sky130_fd_sc_hd__and4bb_2
XPHY_EDGE_ROW_56_Right_56 VGND VGND VPWR VPWR sky130_fd_sc_hd__decap_3
XTAP_TAPCELL_ROW_31_402 VGND VPWR sky130_fd_sc_hd__tapvpwrvgnd_1
XFILLER_0_7_217 VGND VGND VPWR VPWR sky130_fd_sc_hd__decap_6
XFILLER_0_70_134 VGND VGND VPWR VPWR sky130_fd_sc_hd__decap_6
XFILLER_0_43_359 VGND VGND VPWR VPWR sky130_fd_sc_hd__decap_8
XFILLER_0_43_337 VGND VGND VPWR VPWR sky130_fd_sc_hd__fill_2
X_3563_ clknet_leaf_13_clk _0325_ _0136_ VGND VGND VPWR VPWR reg_file.registers\[10\]\[15\]
+ sky130_fd_sc_hd__dfrtp_1
X_3632_ clknet_leaf_21_clk _0394_ _0205_ VGND VGND VPWR VPWR reg_file.registers\[2\]\[21\]
+ sky130_fd_sc_hd__dfrtp_1
XFILLER_0_11_223 VGND VGND VPWR VPWR sky130_fd_sc_hd__fill_1
X_1893_ _0521_ VGND VGND VPWR VPWR _0340_ sky130_fd_sc_hd__clkbuf_1
XPHY_EDGE_ROW_65_Right_65 VGND VGND VPWR VPWR sky130_fd_sc_hd__decap_3
XFILLER_0_59_53 VGND VGND VPWR VPWR sky130_fd_sc_hd__decap_3
X_2445_ _1041_ _1042_ _1002_ VGND VGND VPWR VPWR _1043_ sky130_fd_sc_hd__mux2_1
X_3494_ clknet_leaf_4_clk _0256_ _0067_ VGND VGND VPWR VPWR reg_file.registers\[15\]\[10\]
+ sky130_fd_sc_hd__dfrtp_1
X_2514_ reg_file.registers\[11\]\[16\] _1071_ _1072_ reg_file.registers\[10\]\[16\]
+ VGND VGND VPWR VPWR _1111_ sky130_fd_sc_hd__a22o_1
X_2376_ reg_file.registers\[10\]\[30\] _0785_ _0786_ VGND VGND VPWR VPWR _0974_ sky130_fd_sc_hd__and3_1
XFILLER_0_46_197 VPWR VGND VPWR VGND sky130_ef_sc_hd__decap_12
XFILLER_0_46_186 VGND VGND VPWR VPWR sky130_fd_sc_hd__decap_8
XFILLER_0_19_378 VGND VGND VPWR VPWR sky130_fd_sc_hd__fill_2
XFILLER_0_42_392 VGND VGND VPWR VPWR sky130_fd_sc_hd__decap_4
XFILLER_0_69_256 VPWR VGND VPWR VGND sky130_ef_sc_hd__decap_12
XFILLER_0_57_429 VPWR VGND VPWR VGND sky130_ef_sc_hd__decap_12
XTAP_TAPCELL_ROW_53_582 VGND VPWR sky130_fd_sc_hd__tapvpwrvgnd_1
XTAP_TAPCELL_ROW_45_516 VGND VPWR sky130_fd_sc_hd__tapvpwrvgnd_1
XTAP_TAPCELL_ROW_2_171 VGND VPWR sky130_fd_sc_hd__tapvpwrvgnd_1
XFILLER_0_52_112 VGND VGND VPWR VPWR sky130_fd_sc_hd__decap_8
XFILLER_0_25_337 VPWR VGND VPWR VGND sky130_ef_sc_hd__decap_12
XFILLER_0_4_209 VPWR VGND VPWR VGND sky130_ef_sc_hd__decap_12
X_2230_ _0826_ _0827_ VGND VGND VPWR VPWR _0828_ sky130_fd_sc_hd__nand2_1
X_2092_ net24 _0562_ VGND VGND VPWR VPWR _0690_ sky130_fd_sc_hd__or2_1
X_2161_ _0606_ _0610_ VGND VGND VPWR VPWR _0759_ sky130_fd_sc_hd__nor2_1
XFILLER_0_71_421 VPWR VGND VPWR VGND sky130_ef_sc_hd__decap_12
X_1945_ _0548_ VGND VGND VPWR VPWR _0315_ sky130_fd_sc_hd__clkbuf_1
X_2994_ imem.address\[18\] _1527_ VGND VGND VPWR VPWR _1528_ sky130_fd_sc_hd__and2_1
XFILLER_0_61_87 VPWR VGND VPWR VGND sky130_ef_sc_hd__decap_12
XFILLER_0_48_429 VGND VGND VPWR VPWR sky130_fd_sc_hd__decap_3
XFILLER_0_0_57 VPWR VGND VPWR VGND sky130_ef_sc_hd__decap_12
XTAP_TAPCELL_ROW_16_284 VGND VPWR sky130_fd_sc_hd__tapvpwrvgnd_1
X_3615_ clknet_leaf_5_clk _0377_ _0188_ VGND VGND VPWR VPWR reg_file.registers\[2\]\[4\]
+ sky130_fd_sc_hd__dfrtp_1
X_1876_ reg_file.registers\[5\]\[5\] _0504_ VGND VGND VPWR VPWR _0512_ sky130_fd_sc_hd__and2_1
X_3546_ clknet_leaf_16_clk _0308_ _0119_ VGND VGND VPWR VPWR reg_file.registers\[11\]\[30\]
+ sky130_fd_sc_hd__dfrtp_1
XTAP_TAPCELL_ROW_8_219 VGND VPWR sky130_fd_sc_hd__tapvpwrvgnd_1
XFILLER_0_9_55 VGND VGND VPWR VPWR sky130_fd_sc_hd__fill_1
XFILLER_0_50_3 VPWR VGND VPWR VGND sky130_ef_sc_hd__decap_12
X_2428_ _0594_ _1025_ VGND VGND VPWR VPWR _1026_ sky130_fd_sc_hd__nor2_1
X_3477_ clknet_leaf_15_clk _0000_ VGND VGND VPWR VPWR net10 sky130_fd_sc_hd__dfxtp_1
X_2359_ _0938_ _0939_ VGND VGND VPWR VPWR _0957_ sky130_fd_sc_hd__or2_4
XFILLER_0_62_421 VPWR VGND VPWR VGND sky130_ef_sc_hd__decap_12
XTAP_TAPCELL_ROW_50_552 VGND VPWR sky130_fd_sc_hd__tapvpwrvgnd_1
XFILLER_0_65_281 VGND VGND VPWR VPWR sky130_fd_sc_hd__decap_4
XFILLER_0_57_259 VGND VGND VPWR VPWR sky130_fd_sc_hd__fill_1
XFILLER_0_57_248 VGND VGND VPWR VPWR sky130_fd_sc_hd__decap_4
XFILLER_0_31_57 VGND VGND VPWR VPWR sky130_fd_sc_hd__decap_8
X_3331_ _1704_ VGND VGND VPWR VPWR _1706_ sky130_fd_sc_hd__buf_4
X_1730_ _0419_ VGND VGND VPWR VPWR _0401_ sky130_fd_sc_hd__clkbuf_1
X_3400_ _1713_ VGND VGND VPWR VPWR _0182_ sky130_fd_sc_hd__inv_2
X_2213_ _0614_ _0617_ _0621_ VGND VGND VPWR VPWR _0811_ sky130_fd_sc_hd__nor3_2
X_3262_ _1696_ VGND VGND VPWR VPWR _0061_ sky130_fd_sc_hd__inv_2
X_2144_ _0597_ VGND VGND VPWR VPWR _0742_ sky130_fd_sc_hd__inv_2
XPHY_EDGE_ROW_37_Left_109 VGND VGND VPWR VPWR sky130_fd_sc_hd__decap_3
X_3193_ display.counter\[9\] _1672_ VGND VGND VPWR VPWR _1674_ sky130_fd_sc_hd__and2_1
XTAP_TAPCELL_ROW_64_666 VGND VPWR sky130_fd_sc_hd__tapvpwrvgnd_1
XFILLER_0_48_248 VGND VGND VPWR VPWR sky130_fd_sc_hd__decap_4
XPHY_EDGE_ROW_46_Left_118 VGND VGND VPWR VPWR sky130_fd_sc_hd__decap_3
X_2075_ reg_file.registers\[2\]\[22\] _0559_ VGND VGND VPWR VPWR _0673_ sky130_fd_sc_hd__and2_1
X_2977_ reg_file.registers\[15\]\[3\] _1514_ VGND VGND VPWR VPWR _1515_ sky130_fd_sc_hd__or2_1
X_1928_ reg_file.registers\[10\]\[13\] _0539_ VGND VGND VPWR VPWR _0540_ sky130_fd_sc_hd__and2_1
XFILLER_0_44_421 VPWR VGND VPWR VGND sky130_ef_sc_hd__decap_12
X_1859_ reg_file.registers\[5\]\[13\] _0493_ VGND VGND VPWR VPWR _0503_ sky130_fd_sc_hd__and2_1
XFILLER_0_16_167 VPWR VGND VPWR VGND sky130_ef_sc_hd__decap_12
XPHY_EDGE_ROW_55_Left_127 VGND VGND VPWR VPWR sky130_fd_sc_hd__decap_3
X_3529_ clknet_leaf_13_clk _0291_ _0102_ VGND VGND VPWR VPWR reg_file.registers\[11\]\[13\]
+ sky130_fd_sc_hd__dfrtp_1
XPHY_EDGE_ROW_64_Left_136 VGND VGND VPWR VPWR sky130_fd_sc_hd__decap_3
XFILLER_0_54_207 VGND VGND VPWR VPWR sky130_fd_sc_hd__fill_1
XTAP_TAPCELL_ROW_27_368 VGND VPWR sky130_fd_sc_hd__tapvpwrvgnd_1
XFILLER_0_22_104 VPWR VGND VPWR VGND sky130_ef_sc_hd__decap_12
XTAP_TAPCELL_ROW_10_235 VGND VPWR sky130_fd_sc_hd__tapvpwrvgnd_1
X_2900_ _1469_ VGND VGND VPWR VPWR _0281_ sky130_fd_sc_hd__clkbuf_1
XFILLER_0_26_35 VPWR VGND VPWR VGND sky130_ef_sc_hd__decap_12
XTAP_TAPCELL_ROW_18_302 VGND VPWR sky130_fd_sc_hd__tapvpwrvgnd_1
XTAP_TAPCELL_ROW_61_647 VGND VPWR sky130_fd_sc_hd__tapvpwrvgnd_1
X_2831_ _1264_ _1411_ _1013_ VGND VGND VPWR VPWR _1412_ sky130_fd_sc_hd__mux2_1
XFILLER_0_45_218 VGND VGND VPWR VPWR sky130_fd_sc_hd__decap_6
X_2762_ _1349_ VGND VGND VPWR VPWR _1350_ sky130_fd_sc_hd__inv_2
XFILLER_0_42_67 VPWR VGND VPWR VGND sky130_ef_sc_hd__decap_12
XFILLER_0_5_337 VGND VGND VPWR VPWR sky130_fd_sc_hd__decap_8
X_2693_ _1285_ VGND VGND VPWR VPWR _1286_ sky130_fd_sc_hd__inv_2
X_3314_ _1703_ VGND VGND VPWR VPWR _0106_ sky130_fd_sc_hd__inv_2
XFILLER_0_13_159 VGND VGND VPWR VPWR sky130_fd_sc_hd__decap_8
X_3245_ _1694_ VGND VGND VPWR VPWR _0046_ sky130_fd_sc_hd__inv_2
Xrebuffer23 net38 VGND VGND VPWR VPWR net39 sky130_fd_sc_hd__dlymetal6s2s_1
X_2127_ net24 _0590_ VGND VGND VPWR VPWR _0725_ sky130_fd_sc_hd__or2_2
Xrebuffer34 net49 VGND VGND VPWR VPWR net50 sky130_fd_sc_hd__dlygate4sd1_1
Xrebuffer12 _0867_ VGND VGND VPWR VPWR net28 sky130_fd_sc_hd__dlygate4sd1_1
X_3176_ display.counter\[1\] display.counter\[0\] display.counter\[2\] VGND VGND VPWR
+ VPWR _1664_ sky130_fd_sc_hd__and3_1
XFILLER_0_13_3 VPWR VGND VPWR VGND sky130_ef_sc_hd__decap_12
X_2058_ _0573_ _0652_ _0655_ VGND VGND VPWR VPWR _0656_ sky130_fd_sc_hd__a21boi_1
XFILLER_0_29_281 VPWR VGND VPWR VGND sky130_ef_sc_hd__decap_12
XTAP_TAPCELL_ROW_24_349 VGND VPWR sky130_fd_sc_hd__tapvpwrvgnd_1
XFILLER_0_8_153 VPWR VGND VPWR VGND sky130_ef_sc_hd__decap_12
XFILLER_0_8_197 VPWR VGND VPWR VGND sky130_ef_sc_hd__decap_12
XFILLER_0_12_15 VPWR VGND VPWR VGND sky130_ef_sc_hd__decap_12
Xoutput2 net2 VGND VGND VPWR VPWR an[0] sky130_fd_sc_hd__buf_1
XFILLER_0_2_307 VGND VGND VPWR VPWR sky130_fd_sc_hd__fill_1
X_3030_ imem.address\[15\] _1525_ VGND VGND VPWR VPWR _1548_ sky130_fd_sc_hd__nor2_1
XFILLER_0_53_55 VGND VGND VPWR VPWR sky130_fd_sc_hd__fill_1
XFILLER_0_18_218 VGND VGND VPWR VPWR sky130_fd_sc_hd__fill_2
X_2814_ _1064_ _1385_ _1393_ _1396_ VGND VGND VPWR VPWR _1397_ sky130_fd_sc_hd__a31o_1
XFILLER_0_26_273 VGND VGND VPWR VPWR sky130_fd_sc_hd__fill_1
XFILLER_0_26_251 VGND VGND VPWR VPWR sky130_fd_sc_hd__fill_1
XFILLER_0_5_167 VGND VGND VPWR VPWR sky130_fd_sc_hd__fill_1
X_2745_ reg_file.registers\[11\]\[23\] _1334_ _1059_ VGND VGND VPWR VPWR _1335_ sky130_fd_sc_hd__mux2_1
X_2676_ _0939_ _1268_ _0996_ VGND VGND VPWR VPWR _1269_ sky130_fd_sc_hd__mux2_1
XFILLER_0_1_373 VPWR VGND VPWR VGND sky130_ef_sc_hd__decap_12
X_3228_ _1693_ VGND VGND VPWR VPWR _0030_ sky130_fd_sc_hd__inv_2
XTAP_TAPCELL_ROW_37_452 VGND VPWR sky130_fd_sc_hd__tapvpwrvgnd_1
X_3159_ _1608_ _1645_ _1616_ VGND VGND VPWR VPWR _1655_ sky130_fd_sc_hd__or3_4
XFILLER_0_64_346 VGND VGND VPWR VPWR sky130_fd_sc_hd__fill_1
XFILLER_0_17_262 VPWR VGND VPWR VGND sky130_ef_sc_hd__decap_12
XFILLER_0_32_265 VPWR VGND VPWR VGND sky130_ef_sc_hd__decap_12
XFILLER_0_2_3 VPWR VGND VPWR VGND sky130_ef_sc_hd__decap_12
XTAP_TAPCELL_ROW_71_731 VGND VPWR sky130_fd_sc_hd__tapvpwrvgnd_1
XTAP_TAPCELL_ROW_71_720 VGND VPWR sky130_fd_sc_hd__tapvpwrvgnd_1
XFILLER_0_67_173 VGND VGND VPWR VPWR sky130_fd_sc_hd__decap_8
XFILLER_0_55_335 VGND VGND VPWR VPWR sky130_fd_sc_hd__fill_1
XFILLER_0_70_305 VGND VGND VPWR VPWR sky130_fd_sc_hd__decap_3
Xrebuffer3 net18 VGND VGND VPWR VPWR net19 sky130_fd_sc_hd__dlygate4sd1_1
XFILLER_0_55_368 VGND VGND VPWR VPWR sky130_fd_sc_hd__fill_1
XTAP_TAPCELL_ROW_43_499 VGND VPWR sky130_fd_sc_hd__tapvpwrvgnd_1
X_2530_ _1119_ _1126_ _1025_ VGND VGND VPWR VPWR _1127_ sky130_fd_sc_hd__mux2_1
X_2392_ _0594_ VGND VGND VPWR VPWR _0990_ sky130_fd_sc_hd__clkbuf_4
XFILLER_0_48_11 VGND VGND VPWR VPWR sky130_fd_sc_hd__decap_3
X_2461_ _1058_ VGND VGND VPWR VPWR _1059_ sky130_fd_sc_hd__clkbuf_4
XFILLER_0_11_449 VGND VGND VPWR VPWR sky130_fd_sc_hd__fill_2
XFILLER_0_64_65 VGND VGND VPWR VPWR sky130_fd_sc_hd__fill_1
X_3013_ _1533_ _1541_ VGND VGND VPWR VPWR _0240_ sky130_fd_sc_hd__nor2_1
XFILLER_0_3_57 VPWR VGND VPWR VGND sky130_ef_sc_hd__decap_12
Xclkbuf_leaf_16_clk clknet_1_1__leaf_clk VGND VGND VPWR VPWR clknet_leaf_16_clk sky130_fd_sc_hd__clkbuf_8
X_2659_ _0737_ _0720_ _0731_ VGND VGND VPWR VPWR _1252_ sky130_fd_sc_hd__mux2_1
XFILLER_0_14_221 VPWR VGND VPWR VGND sky130_ef_sc_hd__decap_12
X_2728_ reg_file.registers\[11\]\[24\] _1318_ _1059_ VGND VGND VPWR VPWR _1319_ sky130_fd_sc_hd__mux2_1
XFILLER_0_1_181 VPWR VGND VPWR VGND sky130_ef_sc_hd__decap_12
XFILLER_0_69_449 VGND VGND VPWR VPWR sky130_fd_sc_hd__fill_2
XFILLER_0_69_405 VGND VGND VPWR VPWR sky130_fd_sc_hd__decap_8
XFILLER_0_64_187 VGND VGND VPWR VPWR sky130_fd_sc_hd__fill_2
XFILLER_0_64_176 VGND VGND VPWR VPWR sky130_fd_sc_hd__fill_2
XFILLER_0_37_379 VGND VGND VPWR VPWR sky130_fd_sc_hd__fill_2
XFILLER_0_9_281 VPWR VGND VPWR VGND sky130_ef_sc_hd__decap_12
XFILLER_0_20_246 VGND VGND VPWR VPWR sky130_fd_sc_hd__decap_3
XFILLER_0_20_268 VGND VGND VPWR VPWR sky130_fd_sc_hd__fill_1
XTAP_TAPCELL_ROW_48_536 VGND VPWR sky130_fd_sc_hd__tapvpwrvgnd_1
XFILLER_0_50_23 VGND VGND VPWR VPWR sky130_fd_sc_hd__fill_1
XTAP_TAPCELL_ROW_31_403 VGND VPWR sky130_fd_sc_hd__tapvpwrvgnd_1
X_1961_ _0558_ VGND VGND VPWR VPWR _0559_ sky130_fd_sc_hd__buf_2
X_1892_ reg_file.registers\[10\]\[30\] _0519_ VGND VGND VPWR VPWR _0521_ sky130_fd_sc_hd__and2_1
XFILLER_0_70_113 VGND VGND VPWR VPWR sky130_fd_sc_hd__fill_1
XFILLER_0_59_65 VGND VGND VPWR VPWR sky130_fd_sc_hd__fill_1
XFILLER_0_51_393 VGND VGND VPWR VPWR sky130_fd_sc_hd__decap_8
X_3493_ clknet_leaf_3_clk _0255_ _0066_ VGND VGND VPWR VPWR reg_file.registers\[15\]\[9\]
+ sky130_fd_sc_hd__dfrtp_1
X_3562_ clknet_leaf_13_clk _0324_ _0135_ VGND VGND VPWR VPWR reg_file.registers\[10\]\[14\]
+ sky130_fd_sc_hd__dfrtp_2
X_2513_ _1067_ _1109_ VGND VGND VPWR VPWR _1110_ sky130_fd_sc_hd__nor2_1
X_3631_ clknet_leaf_0_clk _0393_ _0204_ VGND VGND VPWR VPWR reg_file.registers\[2\]\[20\]
+ sky130_fd_sc_hd__dfrtp_1
Xclkbuf_leaf_5_clk clknet_1_0__leaf_clk VGND VGND VPWR VPWR clknet_leaf_5_clk sky130_fd_sc_hd__clkbuf_8
X_2444_ _0825_ _0834_ _0994_ VGND VGND VPWR VPWR _1042_ sky130_fd_sc_hd__mux2_1
XFILLER_0_11_279 VGND VGND VPWR VPWR sky130_fd_sc_hd__fill_1
X_2375_ _0972_ VGND VGND VPWR VPWR _0973_ sky130_fd_sc_hd__inv_2
XFILLER_0_61_157 VGND VGND VPWR VPWR sky130_fd_sc_hd__decap_4
XFILLER_0_61_113 VPWR VGND VPWR VGND sky130_ef_sc_hd__decap_12
XFILLER_0_27_390 VGND VGND VPWR VPWR sky130_fd_sc_hd__fill_2
XFILLER_0_6_251 VGND VGND VPWR VPWR sky130_fd_sc_hd__fill_1
XFILLER_0_19_335 VGND VGND VPWR VPWR sky130_fd_sc_hd__fill_1
XFILLER_0_19_368 VGND VGND VPWR VPWR sky130_fd_sc_hd__decap_6
XTAP_TAPCELL_ROW_45_517 VGND VPWR sky130_fd_sc_hd__tapvpwrvgnd_1
XTAP_TAPCELL_ROW_2_172 VGND VPWR sky130_fd_sc_hd__tapvpwrvgnd_1
XFILLER_0_69_268 VPWR VGND VPWR VGND sky130_ef_sc_hd__decap_12
XTAP_TAPCELL_ROW_53_583 VGND VPWR sky130_fd_sc_hd__tapvpwrvgnd_1
XFILLER_0_25_305 VGND VGND VPWR VPWR sky130_fd_sc_hd__fill_1
XFILLER_0_25_349 VGND VGND VPWR VPWR sky130_fd_sc_hd__decap_6
XFILLER_0_25_327 VGND VGND VPWR VPWR sky130_fd_sc_hd__decap_8
XFILLER_0_0_405 VPWR VGND VPWR VGND sky130_ef_sc_hd__decap_12
XFILLER_0_20_15 VPWR VGND VPWR VGND sky130_ef_sc_hd__decap_12
XFILLER_0_20_37 VGND VGND VPWR VPWR sky130_fd_sc_hd__decap_3
X_2160_ _0756_ _0757_ VGND VGND VPWR VPWR _0758_ sky130_fd_sc_hd__or2_1
XFILLER_0_29_35 VGND VGND VPWR VPWR sky130_fd_sc_hd__fill_1
XFILLER_0_0_449 VGND VGND VPWR VPWR sky130_fd_sc_hd__fill_2
X_2091_ _0687_ _0688_ VGND VGND VPWR VPWR _0689_ sky130_fd_sc_hd__nand2_1
XFILLER_0_71_433 VPWR VGND VPWR VGND sky130_ef_sc_hd__decap_12
X_1944_ reg_file.registers\[10\]\[5\] _0539_ VGND VGND VPWR VPWR _0548_ sky130_fd_sc_hd__and2_1
X_2993_ imem.address\[17\] imem.address\[16\] _1526_ VGND VGND VPWR VPWR _1527_ sky130_fd_sc_hd__and3_1
X_3614_ clknet_leaf_7_clk _0376_ _0187_ VGND VGND VPWR VPWR reg_file.registers\[2\]\[3\]
+ sky130_fd_sc_hd__dfrtp_1
XFILLER_0_61_99 VGND VGND VPWR VPWR sky130_fd_sc_hd__fill_1
XFILLER_0_56_441 VGND VGND VPWR VPWR sky130_fd_sc_hd__decap_6
X_1875_ _0511_ VGND VGND VPWR VPWR _0348_ sky130_fd_sc_hd__clkbuf_1
XFILLER_0_43_124 VGND VGND VPWR VPWR sky130_fd_sc_hd__decap_3
XFILLER_0_28_176 VGND VGND VPWR VPWR sky130_fd_sc_hd__fill_2
XFILLER_0_0_69 VPWR VGND VPWR VGND sky130_ef_sc_hd__decap_12
XTAP_TAPCELL_ROW_16_285 VGND VPWR sky130_fd_sc_hd__tapvpwrvgnd_1
X_3476_ clknet_leaf_7_clk _0245_ _0056_ VGND VGND VPWR VPWR imem.address\[31\] sky130_fd_sc_hd__dfrtp_1
X_2427_ _0742_ VGND VGND VPWR VPWR _1025_ sky130_fd_sc_hd__clkbuf_4
X_3545_ clknet_leaf_19_clk _0307_ _0118_ VGND VGND VPWR VPWR reg_file.registers\[11\]\[29\]
+ sky130_fd_sc_hd__dfrtp_1
XFILLER_0_43_3 VGND VGND VPWR VPWR sky130_fd_sc_hd__decap_8
X_2289_ _0883_ _0884_ _0886_ VGND VGND VPWR VPWR _0887_ sky130_fd_sc_hd__o21ai_1
X_2358_ _0679_ _0943_ _0944_ VGND VGND VPWR VPWR _0956_ sky130_fd_sc_hd__nand3_1
XFILLER_0_39_419 VGND VGND VPWR VPWR sky130_fd_sc_hd__decap_8
XFILLER_0_62_433 VPWR VGND VPWR VGND sky130_ef_sc_hd__decap_12
XTAP_TAPCELL_ROW_50_553 VGND VPWR sky130_fd_sc_hd__tapvpwrvgnd_1
XTAP_TAPCELL_ROW_58_620 VGND VPWR sky130_fd_sc_hd__tapvpwrvgnd_1
XFILLER_0_15_15 VPWR VGND VPWR VGND sky130_ef_sc_hd__decap_12
XFILLER_0_31_25 VGND VGND VPWR VPWR sky130_fd_sc_hd__decap_8
XFILLER_0_40_138 VGND VGND VPWR VPWR sky130_fd_sc_hd__fill_2
X_3330_ _1705_ VGND VGND VPWR VPWR _0120_ sky130_fd_sc_hd__inv_2
XFILLER_0_56_55 VGND VGND VPWR VPWR sky130_fd_sc_hd__decap_4
X_2143_ net48 _0592_ _0558_ VGND VGND VPWR VPWR _0741_ sky130_fd_sc_hd__o21bai_4
X_3261_ _1696_ VGND VGND VPWR VPWR _0060_ sky130_fd_sc_hd__inv_2
X_2212_ _0797_ _0809_ VGND VGND VPWR VPWR _0810_ sky130_fd_sc_hd__nand2_1
X_3192_ _1672_ _1673_ VGND VGND VPWR VPWR _0025_ sky130_fd_sc_hd__nor2_1
XTAP_TAPCELL_ROW_64_667 VGND VPWR sky130_fd_sc_hd__tapvpwrvgnd_1
XFILLER_0_63_219 VGND VGND VPWR VPWR sky130_fd_sc_hd__decap_4
X_2074_ _0574_ _0671_ VGND VGND VPWR VPWR _0672_ sky130_fd_sc_hd__and2_1
XFILLER_0_8_335 VPWR VGND VPWR VGND sky130_ef_sc_hd__decap_12
X_1927_ _0518_ VGND VGND VPWR VPWR _0539_ sky130_fd_sc_hd__clkbuf_2
X_2976_ _0470_ _0481_ VGND VGND VPWR VPWR _1514_ sky130_fd_sc_hd__nor2_1
XFILLER_0_44_433 VPWR VGND VPWR VGND sky130_ef_sc_hd__decap_12
X_1858_ _0502_ VGND VGND VPWR VPWR _0356_ sky130_fd_sc_hd__clkbuf_1
XFILLER_0_16_179 VGND VGND VPWR VPWR sky130_fd_sc_hd__decap_3
X_3459_ clknet_leaf_7_clk _0228_ _0039_ VGND VGND VPWR VPWR imem.address\[14\] sky130_fd_sc_hd__dfrtp_1
X_1789_ imem.address\[31\] imem.address\[30\] _0449_ _0450_ VGND VGND VPWR VPWR _0451_
+ sky130_fd_sc_hd__or4_4
X_3528_ clknet_leaf_12_clk _0290_ _0101_ VGND VGND VPWR VPWR reg_file.registers\[11\]\[12\]
+ sky130_fd_sc_hd__dfrtp_1
XFILLER_0_12_385 VGND VGND VPWR VPWR sky130_fd_sc_hd__decap_8
XTAP_TAPCELL_ROW_27_369 VGND VPWR sky130_fd_sc_hd__tapvpwrvgnd_1
XFILLER_0_62_263 VGND VGND VPWR VPWR sky130_fd_sc_hd__decap_8
XFILLER_0_30_160 VGND VGND VPWR VPWR sky130_fd_sc_hd__fill_1
XFILLER_0_22_116 VPWR VGND VPWR VGND sky130_ef_sc_hd__decap_12
XTAP_TAPCELL_ROW_10_236 VGND VPWR sky130_fd_sc_hd__tapvpwrvgnd_1
XFILLER_0_26_47 VPWR VGND VPWR VGND sky130_ef_sc_hd__decap_12
X_2830_ _1254_ VGND VGND VPWR VPWR _1411_ sky130_fd_sc_hd__inv_2
XTAP_TAPCELL_ROW_18_303 VGND VPWR sky130_fd_sc_hd__tapvpwrvgnd_1
X_2692_ _1283_ _1284_ _1002_ VGND VGND VPWR VPWR _1285_ sky130_fd_sc_hd__mux2_1
X_2761_ _1038_ _1041_ _1003_ VGND VGND VPWR VPWR _1349_ sky130_fd_sc_hd__mux2_1
XFILLER_0_42_79 VGND VGND VPWR VPWR sky130_fd_sc_hd__decap_4
XFILLER_0_41_447 VGND VGND VPWR VPWR sky130_fd_sc_hd__fill_1
XFILLER_0_5_305 VPWR VGND VPWR VGND sky130_ef_sc_hd__decap_12
XTAP_TAPCELL_ROW_69_704 VGND VPWR sky130_fd_sc_hd__tapvpwrvgnd_1
X_3244_ _1694_ VGND VGND VPWR VPWR _0045_ sky130_fd_sc_hd__inv_2
XFILLER_0_67_54 VGND VGND VPWR VPWR sky130_fd_sc_hd__fill_2
X_3313_ _1703_ VGND VGND VPWR VPWR _0105_ sky130_fd_sc_hd__inv_2
Xrebuffer24 net38 VGND VGND VPWR VPWR net40 sky130_fd_sc_hd__dlymetal6s2s_1
X_2126_ _0723_ net54 VGND VGND VPWR VPWR _0724_ sky130_fd_sc_hd__xnor2_1
Xrebuffer13 _0622_ VGND VGND VPWR VPWR net29 sky130_fd_sc_hd__dlymetal6s2s_1
X_2057_ _0573_ _0654_ _0578_ VGND VGND VPWR VPWR _0655_ sky130_fd_sc_hd__a21oi_1
X_3175_ display.counter\[1\] display.counter\[0\] VGND VGND VPWR VPWR _0018_ sky130_fd_sc_hd__xor2_1
XPHY_EDGE_ROW_16_Left_88 VGND VGND VPWR VPWR sky130_fd_sc_hd__decap_3
Xrebuffer35 net49 VGND VGND VPWR VPWR net51 sky130_fd_sc_hd__dlygate4sd1_1
X_2959_ _1505_ VGND VGND VPWR VPWR _0258_ sky130_fd_sc_hd__clkbuf_1
XFILLER_0_29_293 VPWR VGND VPWR VGND sky130_ef_sc_hd__decap_12
XFILLER_0_8_121 VPWR VGND VPWR VGND sky130_ef_sc_hd__decap_12
XFILLER_0_8_165 VPWR VGND VPWR VGND sky130_ef_sc_hd__decap_12
XFILLER_0_44_263 VPWR VGND VPWR VGND sky130_ef_sc_hd__decap_12
XFILLER_0_32_414 VGND VGND VPWR VPWR sky130_fd_sc_hd__decap_6
XFILLER_0_12_27 VGND VGND VPWR VPWR sky130_fd_sc_hd__fill_1
Xoutput3 net3 VGND VGND VPWR VPWR an[1] sky130_fd_sc_hd__buf_1
XFILLER_0_58_399 VGND VGND VPWR VPWR sky130_fd_sc_hd__fill_1
XFILLER_0_58_344 VGND VGND VPWR VPWR sky130_fd_sc_hd__decap_6
XFILLER_0_53_78 VPWR VGND VPWR VGND sky130_ef_sc_hd__decap_12
X_2813_ _1311_ _1341_ _1395_ VGND VGND VPWR VPWR _1396_ sky130_fd_sc_hd__a21bo_1
XFILLER_0_41_222 VGND VGND VPWR VPWR sky130_fd_sc_hd__fill_2
X_2744_ _1329_ _1333_ VGND VGND VPWR VPWR _1334_ sky130_fd_sc_hd__or2_1
XFILLER_0_5_113 VPWR VGND VPWR VGND sky130_ef_sc_hd__decap_12
X_2675_ _0951_ VGND VGND VPWR VPWR _1268_ sky130_fd_sc_hd__inv_2
X_3227_ _1693_ VGND VGND VPWR VPWR _0029_ sky130_fd_sc_hd__inv_2
XFILLER_0_1_385 VGND VGND VPWR VPWR sky130_fd_sc_hd__decap_6
X_2109_ reg_file.registers\[11\]\[7\] _0693_ _0698_ reg_file.registers\[10\]\[7\]
+ VGND VGND VPWR VPWR _0707_ sky130_fd_sc_hd__a22o_1
XFILLER_0_49_311 VGND VGND VPWR VPWR sky130_fd_sc_hd__fill_2
X_3089_ _1434_ _1586_ _1588_ _1449_ VGND VGND VPWR VPWR _1589_ sky130_fd_sc_hd__a22o_1
XTAP_TAPCELL_ROW_37_453 VGND VPWR sky130_fd_sc_hd__tapvpwrvgnd_1
X_3158_ _1648_ _1616_ _1651_ _1653_ VGND VGND VPWR VPWR _1654_ sky130_fd_sc_hd__nor4_1
XFILLER_0_64_358 VGND VGND VPWR VPWR sky130_fd_sc_hd__fill_1
XFILLER_0_32_211 VPWR VGND VPWR VGND sky130_ef_sc_hd__decap_12
XFILLER_0_32_200 VGND VGND VPWR VPWR sky130_fd_sc_hd__fill_1
XFILLER_0_17_274 VGND VGND VPWR VPWR sky130_fd_sc_hd__decap_6
XFILLER_0_32_277 VGND VGND VPWR VPWR sky130_fd_sc_hd__fill_2
XTAP_TAPCELL_ROW_71_732 VGND VPWR sky130_fd_sc_hd__tapvpwrvgnd_1
XTAP_TAPCELL_ROW_71_721 VGND VPWR sky130_fd_sc_hd__tapvpwrvgnd_1
XFILLER_0_67_196 VGND VGND VPWR VPWR sky130_fd_sc_hd__fill_1
XFILLER_0_67_152 VGND VGND VPWR VPWR sky130_fd_sc_hd__fill_2
XFILLER_0_23_15 VPWR VGND VPWR VGND sky130_ef_sc_hd__decap_12
X_2460_ _0458_ _0481_ _0457_ VGND VGND VPWR VPWR _1058_ sky130_fd_sc_hd__nor3b_4
Xrebuffer4 _0461_ VGND VGND VPWR VPWR net20 sky130_fd_sc_hd__dlygate4sd1_1
XFILLER_0_23_211 VGND VGND VPWR VPWR sky130_fd_sc_hd__fill_1
X_2391_ _0977_ _0985_ _0986_ _0988_ VGND VGND VPWR VPWR _0989_ sky130_fd_sc_hd__a211o_1
XFILLER_0_64_33 VGND VGND VPWR VPWR sky130_fd_sc_hd__decap_3
X_3012_ imem.address\[25\] _1532_ imem.address\[26\] VGND VGND VPWR VPWR _1541_ sky130_fd_sc_hd__a21oi_1
XFILLER_0_58_141 VGND VGND VPWR VPWR sky130_fd_sc_hd__decap_3
XFILLER_0_3_69 VPWR VGND VPWR VGND sky130_ef_sc_hd__decap_12
XFILLER_0_58_152 VGND VGND VPWR VPWR sky130_fd_sc_hd__fill_1
X_2589_ _1011_ _1037_ _1004_ VGND VGND VPWR VPWR _1185_ sky130_fd_sc_hd__mux2_1
X_2727_ _1137_ _1312_ _1314_ _1315_ _1317_ VGND VGND VPWR VPWR _1318_ sky130_fd_sc_hd__a221o_1
XFILLER_0_1_193 VPWR VGND VPWR VGND sky130_ef_sc_hd__decap_12
XFILLER_0_14_233 VPWR VGND VPWR VGND sky130_ef_sc_hd__decap_12
XFILLER_0_14_299 VGND VGND VPWR VPWR sky130_fd_sc_hd__fill_1
X_2658_ _1251_ VGND VGND VPWR VPWR _0305_ sky130_fd_sc_hd__clkbuf_1
XFILLER_0_49_185 VGND VGND VPWR VPWR sky130_fd_sc_hd__fill_1
XFILLER_0_37_347 VGND VGND VPWR VPWR sky130_fd_sc_hd__decap_6
XPHY_EDGE_ROW_19_Left_91 VGND VGND VPWR VPWR sky130_fd_sc_hd__decap_3
XFILLER_0_60_361 VGND VGND VPWR VPWR sky130_fd_sc_hd__decap_3
XFILLER_0_45_391 VGND VGND VPWR VPWR sky130_fd_sc_hd__fill_1
XFILLER_0_18_15 VPWR VGND VPWR VGND sky130_ef_sc_hd__decap_12
XTAP_TAPCELL_ROW_48_537 VGND VPWR sky130_fd_sc_hd__tapvpwrvgnd_1
XFILLER_0_34_25 VGND VGND VPWR VPWR sky130_fd_sc_hd__decap_3
XTAP_TAPCELL_ROW_5_192 VGND VPWR sky130_fd_sc_hd__tapvpwrvgnd_1
X_1960_ _0557_ VGND VGND VPWR VPWR _0558_ sky130_fd_sc_hd__buf_2
XTAP_TAPCELL_ROW_31_404 VGND VPWR sky130_fd_sc_hd__tapvpwrvgnd_1
X_3630_ clknet_leaf_0_clk _0392_ _0203_ VGND VGND VPWR VPWR reg_file.registers\[2\]\[19\]
+ sky130_fd_sc_hd__dfrtp_1
X_1891_ _0520_ VGND VGND VPWR VPWR _0341_ sky130_fd_sc_hd__clkbuf_1
XFILLER_0_70_169 VGND VGND VPWR VPWR sky130_fd_sc_hd__decap_6
XFILLER_0_59_44 VGND VGND VPWR VPWR sky130_fd_sc_hd__decap_3
XFILLER_0_51_350 VPWR VGND VPWR VGND sky130_ef_sc_hd__decap_12
X_3492_ clknet_leaf_5_clk _0254_ _0065_ VGND VGND VPWR VPWR reg_file.registers\[15\]\[8\]
+ sky130_fd_sc_hd__dfrtp_1
X_2443_ _0820_ _1040_ _0994_ VGND VGND VPWR VPWR _1041_ sky130_fd_sc_hd__mux2_1
X_3561_ clknet_leaf_12_clk _0323_ _0134_ VGND VGND VPWR VPWR reg_file.registers\[10\]\[13\]
+ sky130_fd_sc_hd__dfrtp_1
X_2512_ _1090_ _1106_ _1108_ VGND VGND VPWR VPWR _1109_ sky130_fd_sc_hd__mux2_1
XFILLER_0_3_447 VGND VGND VPWR VPWR sky130_fd_sc_hd__fill_1
XFILLER_0_11_225 VPWR VGND VPWR VGND sky130_ef_sc_hd__decap_12
X_2374_ _0970_ _0971_ VGND VGND VPWR VPWR _0972_ sky130_fd_sc_hd__or2_1
XFILLER_0_66_409 VGND VGND VPWR VPWR sky130_fd_sc_hd__decap_8
XFILLER_0_46_133 VGND VGND VPWR VPWR sky130_fd_sc_hd__decap_3
XFILLER_0_61_125 VGND VGND VPWR VPWR sky130_fd_sc_hd__fill_1
XFILLER_0_61_103 VGND VGND VPWR VPWR sky130_fd_sc_hd__fill_1
XFILLER_0_40_90 VPWR VGND VPWR VGND sky130_ef_sc_hd__decap_12
XTAP_TAPCELL_ROW_45_518 VGND VPWR sky130_fd_sc_hd__tapvpwrvgnd_1
XTAP_TAPCELL_ROW_2_173 VGND VPWR sky130_fd_sc_hd__tapvpwrvgnd_1
XFILLER_0_25_317 VGND VGND VPWR VPWR sky130_fd_sc_hd__fill_1
XPHY_EDGE_ROW_4_Left_76 VGND VGND VPWR VPWR sky130_fd_sc_hd__decap_3
XFILLER_0_0_417 VGND VGND VPWR VPWR sky130_fd_sc_hd__decap_3
XFILLER_0_20_27 VGND VGND VPWR VPWR sky130_fd_sc_hd__fill_1
X_2090_ _0679_ _0683_ _0686_ _0580_ VGND VGND VPWR VPWR _0688_ sky130_fd_sc_hd__o22ai_1
XFILLER_0_68_280 VGND VGND VPWR VPWR sky130_fd_sc_hd__decap_8
X_2992_ imem.address\[15\] _1525_ VGND VGND VPWR VPWR _1526_ sky130_fd_sc_hd__and2_1
XFILLER_0_0_15 VPWR VGND VPWR VGND sky130_ef_sc_hd__decap_12
X_1943_ _0547_ VGND VGND VPWR VPWR _0316_ sky130_fd_sc_hd__clkbuf_1
X_3613_ clknet_leaf_8_clk _0375_ _0186_ VGND VGND VPWR VPWR reg_file.registers\[2\]\[2\]
+ sky130_fd_sc_hd__dfrtp_1
X_1874_ reg_file.registers\[5\]\[6\] _0504_ VGND VGND VPWR VPWR _0511_ sky130_fd_sc_hd__and2_1
XFILLER_0_28_144 VGND VGND VPWR VPWR sky130_fd_sc_hd__decap_8
XFILLER_0_9_57 VPWR VGND VPWR VGND sky130_ef_sc_hd__decap_12
XTAP_TAPCELL_ROW_16_286 VGND VPWR sky130_fd_sc_hd__tapvpwrvgnd_1
X_3475_ clknet_leaf_7_clk _0244_ _0055_ VGND VGND VPWR VPWR imem.address\[30\] sky130_fd_sc_hd__dfrtp_1
X_2426_ _1019_ _1021_ _1023_ VGND VGND VPWR VPWR _1024_ sky130_fd_sc_hd__o21ai_1
X_3544_ clknet_leaf_16_clk _0306_ _0117_ VGND VGND VPWR VPWR reg_file.registers\[11\]\[28\]
+ sky130_fd_sc_hd__dfrtp_2
XFILLER_0_36_3 VPWR VGND VPWR VGND sky130_ef_sc_hd__decap_12
X_2288_ _0575_ _0885_ _0579_ VGND VGND VPWR VPWR _0886_ sky130_fd_sc_hd__a21o_1
XFILLER_0_19_80 VGND VGND VPWR VPWR sky130_fd_sc_hd__fill_1
X_2357_ _0942_ _0949_ _0954_ VGND VGND VPWR VPWR _0955_ sky130_fd_sc_hd__and3_1
XTAP_TAPCELL_ROW_50_554 VGND VPWR sky130_fd_sc_hd__tapvpwrvgnd_1
XFILLER_0_19_133 VPWR VGND VPWR VGND sky130_ef_sc_hd__decap_12
XFILLER_0_62_445 VGND VGND VPWR VPWR sky130_fd_sc_hd__decap_6
XFILLER_0_22_309 VGND VGND VPWR VPWR sky130_fd_sc_hd__decap_3
XTAP_TAPCELL_ROW_58_621 VGND VPWR sky130_fd_sc_hd__tapvpwrvgnd_1
XTAP_TAPCELL_ROW_7_210 VGND VPWR sky130_fd_sc_hd__tapvpwrvgnd_1
XFILLER_0_15_27 VGND VGND VPWR VPWR sky130_fd_sc_hd__decap_8
XFILLER_0_65_261 VGND VGND VPWR VPWR sky130_fd_sc_hd__decap_4
XFILLER_0_53_412 VGND VGND VPWR VPWR sky130_fd_sc_hd__fill_1
XFILLER_0_31_15 VGND VGND VPWR VPWR sky130_fd_sc_hd__decap_6
XTAP_TAPCELL_ROW_13_256 VGND VPWR sky130_fd_sc_hd__tapvpwrvgnd_1
X_3260_ _1696_ VGND VGND VPWR VPWR _0059_ sky130_fd_sc_hd__inv_2
XFILLER_0_56_23 VGND VGND VPWR VPWR sky130_fd_sc_hd__fill_2
XFILLER_0_0_225 VPWR VGND VPWR VGND sky130_ef_sc_hd__decap_12
XFILLER_0_21_331 VGND VGND VPWR VPWR sky130_fd_sc_hd__decap_4
X_2142_ _0719_ _0720_ _0722_ _0739_ VGND VGND VPWR VPWR _0740_ sky130_fd_sc_hd__a2bb2o_1
X_2211_ _0804_ _0807_ _0808_ VGND VGND VPWR VPWR _0809_ sky130_fd_sc_hd__and3_1
X_2073_ reg_file.registers\[5\]\[23\] _0564_ _0568_ reg_file.registers\[15\]\[23\]
+ _0670_ VGND VGND VPWR VPWR _0671_ sky130_fd_sc_hd__a221o_1
X_3191_ display.counter\[7\] _1670_ display.counter\[8\] VGND VGND VPWR VPWR _1673_
+ sky130_fd_sc_hd__a21oi_1
XTAP_TAPCELL_ROW_64_668 VGND VPWR sky130_fd_sc_hd__tapvpwrvgnd_1
X_2975_ _1513_ VGND VGND VPWR VPWR _0250_ sky130_fd_sc_hd__clkbuf_1
XFILLER_0_8_314 VGND VGND VPWR VPWR sky130_fd_sc_hd__fill_1
XFILLER_0_8_347 VPWR VGND VPWR VGND sky130_ef_sc_hd__decap_12
XFILLER_0_71_253 VPWR VGND VPWR VGND sky130_ef_sc_hd__decap_12
X_1788_ imem.address\[18\] imem.address\[20\] imem.address\[19\] imem.address\[21\]
+ VGND VGND VPWR VPWR _0450_ sky130_fd_sc_hd__or4_4
X_3527_ clknet_leaf_12_clk _0289_ _0100_ VGND VGND VPWR VPWR reg_file.registers\[11\]\[11\]
+ sky130_fd_sc_hd__dfrtp_1
XFILLER_0_44_445 VGND VGND VPWR VPWR sky130_fd_sc_hd__decap_6
X_1926_ _0538_ VGND VGND VPWR VPWR _0324_ sky130_fd_sc_hd__clkbuf_1
X_1857_ reg_file.registers\[5\]\[14\] _0493_ VGND VGND VPWR VPWR _0502_ sky130_fd_sc_hd__and2_1
X_3458_ clknet_leaf_7_clk _0227_ _0038_ VGND VGND VPWR VPWR imem.address\[13\] sky130_fd_sc_hd__dfrtp_1
X_3389_ _1712_ VGND VGND VPWR VPWR _0172_ sky130_fd_sc_hd__inv_2
X_2409_ reg_file.registers\[10\]\[19\] _0785_ _0786_ VGND VGND VPWR VPWR _1007_ sky130_fd_sc_hd__and3_1
XFILLER_0_39_206 VPWR VGND VPWR VGND sky130_ef_sc_hd__decap_12
XFILLER_0_62_253 VGND VGND VPWR VPWR sky130_fd_sc_hd__decap_6
XFILLER_0_50_415 VGND VGND VPWR VPWR sky130_fd_sc_hd__decap_4
XFILLER_0_7_391 VGND VGND VPWR VPWR sky130_fd_sc_hd__fill_1
XTAP_TAPCELL_ROW_10_237 VGND VPWR sky130_fd_sc_hd__tapvpwrvgnd_1
XFILLER_0_22_139 VGND VGND VPWR VPWR sky130_fd_sc_hd__fill_1
XFILLER_0_26_59 VGND VGND VPWR VPWR sky130_fd_sc_hd__decap_3
XFILLER_0_26_15 VPWR VGND VPWR VGND sky130_ef_sc_hd__decap_12
XFILLER_0_42_36 VGND VGND VPWR VPWR sky130_fd_sc_hd__decap_8
XFILLER_0_38_250 VGND VGND VPWR VPWR sky130_fd_sc_hd__fill_2
XFILLER_0_26_412 VGND VGND VPWR VPWR sky130_fd_sc_hd__decap_8
XFILLER_0_53_253 VGND VGND VPWR VPWR sky130_fd_sc_hd__decap_3
X_2691_ _0842_ _0802_ _0994_ VGND VGND VPWR VPWR _1284_ sky130_fd_sc_hd__mux2_1
X_2760_ _0923_ _0881_ _1325_ VGND VGND VPWR VPWR _1348_ sky130_fd_sc_hd__or3_1
XFILLER_0_5_317 VPWR VGND VPWR VGND sky130_ef_sc_hd__decap_12
XFILLER_0_13_139 VGND VGND VPWR VPWR sky130_fd_sc_hd__fill_1
X_3243_ _1694_ VGND VGND VPWR VPWR _0044_ sky130_fd_sc_hd__inv_2
XTAP_TAPCELL_ROW_69_705 VGND VPWR sky130_fd_sc_hd__tapvpwrvgnd_1
X_3312_ _1703_ VGND VGND VPWR VPWR _0104_ sky130_fd_sc_hd__inv_2
Xrebuffer25 net40 VGND VGND VPWR VPWR net41 sky130_fd_sc_hd__dlygate4sd1_1
X_2125_ reg_file.registers\[15\]\[1\] _0599_ _0562_ reg_file.registers\[5\]\[1\] net53
+ VGND VGND VPWR VPWR _0723_ sky130_fd_sc_hd__a221oi_4
X_3174_ _1579_ VGND VGND VPWR VPWR _0413_ sky130_fd_sc_hd__inv_2
X_2056_ reg_file.registers\[5\]\[17\] _0563_ _0567_ reg_file.registers\[15\]\[17\]
+ _0653_ VGND VGND VPWR VPWR _0654_ sky130_fd_sc_hd__a221o_1
Xrebuffer14 net32 VGND VGND VPWR VPWR net30 sky130_fd_sc_hd__dlymetal6s2s_1
Xrebuffer36 net51 VGND VGND VPWR VPWR net52 sky130_fd_sc_hd__dlygate4sd1_1
XFILLER_0_44_275 VGND VGND VPWR VPWR sky130_fd_sc_hd__decap_3
XFILLER_0_44_253 VGND VGND VPWR VPWR sky130_fd_sc_hd__decap_6
X_2958_ reg_file.registers\[15\]\[12\] _1495_ VGND VGND VPWR VPWR _1505_ sky130_fd_sc_hd__and2_1
XFILLER_0_8_133 VGND VGND VPWR VPWR sky130_fd_sc_hd__decap_6
XFILLER_0_8_177 VPWR VGND VPWR VGND sky130_ef_sc_hd__decap_12
X_1909_ reg_file.registers\[10\]\[22\] _0528_ VGND VGND VPWR VPWR _0530_ sky130_fd_sc_hd__and2_1
X_2889_ _1460_ VGND VGND VPWR VPWR _0283_ sky130_fd_sc_hd__clkbuf_1
XFILLER_0_44_286 VPWR VGND VPWR VGND sky130_ef_sc_hd__decap_12
XFILLER_0_67_389 VGND VGND VPWR VPWR sky130_fd_sc_hd__decap_3
XTAP_TAPCELL_ROW_23_340 VGND VPWR sky130_fd_sc_hd__tapvpwrvgnd_1
XFILLER_0_50_256 VGND VGND VPWR VPWR sky130_fd_sc_hd__fill_2
XFILLER_0_2_309 VPWR VGND VPWR VGND sky130_ef_sc_hd__decap_12
Xoutput4 net4 VGND VGND VPWR VPWR an[2] sky130_fd_sc_hd__buf_1
XFILLER_0_37_47 VGND VGND VPWR VPWR sky130_fd_sc_hd__decap_3
XFILLER_0_10_109 VPWR VGND VPWR VGND sky130_ef_sc_hd__decap_12
XFILLER_0_58_301 VGND VGND VPWR VPWR sky130_fd_sc_hd__fill_2
XFILLER_0_53_57 VGND VGND VPWR VPWR sky130_fd_sc_hd__decap_4
X_2812_ _1313_ _1363_ _1394_ _1067_ VGND VGND VPWR VPWR _1395_ sky130_fd_sc_hd__o22a_1
X_2743_ _0752_ _1330_ _1331_ _1332_ VGND VGND VPWR VPWR _1333_ sky130_fd_sc_hd__o2bb2a_1
XFILLER_0_5_125 VPWR VGND VPWR VGND sky130_ef_sc_hd__decap_12
X_2674_ _0594_ _1025_ _1254_ _1266_ VGND VGND VPWR VPWR _1267_ sky130_fd_sc_hd__a31o_1
XFILLER_0_5_169 VPWR VGND VPWR VGND sky130_ef_sc_hd__decap_12
X_3226_ _1693_ VGND VGND VPWR VPWR _0028_ sky130_fd_sc_hd__inv_2
X_3157_ _1634_ _1644_ VGND VGND VPWR VPWR _1653_ sky130_fd_sc_hd__nor2_1
X_2108_ _0622_ _0705_ VGND VGND VPWR VPWR _0706_ sky130_fd_sc_hd__nand2_1
X_3088_ _0477_ _0409_ VGND VGND VPWR VPWR _1588_ sky130_fd_sc_hd__nor2_1
X_2039_ reg_file.registers\[5\]\[12\] _0563_ _0567_ reg_file.registers\[15\]\[12\]
+ _0636_ VGND VGND VPWR VPWR _0637_ sky130_fd_sc_hd__a221o_1
XTAP_TAPCELL_ROW_37_454 VGND VPWR sky130_fd_sc_hd__tapvpwrvgnd_1
XFILLER_0_32_223 VPWR VGND VPWR VGND sky130_ef_sc_hd__decap_12
XFILLER_0_20_407 VGND VGND VPWR VPWR sky130_fd_sc_hd__fill_1
XTAP_TAPCELL_ROW_71_733 VGND VPWR sky130_fd_sc_hd__tapvpwrvgnd_1
XTAP_TAPCELL_ROW_71_722 VGND VPWR sky130_fd_sc_hd__tapvpwrvgnd_1
XFILLER_0_23_27 VGND VGND VPWR VPWR sky130_fd_sc_hd__decap_8
XFILLER_0_63_370 VGND VGND VPWR VPWR sky130_fd_sc_hd__decap_6
Xrebuffer5 net20 VGND VGND VPWR VPWR net21 sky130_fd_sc_hd__dlygate4sd1_1
XFILLER_0_23_223 VGND VGND VPWR VPWR sky130_fd_sc_hd__fill_1
XFILLER_0_2_139 VGND VGND VPWR VPWR sky130_fd_sc_hd__fill_1
X_2390_ _0987_ VGND VGND VPWR VPWR _0988_ sky130_fd_sc_hd__clkbuf_4
X_3011_ _1534_ _1540_ VGND VGND VPWR VPWR _0241_ sky130_fd_sc_hd__nor2_1
XFILLER_0_3_15 VPWR VGND VPWR VGND sky130_ef_sc_hd__decap_12
XFILLER_0_64_89 VGND VGND VPWR VPWR sky130_fd_sc_hd__decap_4
XTAP_TAPCELL_ROW_34_424 VGND VPWR sky130_fd_sc_hd__tapvpwrvgnd_1
XTAP_TAPCELL_ROW_42_490 VGND VPWR sky130_fd_sc_hd__tapvpwrvgnd_1
X_2726_ _0936_ _0988_ _1316_ VGND VGND VPWR VPWR _1317_ sky130_fd_sc_hd__nor3_1
XFILLER_0_66_3 VGND VGND VPWR VPWR sky130_fd_sc_hd__fill_2
X_2588_ _1170_ _1183_ _0990_ VGND VGND VPWR VPWR _1184_ sky130_fd_sc_hd__mux2_1
XFILLER_0_1_161 VGND VGND VPWR VPWR sky130_fd_sc_hd__decap_6
XFILLER_0_14_289 VGND VGND VPWR VPWR sky130_fd_sc_hd__fill_1
X_2657_ reg_file.registers\[11\]\[27\] _1250_ _1059_ VGND VGND VPWR VPWR _1251_ sky130_fd_sc_hd__mux2_1
X_3209_ _1682_ _1683_ VGND VGND VPWR VPWR _0013_ sky130_fd_sc_hd__nor2_1
XFILLER_0_49_197 VPWR VGND VPWR VGND sky130_ef_sc_hd__decap_12
XFILLER_0_49_164 VGND VGND VPWR VPWR sky130_fd_sc_hd__decap_4
XFILLER_0_37_337 VGND VGND VPWR VPWR sky130_fd_sc_hd__fill_1
XFILLER_0_37_304 VPWR VGND VPWR VGND sky130_ef_sc_hd__decap_12
XFILLER_0_9_261 VPWR VGND VPWR VGND sky130_ef_sc_hd__decap_12
XFILLER_0_60_351 VGND VGND VPWR VPWR sky130_fd_sc_hd__decap_4
XFILLER_0_20_226 VGND VGND VPWR VPWR sky130_fd_sc_hd__fill_1
XFILLER_0_18_27 VGND VGND VPWR VPWR sky130_fd_sc_hd__fill_1
XTAP_TAPCELL_ROW_48_538 VGND VPWR sky130_fd_sc_hd__tapvpwrvgnd_1
XFILLER_0_34_15 VGND VGND VPWR VPWR sky130_fd_sc_hd__decap_3
XTAP_TAPCELL_ROW_5_193 VGND VPWR sky130_fd_sc_hd__tapvpwrvgnd_1
XPHY_EDGE_ROW_16_Right_16 VGND VGND VPWR VPWR sky130_fd_sc_hd__decap_3
X_3560_ clknet_leaf_12_clk _0322_ _0133_ VGND VGND VPWR VPWR reg_file.registers\[10\]\[12\]
+ sky130_fd_sc_hd__dfrtp_1
XFILLER_0_36_381 VPWR VGND VPWR VGND sky130_ef_sc_hd__decap_12
XTAP_TAPCELL_ROW_31_405 VGND VPWR sky130_fd_sc_hd__tapvpwrvgnd_1
XPHY_EDGE_ROW_25_Right_25 VGND VGND VPWR VPWR sky130_fd_sc_hd__decap_3
X_1890_ reg_file.registers\[10\]\[31\] _0519_ VGND VGND VPWR VPWR _0520_ sky130_fd_sc_hd__and2_1
X_3491_ clknet_leaf_5_clk _0253_ _0064_ VGND VGND VPWR VPWR reg_file.registers\[15\]\[7\]
+ sky130_fd_sc_hd__dfrtp_1
XFILLER_0_51_362 VPWR VGND VPWR VGND sky130_ef_sc_hd__decap_12
X_2442_ _0842_ VGND VGND VPWR VPWR _1040_ sky130_fd_sc_hd__inv_2
X_2511_ _1107_ VGND VGND VPWR VPWR _1108_ sky130_fd_sc_hd__clkbuf_4
XFILLER_0_11_237 VPWR VGND VPWR VGND sky130_ef_sc_hd__decap_12
X_2373_ reg_file.registers\[11\]\[30\] _0927_ _0928_ reg_file.registers\[10\]\[30\]
+ VGND VGND VPWR VPWR _0971_ sky130_fd_sc_hd__a22o_1
XFILLER_0_38_7 VGND VGND VPWR VPWR sky130_fd_sc_hd__fill_1
XPHY_EDGE_ROW_34_Right_34 VGND VGND VPWR VPWR sky130_fd_sc_hd__decap_3
XFILLER_0_34_307 VGND VGND VPWR VPWR sky130_fd_sc_hd__fill_1
XPHY_EDGE_ROW_20_Left_92 VGND VGND VPWR VPWR sky130_fd_sc_hd__decap_3
XPHY_EDGE_ROW_43_Right_43 VGND VGND VPWR VPWR sky130_fd_sc_hd__decap_3
X_2709_ reg_file.registers\[11\]\[14\] _0927_ _0928_ reg_file.registers\[10\]\[14\]
+ _1153_ VGND VGND VPWR VPWR _1301_ sky130_fd_sc_hd__a221o_1
XFILLER_0_6_253 VPWR VGND VPWR VGND sky130_ef_sc_hd__decap_12
XPHY_EDGE_ROW_52_Right_52 VGND VGND VPWR VPWR sky130_fd_sc_hd__decap_3
XTAP_TAPCELL_ROW_45_519 VGND VPWR sky130_fd_sc_hd__tapvpwrvgnd_1
XTAP_TAPCELL_ROW_2_174 VGND VPWR sky130_fd_sc_hd__tapvpwrvgnd_1
XPHY_EDGE_ROW_61_Right_61 VGND VGND VPWR VPWR sky130_fd_sc_hd__decap_3
XFILLER_0_37_167 VGND VGND VPWR VPWR sky130_fd_sc_hd__fill_1
XPHY_EDGE_ROW_70_Right_70 VGND VGND VPWR VPWR sky130_fd_sc_hd__decap_3
XFILLER_0_33_373 VGND VGND VPWR VPWR sky130_fd_sc_hd__decap_4
XFILLER_0_45_25 VGND VGND VPWR VPWR sky130_fd_sc_hd__fill_1
X_1942_ reg_file.registers\[10\]\[6\] _0539_ VGND VGND VPWR VPWR _0547_ sky130_fd_sc_hd__and2_1
X_2991_ imem.address\[14\] imem.address\[13\] _1524_ VGND VGND VPWR VPWR _1525_ sky130_fd_sc_hd__and3_1
XFILLER_0_61_57 VGND VGND VPWR VPWR sky130_fd_sc_hd__fill_2
XFILLER_0_0_27 VGND VGND VPWR VPWR sky130_fd_sc_hd__fill_1
XTAP_TAPCELL_ROW_16_287 VGND VPWR sky130_fd_sc_hd__tapvpwrvgnd_1
X_3612_ clknet_leaf_7_clk _0374_ _0185_ VGND VGND VPWR VPWR reg_file.registers\[2\]\[0\]
+ sky130_fd_sc_hd__dfrtp_1
X_1873_ _0510_ VGND VGND VPWR VPWR _0349_ sky130_fd_sc_hd__clkbuf_1
XFILLER_0_24_340 VGND VGND VPWR VPWR sky130_fd_sc_hd__decap_4
XFILLER_0_3_223 VGND VGND VPWR VPWR sky130_fd_sc_hd__fill_1
XFILLER_0_9_69 VPWR VGND VPWR VGND sky130_ef_sc_hd__decap_12
X_3543_ clknet_leaf_18_clk _0305_ _0116_ VGND VGND VPWR VPWR reg_file.registers\[11\]\[27\]
+ sky130_fd_sc_hd__dfrtp_1
X_3474_ clknet_leaf_6_clk _0243_ _0054_ VGND VGND VPWR VPWR imem.address\[29\] sky130_fd_sc_hd__dfrtp_1
X_2425_ _1022_ _0996_ _0975_ VGND VGND VPWR VPWR _1023_ sky130_fd_sc_hd__or3_1
XFILLER_0_10_83 VGND VGND VPWR VPWR sky130_fd_sc_hd__fill_1
X_2356_ _0952_ _0953_ VGND VGND VPWR VPWR _0954_ sky130_fd_sc_hd__nor2_1
XFILLER_0_66_218 VPWR VGND VPWR VGND sky130_ef_sc_hd__decap_12
XTAP_TAPCELL_ROW_67_688 VGND VPWR sky130_fd_sc_hd__tapvpwrvgnd_1
XFILLER_0_35_91 VGND VGND VPWR VPWR sky130_fd_sc_hd__fill_2
X_2287_ reg_file.registers\[15\]\[19\] _0588_ _0590_ reg_file.registers\[5\]\[19\]
+ _0649_ VGND VGND VPWR VPWR _0885_ sky130_fd_sc_hd__a221o_1
XFILLER_0_29_3 VPWR VGND VPWR VGND sky130_ef_sc_hd__decap_12
XFILLER_0_62_413 VGND VGND VPWR VPWR sky130_fd_sc_hd__decap_6
XFILLER_0_59_281 VGND VGND VPWR VPWR sky130_fd_sc_hd__decap_4
XTAP_TAPCELL_ROW_50_555 VGND VPWR sky130_fd_sc_hd__tapvpwrvgnd_1
XFILLER_0_47_443 VGND VGND VPWR VPWR sky130_fd_sc_hd__decap_4
XFILLER_0_19_101 VGND VGND VPWR VPWR sky130_fd_sc_hd__decap_4
XFILLER_0_19_145 VGND VGND VPWR VPWR sky130_fd_sc_hd__decap_3
XFILLER_0_19_167 VGND VGND VPWR VPWR sky130_fd_sc_hd__fill_1
XFILLER_0_30_365 VGND VGND VPWR VPWR sky130_fd_sc_hd__decap_6
XFILLER_0_30_321 VPWR VGND VPWR VGND sky130_ef_sc_hd__decap_12
XTAP_TAPCELL_ROW_7_211 VGND VPWR sky130_fd_sc_hd__tapvpwrvgnd_1
XTAP_TAPCELL_ROW_58_622 VGND VPWR sky130_fd_sc_hd__tapvpwrvgnd_1
XFILLER_0_38_421 VGND VGND VPWR VPWR sky130_fd_sc_hd__fill_2
XTAP_TAPCELL_ROW_13_257 VGND VPWR sky130_fd_sc_hd__tapvpwrvgnd_1
XFILLER_0_21_310 VGND VGND VPWR VPWR sky130_fd_sc_hd__fill_2
X_2210_ _0776_ _0805_ _0806_ VGND VGND VPWR VPWR _0808_ sky130_fd_sc_hd__o21ai_1
XFILLER_0_0_237 VPWR VGND VPWR VGND sky130_ef_sc_hd__decap_12
X_3190_ display.counter\[7\] display.counter\[8\] _1670_ VGND VGND VPWR VPWR _1672_
+ sky130_fd_sc_hd__and3_1
X_2141_ _0728_ _0735_ _0738_ VGND VGND VPWR VPWR _0739_ sky130_fd_sc_hd__o21ai_1
XFILLER_0_48_207 VGND VGND VPWR VPWR sky130_fd_sc_hd__decap_4
XTAP_TAPCELL_ROW_29_390 VGND VPWR sky130_fd_sc_hd__tapvpwrvgnd_1
X_2072_ reg_file.registers\[2\]\[23\] _0558_ VGND VGND VPWR VPWR _0670_ sky130_fd_sc_hd__and2_1
XFILLER_0_71_221 VGND VGND VPWR VPWR sky130_fd_sc_hd__decap_3
XTAP_TAPCELL_ROW_64_669 VGND VPWR sky130_fd_sc_hd__tapvpwrvgnd_1
X_2974_ reg_file.registers\[15\]\[4\] _1483_ VGND VGND VPWR VPWR _1513_ sky130_fd_sc_hd__and2_1
X_1925_ reg_file.registers\[10\]\[14\] _0528_ VGND VGND VPWR VPWR _0538_ sky130_fd_sc_hd__and2_1
XFILLER_0_8_359 VGND VGND VPWR VPWR sky130_fd_sc_hd__fill_2
XFILLER_0_71_265 VPWR VGND VPWR VGND sky130_ef_sc_hd__decap_12
X_1787_ imem.address\[29\] imem.address\[28\] imem.address\[27\] imem.address\[26\]
+ VGND VGND VPWR VPWR _0449_ sky130_fd_sc_hd__or4_4
X_3526_ clknet_leaf_12_clk _0288_ _0099_ VGND VGND VPWR VPWR reg_file.registers\[11\]\[10\]
+ sky130_fd_sc_hd__dfrtp_1
X_1856_ _0501_ VGND VGND VPWR VPWR _0357_ sky130_fd_sc_hd__clkbuf_1
XFILLER_0_24_192 VGND VGND VPWR VPWR sky130_fd_sc_hd__decap_4
XFILLER_0_24_181 VGND VGND VPWR VPWR sky130_fd_sc_hd__decap_4
XFILLER_0_16_159 VGND VGND VPWR VPWR sky130_fd_sc_hd__fill_1
X_3457_ clknet_leaf_7_clk _0226_ _0037_ VGND VGND VPWR VPWR imem.address\[12\] sky130_fd_sc_hd__dfrtp_1
X_3388_ _1712_ VGND VGND VPWR VPWR _0171_ sky130_fd_sc_hd__inv_2
X_2408_ _1005_ VGND VGND VPWR VPWR _1006_ sky130_fd_sc_hd__inv_2
XPHY_EDGE_ROW_2_Right_2 VGND VGND VPWR VPWR sky130_fd_sc_hd__decap_3
X_2339_ _0587_ _0677_ _0584_ _0580_ VGND VGND VPWR VPWR _0937_ sky130_fd_sc_hd__o2bb2a_4
XFILLER_0_39_229 VGND VGND VPWR VPWR sky130_fd_sc_hd__fill_1
XFILLER_0_39_218 VGND VGND VPWR VPWR sky130_fd_sc_hd__decap_3
XFILLER_0_1_81 VPWR VGND VPWR VGND sky130_ef_sc_hd__decap_12
XPHY_EDGE_ROW_33_Left_105 VGND VGND VPWR VPWR sky130_fd_sc_hd__decap_3
XTAP_TAPCELL_ROW_10_238 VGND VPWR sky130_fd_sc_hd__tapvpwrvgnd_1
XFILLER_0_15_181 VPWR VGND VPWR VGND sky130_ef_sc_hd__decap_12
XPHY_EDGE_ROW_42_Left_114 VGND VGND VPWR VPWR sky130_fd_sc_hd__decap_3
XFILLER_0_26_27 VGND VGND VPWR VPWR sky130_fd_sc_hd__fill_1
XPHY_EDGE_ROW_51_Left_123 VGND VGND VPWR VPWR sky130_fd_sc_hd__decap_3
XFILLER_0_42_26 VGND VGND VPWR VPWR sky130_fd_sc_hd__fill_2
XFILLER_0_26_446 VGND VGND VPWR VPWR sky130_fd_sc_hd__fill_2
XFILLER_0_26_402 VGND VGND VPWR VPWR sky130_fd_sc_hd__fill_1
XTAP_TAPCELL_ROW_26_360 VGND VPWR sky130_fd_sc_hd__tapvpwrvgnd_1
XFILLER_0_5_329 VGND VGND VPWR VPWR sky130_fd_sc_hd__decap_6
XFILLER_0_53_265 VPWR VGND VPWR VGND sky130_ef_sc_hd__decap_12
X_3311_ _1703_ VGND VGND VPWR VPWR _0103_ sky130_fd_sc_hd__inv_2
X_2690_ _0848_ _0795_ _0994_ VGND VGND VPWR VPWR _1283_ sky130_fd_sc_hd__mux2_1
XFILLER_0_41_449 VGND VGND VPWR VPWR sky130_fd_sc_hd__fill_2
XFILLER_0_6_15 VPWR VGND VPWR VGND sky130_ef_sc_hd__decap_12
XTAP_TAPCELL_ROW_69_706 VGND VPWR sky130_fd_sc_hd__tapvpwrvgnd_1
X_3242_ _1694_ VGND VGND VPWR VPWR _0043_ sky130_fd_sc_hd__inv_2
X_2124_ _0719_ _0721_ VGND VGND VPWR VPWR _0722_ sky130_fd_sc_hd__xnor2_1
XPHY_EDGE_ROW_60_Left_132 VGND VGND VPWR VPWR sky130_fd_sc_hd__decap_3
X_3173_ _1648_ _1646_ _1663_ _1662_ VGND VGND VPWR VPWR _0006_ sky130_fd_sc_hd__a22o_1
Xrebuffer37 _0556_ VGND VGND VPWR VPWR net53 sky130_fd_sc_hd__dlygate4sd1_1
Xrebuffer26 _0614_ VGND VGND VPWR VPWR net42 sky130_fd_sc_hd__dlygate4sd1_1
X_2055_ reg_file.registers\[2\]\[17\] _0557_ VGND VGND VPWR VPWR _0653_ sky130_fd_sc_hd__and2_1
Xrebuffer15 _0895_ VGND VGND VPWR VPWR net31 sky130_fd_sc_hd__dlygate4sd1_1
X_2888_ _1459_ reg_file.registers\[11\]\[5\] _1207_ VGND VGND VPWR VPWR _1460_ sky130_fd_sc_hd__mux2_1
XFILLER_0_44_298 VGND VGND VPWR VPWR sky130_fd_sc_hd__decap_4
X_2957_ _1504_ VGND VGND VPWR VPWR _0259_ sky130_fd_sc_hd__clkbuf_1
XFILLER_0_32_427 VGND VGND VPWR VPWR sky130_fd_sc_hd__fill_1
XFILLER_0_32_405 VGND VGND VPWR VPWR sky130_fd_sc_hd__fill_2
X_1839_ _0492_ VGND VGND VPWR VPWR _0365_ sky130_fd_sc_hd__clkbuf_1
XFILLER_0_8_189 VGND VGND VPWR VPWR sky130_fd_sc_hd__decap_6
X_1908_ _0529_ VGND VGND VPWR VPWR _0333_ sky130_fd_sc_hd__clkbuf_1
XFILLER_0_12_195 VGND VGND VPWR VPWR sky130_fd_sc_hd__fill_1
X_3509_ clknet_leaf_21_clk _0271_ _0082_ VGND VGND VPWR VPWR reg_file.registers\[15\]\[25\]
+ sky130_fd_sc_hd__dfrtp_1
XFILLER_0_67_335 VGND VGND VPWR VPWR sky130_fd_sc_hd__fill_1
XTAP_TAPCELL_ROW_23_341 VGND VPWR sky130_fd_sc_hd__tapvpwrvgnd_1
XFILLER_0_12_29 VPWR VGND VPWR VGND sky130_ef_sc_hd__decap_12
Xoutput5 net5 VGND VGND VPWR VPWR an[3] sky130_fd_sc_hd__buf_1
XFILLER_0_50_279 VPWR VGND VPWR VGND sky130_ef_sc_hd__decap_12
XFILLER_0_50_202 VPWR VGND VPWR VGND sky130_ef_sc_hd__decap_12
XFILLER_0_23_449 VGND VGND VPWR VPWR sky130_fd_sc_hd__fill_2
XFILLER_0_37_26 VGND VGND VPWR VPWR sky130_fd_sc_hd__fill_1
XFILLER_0_37_15 VGND VGND VPWR VPWR sky130_fd_sc_hd__decap_3
XFILLER_0_58_357 VGND VGND VPWR VPWR sky130_fd_sc_hd__decap_6
X_2742_ _1244_ VGND VGND VPWR VPWR _1332_ sky130_fd_sc_hd__clkbuf_4
X_2811_ net36 _1074_ VGND VGND VPWR VPWR _1394_ sky130_fd_sc_hd__or2_1
XFILLER_0_5_137 VPWR VGND VPWR VGND sky130_ef_sc_hd__decap_12
X_2673_ _0594_ _1265_ VGND VGND VPWR VPWR _1266_ sky130_fd_sc_hd__nor2_1
X_3225_ _1693_ VGND VGND VPWR VPWR _0027_ sky130_fd_sc_hd__inv_2
X_2107_ _0704_ _0620_ VGND VGND VPWR VPWR _0705_ sky130_fd_sc_hd__or2_1
X_3087_ _1587_ VGND VGND VPWR VPWR _0409_ sky130_fd_sc_hd__buf_1
X_3156_ _1647_ _1608_ _1650_ _1652_ VGND VGND VPWR VPWR _0000_ sky130_fd_sc_hd__a211o_1
Xclkbuf_leaf_19_clk clknet_1_1__leaf_clk VGND VGND VPWR VPWR clknet_leaf_19_clk sky130_fd_sc_hd__clkbuf_8
XFILLER_0_57_390 VGND VGND VPWR VPWR sky130_fd_sc_hd__fill_2
XFILLER_0_49_335 VGND VGND VPWR VPWR sky130_fd_sc_hd__fill_1
X_2038_ reg_file.registers\[2\]\[12\] _0557_ VGND VGND VPWR VPWR _0636_ sky130_fd_sc_hd__and2_1
XTAP_TAPCELL_ROW_37_455 VGND VPWR sky130_fd_sc_hd__tapvpwrvgnd_1
XFILLER_0_11_3 VPWR VGND VPWR VGND sky130_ef_sc_hd__decap_12
XFILLER_0_32_235 VPWR VGND VPWR VGND sky130_ef_sc_hd__decap_12
XFILLER_0_20_419 VGND VGND VPWR VPWR sky130_fd_sc_hd__fill_1
XTAP_TAPCELL_ROW_71_734 VGND VPWR sky130_fd_sc_hd__tapvpwrvgnd_1
XTAP_TAPCELL_ROW_71_723 VGND VPWR sky130_fd_sc_hd__tapvpwrvgnd_1
XFILLER_0_63_382 VGND VGND VPWR VPWR sky130_fd_sc_hd__fill_1
XFILLER_0_55_327 VGND VGND VPWR VPWR sky130_fd_sc_hd__decap_8
Xrebuffer6 net20 VGND VGND VPWR VPWR net22 sky130_fd_sc_hd__dlygate4sd1_1
XFILLER_0_23_279 VGND VGND VPWR VPWR sky130_fd_sc_hd__fill_1
X_3010_ imem.address\[27\] _1533_ VGND VGND VPWR VPWR _1540_ sky130_fd_sc_hd__nor2_1
XFILLER_0_48_69 VPWR VGND VPWR VGND sky130_ef_sc_hd__decap_12
XFILLER_0_3_27 VPWR VGND VPWR VGND sky130_ef_sc_hd__decap_12
XTAP_TAPCELL_ROW_34_425 VGND VPWR sky130_fd_sc_hd__tapvpwrvgnd_1
Xclkbuf_leaf_8_clk clknet_1_0__leaf_clk VGND VGND VPWR VPWR clknet_leaf_8_clk sky130_fd_sc_hd__clkbuf_8
XFILLER_0_54_382 VGND VGND VPWR VPWR sky130_fd_sc_hd__decap_4
XFILLER_0_54_360 VGND VGND VPWR VPWR sky130_fd_sc_hd__decap_4
XTAP_TAPCELL_ROW_42_491 VGND VPWR sky130_fd_sc_hd__tapvpwrvgnd_1
X_2725_ _0935_ net33 _0932_ VGND VGND VPWR VPWR _1316_ sky130_fd_sc_hd__and3_1
XFILLER_0_13_94 VGND VGND VPWR VPWR sky130_fd_sc_hd__fill_1
X_2656_ _1065_ _1237_ _1238_ _1249_ VGND VGND VPWR VPWR _1250_ sky130_fd_sc_hd__a31o_1
XFILLER_0_59_3 VGND VGND VPWR VPWR sky130_fd_sc_hd__fill_1
X_2587_ _1178_ _1182_ _1013_ VGND VGND VPWR VPWR _1183_ sky130_fd_sc_hd__mux2_1
XFILLER_0_49_110 VGND VGND VPWR VPWR sky130_fd_sc_hd__fill_2
X_3139_ _0477_ _0412_ VGND VGND VPWR VPWR _1636_ sky130_fd_sc_hd__nor2_1
X_3208_ display.counter\[15\] _1680_ VGND VGND VPWR VPWR _1683_ sky130_fd_sc_hd__nor2_1
XFILLER_0_49_143 VPWR VGND VPWR VGND sky130_ef_sc_hd__decap_12
XFILLER_0_37_316 VPWR VGND VPWR VGND sky130_ef_sc_hd__decap_12
XFILLER_0_9_273 VGND VGND VPWR VPWR sky130_fd_sc_hd__decap_6
XFILLER_0_45_393 VGND VGND VPWR VPWR sky130_fd_sc_hd__fill_2
XFILLER_0_20_205 VGND VGND VPWR VPWR sky130_fd_sc_hd__fill_2
XTAP_TAPCELL_ROW_48_539 VGND VPWR sky130_fd_sc_hd__tapvpwrvgnd_1
XTAP_TAPCELL_ROW_5_194 VGND VPWR sky130_fd_sc_hd__tapvpwrvgnd_1
XFILLER_0_0_3 VPWR VGND VPWR VGND sky130_ef_sc_hd__decap_12
XFILLER_0_55_113 VGND VGND VPWR VPWR sky130_fd_sc_hd__fill_1
XFILLER_0_50_15 VGND VGND VPWR VPWR sky130_fd_sc_hd__decap_4
XTAP_TAPCELL_ROW_31_406 VGND VPWR sky130_fd_sc_hd__tapvpwrvgnd_1
XFILLER_0_28_349 VPWR VGND VPWR VGND sky130_ef_sc_hd__decap_12
XFILLER_0_70_105 VGND VGND VPWR VPWR sky130_fd_sc_hd__decap_8
X_3490_ clknet_leaf_5_clk _0252_ _0063_ VGND VGND VPWR VPWR reg_file.registers\[15\]\[6\]
+ sky130_fd_sc_hd__dfrtp_1
XFILLER_0_51_374 VPWR VGND VPWR VGND sky130_ef_sc_hd__decap_12
X_2510_ _0741_ VGND VGND VPWR VPWR _1107_ sky130_fd_sc_hd__buf_2
XFILLER_0_36_393 VGND VGND VPWR VPWR sky130_fd_sc_hd__decap_6
XFILLER_0_3_449 VGND VGND VPWR VPWR sky130_fd_sc_hd__fill_2
XFILLER_0_3_405 VPWR VGND VPWR VGND sky130_ef_sc_hd__decap_12
XFILLER_0_11_205 VPWR VGND VPWR VGND sky130_ef_sc_hd__decap_12
XFILLER_0_59_57 VGND VGND VPWR VPWR sky130_fd_sc_hd__decap_8
X_2441_ _1037_ _1038_ _1003_ VGND VGND VPWR VPWR _1039_ sky130_fd_sc_hd__mux2_1
XFILLER_0_11_249 VPWR VGND VPWR VGND sky130_ef_sc_hd__decap_12
X_2372_ _0968_ _0969_ VGND VGND VPWR VPWR _0970_ sky130_fd_sc_hd__or2_1
XFILLER_0_6_221 VPWR VGND VPWR VGND sky130_ef_sc_hd__decap_12
XFILLER_0_19_327 VGND VGND VPWR VPWR sky130_fd_sc_hd__decap_8
XFILLER_0_42_385 VGND VGND VPWR VPWR sky130_fd_sc_hd__fill_1
XFILLER_0_42_352 VPWR VGND VPWR VGND sky130_ef_sc_hd__decap_12
X_2708_ _1299_ VGND VGND VPWR VPWR _1300_ sky130_fd_sc_hd__inv_2
XFILLER_0_6_265 VPWR VGND VPWR VGND sky130_ef_sc_hd__decap_12
X_2639_ reg_file.registers\[11\]\[28\] _1233_ _1059_ VGND VGND VPWR VPWR _1234_ sky130_fd_sc_hd__mux2_1
XTAP_TAPCELL_ROW_2_175 VGND VPWR sky130_fd_sc_hd__tapvpwrvgnd_1
XFILLER_0_52_138 VGND VGND VPWR VPWR sky130_fd_sc_hd__fill_2
XFILLER_0_20_29 VGND VGND VPWR VPWR sky130_fd_sc_hd__decap_8
XFILLER_0_45_15 VGND VGND VPWR VPWR sky130_fd_sc_hd__decap_3
X_1941_ _0546_ VGND VGND VPWR VPWR _0317_ sky130_fd_sc_hd__clkbuf_1
X_2990_ imem.address\[12\] _1523_ VGND VGND VPWR VPWR _1524_ sky130_fd_sc_hd__and2_1
XFILLER_0_61_36 VPWR VGND VPWR VGND sky130_ef_sc_hd__decap_12
X_1872_ reg_file.registers\[5\]\[7\] _0504_ VGND VGND VPWR VPWR _0510_ sky130_fd_sc_hd__and2_1
XFILLER_0_28_168 VGND VGND VPWR VPWR sky130_fd_sc_hd__decap_8
XFILLER_0_9_15 VPWR VGND VPWR VGND sky130_ef_sc_hd__decap_12
X_3473_ clknet_leaf_6_clk _0242_ _0053_ VGND VGND VPWR VPWR imem.address\[28\] sky130_fd_sc_hd__dfrtp_1
XFILLER_0_51_182 VPWR VGND VPWR VGND sky130_ef_sc_hd__decap_12
X_3611_ clknet_leaf_1_clk _0373_ _0184_ VGND VGND VPWR VPWR reg_file.registers\[5\]\[31\]
+ sky130_fd_sc_hd__dfrtp_1
XFILLER_0_3_279 VGND VGND VPWR VPWR sky130_fd_sc_hd__fill_1
X_3542_ clknet_leaf_16_clk _0304_ _0115_ VGND VGND VPWR VPWR reg_file.registers\[11\]\[26\]
+ sky130_fd_sc_hd__dfrtp_2
X_2286_ _0648_ _0642_ _0656_ VGND VGND VPWR VPWR _0884_ sky130_fd_sc_hd__or3b_4
X_2424_ _1004_ VGND VGND VPWR VPWR _1022_ sky130_fd_sc_hd__buf_2
X_2355_ _0950_ _0951_ VGND VGND VPWR VPWR _0953_ sky130_fd_sc_hd__nor2_1
XTAP_TAPCELL_ROW_67_689 VGND VPWR sky130_fd_sc_hd__tapvpwrvgnd_1
XFILLER_0_59_271 VGND VGND VPWR VPWR sky130_fd_sc_hd__fill_2
XFILLER_0_51_91 VGND VGND VPWR VPWR sky130_fd_sc_hd__decap_4
XTAP_TAPCELL_ROW_50_556 VGND VPWR sky130_fd_sc_hd__tapvpwrvgnd_1
XFILLER_0_30_333 VGND VGND VPWR VPWR sky130_fd_sc_hd__decap_4
XTAP_TAPCELL_ROW_7_212 VGND VPWR sky130_fd_sc_hd__tapvpwrvgnd_1
XFILLER_0_15_396 VGND VGND VPWR VPWR sky130_fd_sc_hd__fill_2
XTAP_TAPCELL_ROW_58_623 VGND VPWR sky130_fd_sc_hd__tapvpwrvgnd_1
XFILLER_0_53_447 VGND VGND VPWR VPWR sky130_fd_sc_hd__fill_1
XFILLER_0_25_138 VGND VGND VPWR VPWR sky130_fd_sc_hd__decap_4
XTAP_TAPCELL_ROW_13_258 VGND VPWR sky130_fd_sc_hd__tapvpwrvgnd_1
X_2140_ _0724_ _0737_ VGND VGND VPWR VPWR _0738_ sky130_fd_sc_hd__or2_1
XFILLER_0_0_249 VGND VGND VPWR VPWR sky130_fd_sc_hd__decap_3
XFILLER_0_21_388 VGND VGND VPWR VPWR sky130_fd_sc_hd__decap_4
XFILLER_0_21_399 VGND VGND VPWR VPWR sky130_fd_sc_hd__fill_1
XTAP_TAPCELL_ROW_29_391 VGND VPWR sky130_fd_sc_hd__tapvpwrvgnd_1
X_2071_ _0668_ VGND VGND VPWR VPWR _0669_ sky130_fd_sc_hd__inv_2
XFILLER_0_71_277 VGND VGND VPWR VPWR sky130_fd_sc_hd__decap_3
X_2973_ _1512_ VGND VGND VPWR VPWR _0251_ sky130_fd_sc_hd__clkbuf_1
X_1924_ _0537_ VGND VGND VPWR VPWR _0325_ sky130_fd_sc_hd__clkbuf_1
X_1855_ reg_file.registers\[5\]\[15\] _0493_ VGND VGND VPWR VPWR _0501_ sky130_fd_sc_hd__and2_1
X_3456_ clknet_leaf_8_clk _0225_ _0036_ VGND VGND VPWR VPWR imem.address\[11\] sky130_fd_sc_hd__dfrtp_1
X_1786_ imem.address\[25\] imem.address\[24\] imem.address\[23\] imem.address\[22\]
+ VGND VGND VPWR VPWR _0448_ sky130_fd_sc_hd__or4_4
X_3525_ clknet_leaf_11_clk _0287_ _0098_ VGND VGND VPWR VPWR reg_file.registers\[11\]\[9\]
+ sky130_fd_sc_hd__dfrtp_1
XFILLER_0_46_80 VGND VGND VPWR VPWR sky130_fd_sc_hd__decap_4
XFILLER_0_41_3 VGND VGND VPWR VPWR sky130_fd_sc_hd__decap_8
X_3387_ _1712_ VGND VGND VPWR VPWR _0170_ sky130_fd_sc_hd__inv_2
X_2407_ _0997_ _1001_ _1004_ VGND VGND VPWR VPWR _1005_ sky130_fd_sc_hd__mux2_1
X_2338_ _0912_ _0932_ _0935_ VGND VGND VPWR VPWR _0936_ sky130_fd_sc_hd__a21oi_4
X_2269_ _0866_ _0865_ VGND VGND VPWR VPWR _0867_ sky130_fd_sc_hd__nor2_2
XFILLER_0_1_93 VPWR VGND VPWR VGND sky130_ef_sc_hd__decap_12
XFILLER_0_50_406 VGND VGND VPWR VPWR sky130_fd_sc_hd__decap_3
XFILLER_0_35_436 VPWR VGND VPWR VGND sky130_ef_sc_hd__decap_12
XFILLER_0_7_393 VGND VGND VPWR VPWR sky130_fd_sc_hd__decap_6
XTAP_TAPCELL_ROW_10_239 VGND VPWR sky130_fd_sc_hd__tapvpwrvgnd_1
XFILLER_0_15_193 VPWR VGND VPWR VGND sky130_ef_sc_hd__decap_12
XFILLER_0_30_141 VGND VGND VPWR VPWR sky130_fd_sc_hd__decap_6
XFILLER_0_53_222 VGND VGND VPWR VPWR sky130_fd_sc_hd__fill_2
XTAP_TAPCELL_ROW_26_361 VGND VPWR sky130_fd_sc_hd__tapvpwrvgnd_1
XFILLER_0_53_277 VGND VGND VPWR VPWR sky130_fd_sc_hd__decap_3
X_3310_ _1703_ VGND VGND VPWR VPWR _0102_ sky130_fd_sc_hd__inv_2
XFILLER_0_6_27 VGND VGND VPWR VPWR sky130_fd_sc_hd__fill_1
XTAP_TAPCELL_ROW_69_707 VGND VPWR sky130_fd_sc_hd__tapvpwrvgnd_1
X_3241_ _1694_ VGND VGND VPWR VPWR _0042_ sky130_fd_sc_hd__inv_2
X_2123_ _0720_ VGND VGND VPWR VPWR _0721_ sky130_fd_sc_hd__inv_2
Xrebuffer27 _0857_ VGND VGND VPWR VPWR net43 sky130_fd_sc_hd__dlymetal6s4s_1
Xrebuffer16 _0962_ VGND VGND VPWR VPWR net32 sky130_fd_sc_hd__clkbuf_1
X_3172_ _1616_ _1634_ VGND VGND VPWR VPWR _1663_ sky130_fd_sc_hd__nand2_1
Xrebuffer38 _0604_ VGND VGND VPWR VPWR net54 sky130_fd_sc_hd__dlygate4sd1_1
X_2054_ reg_file.registers\[5\]\[16\] _0563_ _0567_ reg_file.registers\[15\]\[16\]
+ _0651_ VGND VGND VPWR VPWR _0652_ sky130_fd_sc_hd__a221o_1
X_2887_ _1107_ _1200_ _1183_ _1457_ _1458_ VGND VGND VPWR VPWR _1459_ sky130_fd_sc_hd__a32o_1
X_2956_ reg_file.registers\[15\]\[13\] _1495_ VGND VGND VPWR VPWR _1504_ sky130_fd_sc_hd__and2_1
X_1838_ reg_file.registers\[5\]\[23\] _0483_ VGND VGND VPWR VPWR _0492_ sky130_fd_sc_hd__and2_1
XFILLER_0_4_363 VGND VGND VPWR VPWR sky130_fd_sc_hd__fill_1
X_1907_ reg_file.registers\[10\]\[23\] _0528_ VGND VGND VPWR VPWR _0529_ sky130_fd_sc_hd__and2_1
XFILLER_0_17_447 VGND VGND VPWR VPWR sky130_fd_sc_hd__fill_1
X_1769_ reg_file.registers\[2\]\[8\] VGND VGND VPWR VPWR _0439_ sky130_fd_sc_hd__clkbuf_1
X_3439_ _1719_ VGND VGND VPWR VPWR _0215_ sky130_fd_sc_hd__inv_2
XFILLER_0_12_141 VPWR VGND VPWR VGND sky130_ef_sc_hd__decap_12
X_3508_ clknet_leaf_21_clk _0270_ _0081_ VGND VGND VPWR VPWR reg_file.registers\[15\]\[24\]
+ sky130_fd_sc_hd__dfrtp_1
XTAP_TAPCELL_ROW_23_342 VGND VPWR sky130_fd_sc_hd__tapvpwrvgnd_1
Xoutput6 net6 VGND VGND VPWR VPWR an[4] sky130_fd_sc_hd__buf_1
XFILLER_0_50_214 VPWR VGND VPWR VGND sky130_ef_sc_hd__decap_12
XFILLER_0_53_26 VPWR VGND VPWR VGND sky130_ef_sc_hd__decap_12
XFILLER_0_53_15 VGND VGND VPWR VPWR sky130_fd_sc_hd__decap_8
X_2672_ _1260_ _1264_ _1013_ VGND VGND VPWR VPWR _1265_ sky130_fd_sc_hd__mux2_1
X_2741_ _0680_ _0741_ _1054_ VGND VGND VPWR VPWR _1331_ sky130_fd_sc_hd__and3_1
XFILLER_0_41_225 VPWR VGND VPWR VGND sky130_ef_sc_hd__decap_12
XFILLER_0_41_214 VGND VGND VPWR VPWR sky130_fd_sc_hd__decap_8
X_2810_ _0857_ _0910_ VGND VGND VPWR VPWR _1393_ sky130_fd_sc_hd__nand2_1
XFILLER_0_26_299 VGND VGND VPWR VPWR sky130_fd_sc_hd__fill_1
XFILLER_0_26_222 VGND VGND VPWR VPWR sky130_fd_sc_hd__decap_3
XFILLER_0_26_211 VGND VGND VPWR VPWR sky130_fd_sc_hd__decap_4
XFILLER_0_5_149 VPWR VGND VPWR VGND sky130_ef_sc_hd__decap_12
XFILLER_0_5_105 VGND VGND VPWR VPWR sky130_fd_sc_hd__decap_6
XFILLER_0_14_417 VGND VGND VPWR VPWR sky130_fd_sc_hd__decap_3
X_3224_ _1692_ VGND VGND VPWR VPWR _1693_ sky130_fd_sc_hd__buf_4
XFILLER_0_22_450 VGND VGND VPWR VPWR sky130_fd_sc_hd__fill_1
.ends
