* NGSPICE file created from RegFileALU.ext - technology: sky130A

* Black-box entry subcircuit for sky130_fd_sc_hd__fill_2 abstract view
.subckt sky130_fd_sc_hd__fill_2 VGND VNB VPB VPWR
.ends

* Black-box entry subcircuit for sky130_fd_sc_hd__mux2_1 abstract view
.subckt sky130_fd_sc_hd__mux2_1 A0 A1 S VGND VNB VPB VPWR X
.ends

* Black-box entry subcircuit for sky130_fd_sc_hd__diode_2 abstract view
.subckt sky130_fd_sc_hd__diode_2 DIODE VGND VNB VPB VPWR
.ends

* Black-box entry subcircuit for sky130_fd_sc_hd__clkbuf_1 abstract view
.subckt sky130_fd_sc_hd__clkbuf_1 A VGND VNB VPB VPWR X
.ends

* Black-box entry subcircuit for sky130_fd_sc_hd__tapvpwrvgnd_1 abstract view
.subckt sky130_fd_sc_hd__tapvpwrvgnd_1 VGND VPWR
.ends

* Black-box entry subcircuit for sky130_fd_sc_hd__decap_3 abstract view
.subckt sky130_fd_sc_hd__decap_3 VGND VNB VPB VPWR
.ends

* Black-box entry subcircuit for sky130_fd_sc_hd__dfxtp_1 abstract view
.subckt sky130_fd_sc_hd__dfxtp_1 CLK D VGND VNB VPB VPWR Q
.ends

* Black-box entry subcircuit for sky130_fd_sc_hd__a21oi_1 abstract view
.subckt sky130_fd_sc_hd__a21oi_1 A1 A2 B1 VGND VNB VPB VPWR Y
.ends

* Black-box entry subcircuit for sky130_fd_sc_hd__decap_4 abstract view
.subckt sky130_fd_sc_hd__decap_4 VGND VNB VPB VPWR
.ends

* Black-box entry subcircuit for sky130_fd_sc_hd__fill_1 abstract view
.subckt sky130_fd_sc_hd__fill_1 VGND VNB VPB VPWR
.ends

* Black-box entry subcircuit for sky130_fd_sc_hd__and3_1 abstract view
.subckt sky130_fd_sc_hd__and3_1 A B C VGND VNB VPB VPWR X
.ends

* Black-box entry subcircuit for sky130_fd_sc_hd__nor2_1 abstract view
.subckt sky130_fd_sc_hd__nor2_1 A B VGND VNB VPB VPWR Y
.ends

* Black-box entry subcircuit for sky130_fd_sc_hd__clkbuf_4 abstract view
.subckt sky130_fd_sc_hd__clkbuf_4 A VGND VNB VPB VPWR X
.ends

* Black-box entry subcircuit for sky130_ef_sc_hd__decap_12 abstract view
.subckt sky130_ef_sc_hd__decap_12 VPWR VGND VPB VNB
.ends

* Black-box entry subcircuit for sky130_fd_sc_hd__decap_6 abstract view
.subckt sky130_fd_sc_hd__decap_6 VGND VNB VPB VPWR
.ends

* Black-box entry subcircuit for sky130_fd_sc_hd__nand2_1 abstract view
.subckt sky130_fd_sc_hd__nand2_1 A B VGND VNB VPB VPWR Y
.ends

* Black-box entry subcircuit for sky130_fd_sc_hd__o221a_1 abstract view
.subckt sky130_fd_sc_hd__o221a_1 A1 A2 B1 B2 C1 VGND VNB VPB VPWR X
.ends

* Black-box entry subcircuit for sky130_fd_sc_hd__buf_2 abstract view
.subckt sky130_fd_sc_hd__buf_2 A VGND VNB VPB VPWR X
.ends

* Black-box entry subcircuit for sky130_fd_sc_hd__mux4_1 abstract view
.subckt sky130_fd_sc_hd__mux4_1 A0 A1 A2 A3 S0 S1 VGND VNB VPB VPWR X
.ends

* Black-box entry subcircuit for sky130_fd_sc_hd__clkbuf_8 abstract view
.subckt sky130_fd_sc_hd__clkbuf_8 A VGND VNB VPB VPWR X
.ends

* Black-box entry subcircuit for sky130_fd_sc_hd__decap_8 abstract view
.subckt sky130_fd_sc_hd__decap_8 VGND VNB VPB VPWR
.ends

* Black-box entry subcircuit for sky130_fd_sc_hd__and2b_1 abstract view
.subckt sky130_fd_sc_hd__and2b_1 A_N B VGND VNB VPB VPWR X
.ends

* Black-box entry subcircuit for sky130_fd_sc_hd__clkbuf_2 abstract view
.subckt sky130_fd_sc_hd__clkbuf_2 A VGND VNB VPB VPWR X
.ends

* Black-box entry subcircuit for sky130_fd_sc_hd__a221o_1 abstract view
.subckt sky130_fd_sc_hd__a221o_1 A1 A2 B1 B2 C1 VGND VNB VPB VPWR X
.ends

* Black-box entry subcircuit for sky130_fd_sc_hd__inv_2 abstract view
.subckt sky130_fd_sc_hd__inv_2 A VGND VNB VPB VPWR Y
.ends

* Black-box entry subcircuit for sky130_fd_sc_hd__buf_4 abstract view
.subckt sky130_fd_sc_hd__buf_4 A VGND VNB VPB VPWR X
.ends

* Black-box entry subcircuit for sky130_fd_sc_hd__a21o_1 abstract view
.subckt sky130_fd_sc_hd__a21o_1 A1 A2 B1 VGND VNB VPB VPWR X
.ends

* Black-box entry subcircuit for sky130_fd_sc_hd__and2_1 abstract view
.subckt sky130_fd_sc_hd__and2_1 A B VGND VNB VPB VPWR X
.ends

* Black-box entry subcircuit for sky130_fd_sc_hd__or3b_4 abstract view
.subckt sky130_fd_sc_hd__or3b_4 A B C_N VGND VNB VPB VPWR X
.ends

* Black-box entry subcircuit for sky130_fd_sc_hd__inv_6 abstract view
.subckt sky130_fd_sc_hd__inv_6 A VGND VNB VPB VPWR Y
.ends

* Black-box entry subcircuit for sky130_fd_sc_hd__xnor2_2 abstract view
.subckt sky130_fd_sc_hd__xnor2_2 A B VGND VNB VPB VPWR Y
.ends

* Black-box entry subcircuit for sky130_fd_sc_hd__o22a_2 abstract view
.subckt sky130_fd_sc_hd__o22a_2 A1 A2 B1 B2 VGND VNB VPB VPWR X
.ends

* Black-box entry subcircuit for sky130_fd_sc_hd__xnor2_1 abstract view
.subckt sky130_fd_sc_hd__xnor2_1 A B VGND VNB VPB VPWR Y
.ends

* Black-box entry subcircuit for sky130_fd_sc_hd__o221ai_1 abstract view
.subckt sky130_fd_sc_hd__o221ai_1 A1 A2 B1 B2 C1 VGND VNB VPB VPWR Y
.ends

* Black-box entry subcircuit for sky130_fd_sc_hd__o21ai_1 abstract view
.subckt sky130_fd_sc_hd__o21ai_1 A1 A2 B1 VGND VNB VPB VPWR Y
.ends

* Black-box entry subcircuit for sky130_fd_sc_hd__a41o_1 abstract view
.subckt sky130_fd_sc_hd__a41o_1 A1 A2 A3 A4 B1 VGND VNB VPB VPWR X
.ends

* Black-box entry subcircuit for sky130_fd_sc_hd__a211o_1 abstract view
.subckt sky130_fd_sc_hd__a211o_1 A1 A2 B1 C1 VGND VNB VPB VPWR X
.ends

* Black-box entry subcircuit for sky130_fd_sc_hd__buf_1 abstract view
.subckt sky130_fd_sc_hd__buf_1 A VGND VNB VPB VPWR X
.ends

* Black-box entry subcircuit for sky130_fd_sc_hd__or2_1 abstract view
.subckt sky130_fd_sc_hd__or2_1 A B VGND VNB VPB VPWR X
.ends

* Black-box entry subcircuit for sky130_fd_sc_hd__o21a_1 abstract view
.subckt sky130_fd_sc_hd__o21a_1 A1 A2 B1 VGND VNB VPB VPWR X
.ends

* Black-box entry subcircuit for sky130_fd_sc_hd__a2bb2o_4 abstract view
.subckt sky130_fd_sc_hd__a2bb2o_4 A1_N A2_N B1 B2 VGND VNB VPB VPWR X
.ends

* Black-box entry subcircuit for sky130_fd_sc_hd__buf_6 abstract view
.subckt sky130_fd_sc_hd__buf_6 A VGND VNB VPB VPWR X
.ends

* Black-box entry subcircuit for sky130_fd_sc_hd__clkinv_4 abstract view
.subckt sky130_fd_sc_hd__clkinv_4 A VGND VNB VPB VPWR Y
.ends

* Black-box entry subcircuit for sky130_fd_sc_hd__clkinv_1 abstract view
.subckt sky130_fd_sc_hd__clkinv_1 A VGND VNB VPB VPWR Y
.ends

* Black-box entry subcircuit for sky130_fd_sc_hd__o21bai_1 abstract view
.subckt sky130_fd_sc_hd__o21bai_1 A1 A2 B1_N VGND VNB VPB VPWR Y
.ends

* Black-box entry subcircuit for sky130_fd_sc_hd__o2bb2a_1 abstract view
.subckt sky130_fd_sc_hd__o2bb2a_1 A1_N A2_N B1 B2 VGND VNB VPB VPWR X
.ends

* Black-box entry subcircuit for sky130_fd_sc_hd__or3_1 abstract view
.subckt sky130_fd_sc_hd__or3_1 A B C VGND VNB VPB VPWR X
.ends

* Black-box entry subcircuit for sky130_fd_sc_hd__o211a_1 abstract view
.subckt sky130_fd_sc_hd__o211a_1 A1 A2 B1 C1 VGND VNB VPB VPWR X
.ends

* Black-box entry subcircuit for sky130_fd_sc_hd__a22o_1 abstract view
.subckt sky130_fd_sc_hd__a22o_1 A1 A2 B1 B2 VGND VNB VPB VPWR X
.ends

* Black-box entry subcircuit for sky130_fd_sc_hd__o21ai_4 abstract view
.subckt sky130_fd_sc_hd__o21ai_4 A1 A2 B1 VGND VNB VPB VPWR Y
.ends

* Black-box entry subcircuit for sky130_fd_sc_hd__o21ai_2 abstract view
.subckt sky130_fd_sc_hd__o21ai_2 A1 A2 B1 VGND VNB VPB VPWR Y
.ends

* Black-box entry subcircuit for sky130_fd_sc_hd__and2_2 abstract view
.subckt sky130_fd_sc_hd__and2_2 A B VGND VNB VPB VPWR X
.ends

* Black-box entry subcircuit for sky130_fd_sc_hd__nand2_4 abstract view
.subckt sky130_fd_sc_hd__nand2_4 A B VGND VNB VPB VPWR Y
.ends

* Black-box entry subcircuit for sky130_fd_sc_hd__clkinvlp_2 abstract view
.subckt sky130_fd_sc_hd__clkinvlp_2 A VGND VNB VPB VPWR Y
.ends

* Black-box entry subcircuit for sky130_fd_sc_hd__bufinv_16 abstract view
.subckt sky130_fd_sc_hd__bufinv_16 A VGND VNB VPB VPWR Y
.ends

* Black-box entry subcircuit for sky130_fd_sc_hd__clkinvlp_4 abstract view
.subckt sky130_fd_sc_hd__clkinvlp_4 A VGND VNB VPB VPWR Y
.ends

* Black-box entry subcircuit for sky130_fd_sc_hd__o32a_1 abstract view
.subckt sky130_fd_sc_hd__o32a_1 A1 A2 A3 B1 B2 VGND VNB VPB VPWR X
.ends

* Black-box entry subcircuit for sky130_fd_sc_hd__o22a_1 abstract view
.subckt sky130_fd_sc_hd__o22a_1 A1 A2 B1 B2 VGND VNB VPB VPWR X
.ends

* Black-box entry subcircuit for sky130_fd_sc_hd__nor2_2 abstract view
.subckt sky130_fd_sc_hd__nor2_2 A B VGND VNB VPB VPWR Y
.ends

* Black-box entry subcircuit for sky130_fd_sc_hd__xor2_1 abstract view
.subckt sky130_fd_sc_hd__xor2_1 A B VGND VNB VPB VPWR X
.ends

* Black-box entry subcircuit for sky130_fd_sc_hd__nor3_1 abstract view
.subckt sky130_fd_sc_hd__nor3_1 A B C VGND VNB VPB VPWR Y
.ends

* Black-box entry subcircuit for sky130_fd_sc_hd__o41a_1 abstract view
.subckt sky130_fd_sc_hd__o41a_1 A1 A2 A3 A4 B1 VGND VNB VPB VPWR X
.ends

* Black-box entry subcircuit for sky130_fd_sc_hd__a2bb2o_2 abstract view
.subckt sky130_fd_sc_hd__a2bb2o_2 A1_N A2_N B1 B2 VGND VNB VPB VPWR X
.ends

* Black-box entry subcircuit for sky130_fd_sc_hd__or4_1 abstract view
.subckt sky130_fd_sc_hd__or4_1 A B C D VGND VNB VPB VPWR X
.ends

* Black-box entry subcircuit for sky130_fd_sc_hd__or3b_1 abstract view
.subckt sky130_fd_sc_hd__or3b_1 A B C_N VGND VNB VPB VPWR X
.ends

* Black-box entry subcircuit for sky130_fd_sc_hd__and3b_1 abstract view
.subckt sky130_fd_sc_hd__and3b_1 A_N B C VGND VNB VPB VPWR X
.ends

* Black-box entry subcircuit for sky130_fd_sc_hd__or2_2 abstract view
.subckt sky130_fd_sc_hd__or2_2 A B VGND VNB VPB VPWR X
.ends

* Black-box entry subcircuit for sky130_fd_sc_hd__o31a_1 abstract view
.subckt sky130_fd_sc_hd__o31a_1 A1 A2 A3 B1 VGND VNB VPB VPWR X
.ends

* Black-box entry subcircuit for sky130_fd_sc_hd__dlymetal6s2s_1 abstract view
.subckt sky130_fd_sc_hd__dlymetal6s2s_1 A VGND VNB VPB VPWR X
.ends

* Black-box entry subcircuit for sky130_fd_sc_hd__a31o_1 abstract view
.subckt sky130_fd_sc_hd__a31o_1 A1 A2 A3 B1 VGND VNB VPB VPWR X
.ends

* Black-box entry subcircuit for sky130_fd_sc_hd__o221ai_2 abstract view
.subckt sky130_fd_sc_hd__o221ai_2 A1 A2 B1 B2 C1 VGND VNB VPB VPWR Y
.ends

* Black-box entry subcircuit for sky130_fd_sc_hd__o21ba_1 abstract view
.subckt sky130_fd_sc_hd__o21ba_1 A1 A2 B1_N VGND VNB VPB VPWR X
.ends

* Black-box entry subcircuit for sky130_fd_sc_hd__a32o_4 abstract view
.subckt sky130_fd_sc_hd__a32o_4 A1 A2 A3 B1 B2 VGND VNB VPB VPWR X
.ends

* Black-box entry subcircuit for sky130_fd_sc_hd__or2b_1 abstract view
.subckt sky130_fd_sc_hd__or2b_1 A B_N VGND VNB VPB VPWR X
.ends

* Black-box entry subcircuit for sky130_fd_sc_hd__buf_8 abstract view
.subckt sky130_fd_sc_hd__buf_8 A VGND VNB VPB VPWR X
.ends

* Black-box entry subcircuit for sky130_fd_sc_hd__clkbuf_16 abstract view
.subckt sky130_fd_sc_hd__clkbuf_16 A VGND VNB VPB VPWR X
.ends

* Black-box entry subcircuit for sky130_fd_sc_hd__nor2_4 abstract view
.subckt sky130_fd_sc_hd__nor2_4 A B VGND VNB VPB VPWR Y
.ends

* Black-box entry subcircuit for sky130_fd_sc_hd__o211ai_1 abstract view
.subckt sky130_fd_sc_hd__o211ai_1 A1 A2 B1 C1 VGND VNB VPB VPWR Y
.ends

* Black-box entry subcircuit for sky130_fd_sc_hd__xor2_2 abstract view
.subckt sky130_fd_sc_hd__xor2_2 A B VGND VNB VPB VPWR X
.ends

* Black-box entry subcircuit for sky130_fd_sc_hd__a21bo_1 abstract view
.subckt sky130_fd_sc_hd__a21bo_1 A1 A2 B1_N VGND VNB VPB VPWR X
.ends

* Black-box entry subcircuit for sky130_fd_sc_hd__nand3b_4 abstract view
.subckt sky130_fd_sc_hd__nand3b_4 A_N B C VGND VNB VPB VPWR Y
.ends

* Black-box entry subcircuit for sky130_fd_sc_hd__or4_4 abstract view
.subckt sky130_fd_sc_hd__or4_4 A B C D VGND VNB VPB VPWR X
.ends

* Black-box entry subcircuit for sky130_fd_sc_hd__inv_8 abstract view
.subckt sky130_fd_sc_hd__inv_8 A VGND VNB VPB VPWR Y
.ends

* Black-box entry subcircuit for sky130_fd_sc_hd__a221oi_2 abstract view
.subckt sky130_fd_sc_hd__a221oi_2 A1 A2 B1 B2 C1 VGND VNB VPB VPWR Y
.ends

* Black-box entry subcircuit for sky130_fd_sc_hd__o2bb2a_2 abstract view
.subckt sky130_fd_sc_hd__o2bb2a_2 A1_N A2_N B1 B2 VGND VNB VPB VPWR X
.ends

* Black-box entry subcircuit for sky130_fd_sc_hd__a21oi_4 abstract view
.subckt sky130_fd_sc_hd__a21oi_4 A1 A2 B1 VGND VNB VPB VPWR Y
.ends

* Black-box entry subcircuit for sky130_fd_sc_hd__a2bb2o_1 abstract view
.subckt sky130_fd_sc_hd__a2bb2o_1 A1_N A2_N B1 B2 VGND VNB VPB VPWR X
.ends

* Black-box entry subcircuit for sky130_fd_sc_hd__o31ai_4 abstract view
.subckt sky130_fd_sc_hd__o31ai_4 A1 A2 A3 B1 VGND VNB VPB VPWR Y
.ends

* Black-box entry subcircuit for sky130_fd_sc_hd__mux2_2 abstract view
.subckt sky130_fd_sc_hd__mux2_2 A0 A1 S VGND VNB VPB VPWR X
.ends

* Black-box entry subcircuit for sky130_fd_sc_hd__a21oi_2 abstract view
.subckt sky130_fd_sc_hd__a21oi_2 A1 A2 B1 VGND VNB VPB VPWR Y
.ends

* Black-box entry subcircuit for sky130_fd_sc_hd__and3b_2 abstract view
.subckt sky130_fd_sc_hd__and3b_2 A_N B C VGND VNB VPB VPWR X
.ends

* Black-box entry subcircuit for sky130_fd_sc_hd__nand2_2 abstract view
.subckt sky130_fd_sc_hd__nand2_2 A B VGND VNB VPB VPWR Y
.ends

* Black-box entry subcircuit for sky130_fd_sc_hd__nand3_4 abstract view
.subckt sky130_fd_sc_hd__nand3_4 A B C VGND VNB VPB VPWR Y
.ends

* Black-box entry subcircuit for sky130_fd_sc_hd__a22oi_1 abstract view
.subckt sky130_fd_sc_hd__a22oi_1 A1 A2 B1 B2 VGND VNB VPB VPWR Y
.ends

* Black-box entry subcircuit for sky130_fd_sc_hd__and4_1 abstract view
.subckt sky130_fd_sc_hd__and4_1 A B C D VGND VNB VPB VPWR X
.ends

* Black-box entry subcircuit for sky130_fd_sc_hd__nor4_4 abstract view
.subckt sky130_fd_sc_hd__nor4_4 A B C D VGND VNB VPB VPWR Y
.ends

* Black-box entry subcircuit for sky130_fd_sc_hd__mux4_2 abstract view
.subckt sky130_fd_sc_hd__mux4_2 A0 A1 A2 A3 S0 S1 VGND VNB VPB VPWR X
.ends

* Black-box entry subcircuit for sky130_fd_sc_hd__a31o_4 abstract view
.subckt sky130_fd_sc_hd__a31o_4 A1 A2 A3 B1 VGND VNB VPB VPWR X
.ends

* Black-box entry subcircuit for sky130_fd_sc_hd__a32o_1 abstract view
.subckt sky130_fd_sc_hd__a32o_1 A1 A2 A3 B1 B2 VGND VNB VPB VPWR X
.ends

* Black-box entry subcircuit for sky130_fd_sc_hd__a32oi_4 abstract view
.subckt sky130_fd_sc_hd__a32oi_4 A1 A2 A3 B1 B2 VGND VNB VPB VPWR Y
.ends

* Black-box entry subcircuit for sky130_fd_sc_hd__o2bb2a_4 abstract view
.subckt sky130_fd_sc_hd__o2bb2a_4 A1_N A2_N B1 B2 VGND VNB VPB VPWR X
.ends

* Black-box entry subcircuit for sky130_fd_sc_hd__and3b_4 abstract view
.subckt sky130_fd_sc_hd__and3b_4 A_N B C VGND VNB VPB VPWR X
.ends

* Black-box entry subcircuit for sky130_fd_sc_hd__a311o_2 abstract view
.subckt sky130_fd_sc_hd__a311o_2 A1 A2 A3 B1 C1 VGND VNB VPB VPWR X
.ends

* Black-box entry subcircuit for sky130_fd_sc_hd__and3_2 abstract view
.subckt sky130_fd_sc_hd__and3_2 A B C VGND VNB VPB VPWR X
.ends

* Black-box entry subcircuit for sky130_fd_sc_hd__or3_2 abstract view
.subckt sky130_fd_sc_hd__or3_2 A B C VGND VNB VPB VPWR X
.ends

* Black-box entry subcircuit for sky130_fd_sc_hd__a311o_1 abstract view
.subckt sky130_fd_sc_hd__a311o_1 A1 A2 A3 B1 C1 VGND VNB VPB VPWR X
.ends

* Black-box entry subcircuit for sky130_fd_sc_hd__or4b_4 abstract view
.subckt sky130_fd_sc_hd__or4b_4 A B C D_N VGND VNB VPB VPWR X
.ends

* Black-box entry subcircuit for sky130_fd_sc_hd__o211ai_2 abstract view
.subckt sky130_fd_sc_hd__o211ai_2 A1 A2 B1 C1 VGND VNB VPB VPWR Y
.ends

* Black-box entry subcircuit for sky130_fd_sc_hd__nor4_1 abstract view
.subckt sky130_fd_sc_hd__nor4_1 A B C D VGND VNB VPB VPWR Y
.ends

* Black-box entry subcircuit for sky130_fd_sc_hd__and4b_1 abstract view
.subckt sky130_fd_sc_hd__and4b_1 A_N B C D VGND VNB VPB VPWR X
.ends

* Black-box entry subcircuit for sky130_fd_sc_hd__or4b_2 abstract view
.subckt sky130_fd_sc_hd__or4b_2 A B C D_N VGND VNB VPB VPWR X
.ends

* Black-box entry subcircuit for sky130_fd_sc_hd__nand3_1 abstract view
.subckt sky130_fd_sc_hd__nand3_1 A B C VGND VNB VPB VPWR Y
.ends

* Black-box entry subcircuit for sky130_fd_sc_hd__nand4_1 abstract view
.subckt sky130_fd_sc_hd__nand4_1 A B C D VGND VNB VPB VPWR Y
.ends

* Black-box entry subcircuit for sky130_fd_sc_hd__a2111oi_2 abstract view
.subckt sky130_fd_sc_hd__a2111oi_2 A1 A2 B1 C1 D1 VGND VNB VPB VPWR Y
.ends

.subckt RegFileALU VGND VPWR a1[0] a1[1] a1[2] a1[3] a1[4] a2[0] a2[1] a2[2] a2[3]
+ a2[4] a3[0] a3[1] a3[2] a3[3] a3[4] alu_op[0] alu_op[1] alu_result[0] alu_result[10]
+ alu_result[11] alu_result[12] alu_result[13] alu_result[14] alu_result[15] alu_result[16]
+ alu_result[17] alu_result[18] alu_result[19] alu_result[1] alu_result[20] alu_result[21]
+ alu_result[22] alu_result[23] alu_result[24] alu_result[25] alu_result[26] alu_result[27]
+ alu_result[28] alu_result[29] alu_result[2] alu_result[30] alu_result[31] alu_result[3]
+ alu_result[4] alu_result[5] alu_result[6] alu_result[7] alu_result[8] alu_result[9]
+ clk rd1[0] rd1[10] rd1[11] rd1[12] rd1[13] rd1[14] rd1[15] rd1[16] rd1[17] rd1[18]
+ rd1[19] rd1[1] rd1[20] rd1[21] rd1[22] rd1[23] rd1[24] rd1[25] rd1[26] rd1[27] rd1[28]
+ rd1[29] rd1[2] rd1[30] rd1[31] rd1[3] rd1[4] rd1[5] rd1[6] rd1[7] rd1[8] rd1[9]
+ rd2[0] rd2[10] rd2[11] rd2[12] rd2[13] rd2[14] rd2[15] rd2[16] rd2[17] rd2[18] rd2[19]
+ rd2[1] rd2[20] rd2[21] rd2[22] rd2[23] rd2[24] rd2[25] rd2[26] rd2[27] rd2[28] rd2[29]
+ rd2[2] rd2[30] rd2[31] rd2[3] rd2[4] rd2[5] rd2[6] rd2[7] rd2[8] rd2[9] wd3[0] wd3[10]
+ wd3[11] wd3[12] wd3[13] wd3[14] wd3[15] wd3[16] wd3[17] wd3[18] wd3[19] wd3[1] wd3[20]
+ wd3[21] wd3[22] wd3[23] wd3[24] wd3[25] wd3[26] wd3[27] wd3[28] wd3[29] wd3[2] wd3[30]
+ wd3[31] wd3[3] wd3[4] wd3[5] wd3[6] wd3[7] wd3[8] wd3[9] we3
XFILLER_0_94_77 VGND VGND VPWR VPWR sky130_fd_sc_hd__fill_2
XFILLER_0_94_55 VGND VGND VPWR VPWR sky130_fd_sc_hd__fill_2
X_7963_ _2991_ registers\[28\]\[14\] _3912_ VGND VGND VPWR VPWR _3917_ sky130_fd_sc_hd__mux2_1
XANTENNA__5469__C _1319_ VGND VGND VPWR VPWR sky130_fd_sc_hd__diode_2
X_6914_ _3106_ registers\[13\]\[18\] _3335_ VGND VGND VPWR VPWR _3344_ sky130_fd_sc_hd__mux2_1
X_7894_ _3880_ VGND VGND VPWR VPWR _0358_ sky130_fd_sc_hd__clkbuf_1
XTAP_TAPCELL_ROW_85_1362 VGND VPWR sky130_fd_sc_hd__tapvpwrvgnd_1
XFILLER_0_76_122 VGND VGND VPWR VPWR sky130_fd_sc_hd__fill_2
XTAP_TAPCELL_ROW_53_949 VGND VPWR sky130_fd_sc_hd__tapvpwrvgnd_1
X_6845_ _3307_ VGND VGND VPWR VPWR _0906_ sky130_fd_sc_hd__clkbuf_1
XFILLER_0_77_689 VGND VGND VPWR VPWR sky130_fd_sc_hd__decap_3
XFILLER_0_76_177 VGND VGND VPWR VPWR sky130_fd_sc_hd__fill_2
XFILLER_0_9_444 VGND VGND VPWR VPWR sky130_fd_sc_hd__fill_2
XANTENNA__7457__S _3648_ VGND VGND VPWR VPWR sky130_fd_sc_hd__diode_2
XANTENNA__6361__S _3030_ VGND VGND VPWR VPWR sky130_fd_sc_hd__diode_2
X_6776_ registers\[11\]\[18\] _2999_ _3261_ VGND VGND VPWR VPWR _3270_ sky130_fd_sc_hd__mux2_1
XFILLER_0_45_531 VGND VGND VPWR VPWR sky130_fd_sc_hd__fill_2
X_9564_ clknet_leaf_108_clk _0661_ VGND VGND VPWR VPWR registers\[4\]\[28\] sky130_fd_sc_hd__dfxtp_1
XANTENNA__4670__A _1381_ VGND VGND VPWR VPWR sky130_fd_sc_hd__diode_2
X_5727_ _2429_ _2437_ _2459_ VGND VGND VPWR VPWR net74 sky130_fd_sc_hd__a21oi_1
XFILLER_0_91_169 VGND VGND VPWR VPWR sky130_fd_sc_hd__decap_3
XFILLER_0_91_147 VGND VGND VPWR VPWR sky130_fd_sc_hd__fill_2
X_8515_ registers\[4\]\[18\] net25 _4200_ VGND VGND VPWR VPWR _4209_ sky130_fd_sc_hd__mux2_1
XFILLER_0_45_553 VGND VGND VPWR VPWR sky130_fd_sc_hd__decap_4
X_9495_ clknet_leaf_69_clk _0592_ VGND VGND VPWR VPWR registers\[5\]\[23\] sky130_fd_sc_hd__dfxtp_1
XANTENNA__6806__A_N net13 VGND VGND VPWR VPWR sky130_fd_sc_hd__diode_2
XTAP_TAPCELL_ROW_33_684 VGND VPWR sky130_fd_sc_hd__tapvpwrvgnd_1
X_8446_ _4172_ VGND VGND VPWR VPWR _0618_ sky130_fd_sc_hd__clkbuf_1
XANTENNA__6145__A1 _2084_ VGND VGND VPWR VPWR sky130_fd_sc_hd__diode_2
XFILLER_0_45_586 VGND VGND VPWR VPWR sky130_fd_sc_hd__fill_1
X_5658_ net139 _2199_ _2392_ VGND VGND VPWR VPWR _2393_ sky130_fd_sc_hd__and3_1
XANTENNA__7192__S _3503_ VGND VGND VPWR VPWR sky130_fd_sc_hd__diode_2
XANTENNA__8288__S _4081_ VGND VGND VPWR VPWR sky130_fd_sc_hd__diode_2
X_8377_ registers\[5\]\[17\] _3470_ _4128_ VGND VGND VPWR VPWR _4136_ sky130_fd_sc_hd__mux2_1
X_5589_ _2323_ _2234_ VGND VGND VPWR VPWR _2324_ sky130_fd_sc_hd__nor2_1
XFILLER_0_60_589 VGND VGND VPWR VPWR sky130_fd_sc_hd__decap_4
XFILLER_0_4_171 VGND VGND VPWR VPWR sky130_fd_sc_hd__fill_2
XFILLER_0_13_461 VGND VGND VPWR VPWR sky130_fd_sc_hd__fill_2
XFILLER_0_32_258 VGND VGND VPWR VPWR sky130_fd_sc_hd__fill_2
X_4609_ _1324_ VGND VGND VPWR VPWR _1391_ sky130_fd_sc_hd__clkbuf_4
X_7328_ registers\[1\]\[4\] _3443_ _3575_ VGND VGND VPWR VPWR _3580_ sky130_fd_sc_hd__mux2_1
XFILLER_0_7_81 VGND VGND VPWR VPWR sky130_fd_sc_hd__fill_2
X_7259_ _3543_ VGND VGND VPWR VPWR _0060_ sky130_fd_sc_hd__clkbuf_1
XFILLER_0_40_291 VGND VGND VPWR VPWR sky130_fd_sc_hd__fill_2
XANTENNA__5006__A _1767_ VGND VGND VPWR VPWR sky130_fd_sc_hd__diode_2
XANTENNA__4459__A1 _1116_ VGND VGND VPWR VPWR sky130_fd_sc_hd__diode_2
XTAP_TAPCELL_ROW_5_321 VGND VPWR sky130_fd_sc_hd__tapvpwrvgnd_1
XANTENNA__7920__S _3887_ VGND VGND VPWR VPWR sky130_fd_sc_hd__diode_2
XANTENNA__6536__S _3137_ VGND VGND VPWR VPWR sky130_fd_sc_hd__diode_2
XANTENNA__4306__S1 _1040_ VGND VGND VPWR VPWR sky130_fd_sc_hd__diode_2
XFILLER_0_68_612 VGND VGND VPWR VPWR sky130_fd_sc_hd__decap_3
XFILLER_0_95_442 VGND VGND VPWR VPWR sky130_fd_sc_hd__decap_3
XFILLER_0_95_420 VGND VGND VPWR VPWR sky130_fd_sc_hd__fill_2
XFILLER_0_68_634 VGND VGND VPWR VPWR sky130_fd_sc_hd__fill_1
XFILLER_0_67_133 VGND VGND VPWR VPWR sky130_fd_sc_hd__fill_2
XFILLER_0_67_111 VGND VGND VPWR VPWR sky130_fd_sc_hd__fill_1
XANTENNA__6271__S _2962_ VGND VGND VPWR VPWR sky130_fd_sc_hd__diode_2
XFILLER_0_95_486 VGND VGND VPWR VPWR sky130_fd_sc_hd__fill_2
XFILLER_0_83_648 VPWR VGND VPWR VGND sky130_ef_sc_hd__decap_12
XFILLER_0_67_199 VGND VGND VPWR VPWR sky130_fd_sc_hd__decap_4
XFILLER_0_82_158 VGND VGND VPWR VPWR sky130_fd_sc_hd__decap_3
XANTENNA__4490__S0 _1201_ VGND VGND VPWR VPWR sky130_fd_sc_hd__diode_2
XFILLER_0_63_383 VGND VGND VPWR VPWR sky130_fd_sc_hd__fill_2
XFILLER_0_51_501 VGND VGND VPWR VPWR sky130_fd_sc_hd__fill_1
XFILLER_0_51_534 VGND VGND VPWR VPWR sky130_fd_sc_hd__fill_2
XFILLER_0_23_225 VGND VGND VPWR VPWR sky130_fd_sc_hd__fill_1
XFILLER_0_11_409 VGND VGND VPWR VPWR sky130_fd_sc_hd__fill_2
XANTENNA__8198__S _4031_ VGND VGND VPWR VPWR sky130_fd_sc_hd__diode_2
XFILLER_0_48_15 VGND VGND VPWR VPWR sky130_fd_sc_hd__fill_2
XFILLER_0_102_691 VGND VGND VPWR VPWR sky130_fd_sc_hd__decap_6
X_4960_ _1701_ _1723_ _1702_ VGND VGND VPWR VPWR _1724_ sky130_fd_sc_hd__a21oi_1
XANTENNA__7277__S _3550_ VGND VGND VPWR VPWR sky130_fd_sc_hd__diode_2
XFILLER_0_86_475 VGND VGND VPWR VPWR sky130_fd_sc_hd__fill_1
XFILLER_0_59_678 VGND VGND VPWR VPWR sky130_fd_sc_hd__fill_2
X_4891_ _1656_ _1657_ _1627_ VGND VGND VPWR VPWR _1658_ sky130_fd_sc_hd__mux2_1
XANTENNA__5586__A _2270_ VGND VGND VPWR VPWR sky130_fd_sc_hd__diode_2
X_6630_ _3191_ VGND VGND VPWR VPWR _0807_ sky130_fd_sc_hd__clkbuf_1
XFILLER_0_80_79 VGND VGND VPWR VPWR sky130_fd_sc_hd__decap_4
XFILLER_0_80_68 VGND VGND VPWR VPWR sky130_fd_sc_hd__decap_4
XANTENNA__6375__A1 _2978_ VGND VGND VPWR VPWR sky130_fd_sc_hd__diode_2
XTAP_TAPCELL_ROW_50_908 VGND VPWR sky130_fd_sc_hd__tapvpwrvgnd_1
XFILLER_0_46_339 VGND VGND VPWR VPWR sky130_fd_sc_hd__fill_2
XFILLER_0_116_205 VGND VGND VPWR VPWR sky130_fd_sc_hd__fill_1
X_6561_ registers\[7\]\[15\] _2993_ _3148_ VGND VGND VPWR VPWR _3154_ sky130_fd_sc_hd__mux2_1
XFILLER_0_13_73 VGND VGND VPWR VPWR sky130_fd_sc_hd__fill_2
X_8300_ _4095_ VGND VGND VPWR VPWR _0549_ sky130_fd_sc_hd__clkbuf_1
X_5512_ _2220_ _2247_ VGND VGND VPWR VPWR _2248_ sky130_fd_sc_hd__nand2_1
XTAP_TAPCELL_ROW_30_643 VGND VPWR sky130_fd_sc_hd__tapvpwrvgnd_1
XTAP_TAPCELL_ROW_30_654 VGND VPWR sky130_fd_sc_hd__tapvpwrvgnd_1
XFILLER_0_89_66 VGND VGND VPWR VPWR sky130_fd_sc_hd__decap_4
XFILLER_0_80_7 VGND VGND VPWR VPWR sky130_fd_sc_hd__fill_2
X_9280_ clknet_leaf_111_clk _0377_ VGND VGND VPWR VPWR registers\[28\]\[0\] sky130_fd_sc_hd__dfxtp_1
X_6492_ _3110_ registers\[29\]\[20\] _3111_ VGND VGND VPWR VPWR _3112_ sky130_fd_sc_hd__mux2_1
XFILLER_0_89_88 VGND VGND VPWR VPWR sky130_fd_sc_hd__fill_2
X_8231_ registers\[6\]\[12\] _3460_ _4056_ VGND VGND VPWR VPWR _4059_ sky130_fd_sc_hd__mux2_1
X_5443_ _2175_ _2177_ _2180_ _1771_ _1741_ VGND VGND VPWR VPWR _2181_ sky130_fd_sc_hd__o221a_1
XFILLER_0_42_589 VGND VGND VPWR VPWR sky130_fd_sc_hd__fill_2
XFILLER_0_2_642 VGND VGND VPWR VPWR sky130_fd_sc_hd__fill_2
XFILLER_0_30_718 VGND VGND VPWR VPWR sky130_fd_sc_hd__fill_2
X_8162_ _4022_ VGND VGND VPWR VPWR _0484_ sky130_fd_sc_hd__clkbuf_1
XFILLER_0_100_617 VGND VGND VPWR VPWR sky130_fd_sc_hd__fill_2
XANTENNA__6210__A _2168_ VGND VGND VPWR VPWR sky130_fd_sc_hd__diode_2
XANTENNA__4689__B2 _1379_ VGND VGND VPWR VPWR sky130_fd_sc_hd__diode_2
XFILLER_0_2_653 VGND VGND VPWR VPWR sky130_fd_sc_hd__fill_1
X_5374_ _2114_ _2115_ _2076_ VGND VGND VPWR VPWR _2116_ sky130_fd_sc_hd__mux2_1
XFILLER_0_112_499 VGND VGND VPWR VPWR sky130_fd_sc_hd__fill_2
XFILLER_0_112_488 VGND VGND VPWR VPWR sky130_fd_sc_hd__fill_2
X_7113_ net17 VGND VGND VPWR VPWR _3455_ sky130_fd_sc_hd__buf_2
X_4325_ _1119_ _1120_ _1117_ VGND VGND VPWR VPWR _1121_ sky130_fd_sc_hd__mux2_1
X_8093_ _2985_ registers\[30\]\[11\] _3984_ VGND VGND VPWR VPWR _3986_ sky130_fd_sc_hd__mux2_1
XANTENNA__7740__S _3793_ VGND VGND VPWR VPWR sky130_fd_sc_hd__diode_2
XFILLER_0_10_486 VGND VGND VPWR VPWR sky130_fd_sc_hd__fill_2
X_7044_ _3098_ registers\[15\]\[14\] _3409_ VGND VGND VPWR VPWR _3414_ sky130_fd_sc_hd__mux2_1
X_4256_ registers\[24\]\[1\] registers\[25\]\[1\] registers\[26\]\[1\] registers\[27\]\[1\]
+ _1053_ _1054_ VGND VGND VPWR VPWR _1055_ sky130_fd_sc_hd__mux4_1
XANTENNA__8052__A1 _3485_ VGND VGND VPWR VPWR sky130_fd_sc_hd__diode_2
XFILLER_0_97_729 VGND VGND VPWR VPWR sky130_fd_sc_hd__fill_1
XANTENNA__6063__B1 _2778_ VGND VGND VPWR VPWR sky130_fd_sc_hd__diode_2
X_8995_ clknet_leaf_21_clk _0092_ VGND VGND VPWR VPWR registers\[1\]\[3\] sky130_fd_sc_hd__dfxtp_1
XTAP_TAPCELL_ROW_38_754 VGND VPWR sky130_fd_sc_hd__tapvpwrvgnd_1
X_7946_ _2974_ registers\[28\]\[6\] _3901_ VGND VGND VPWR VPWR _3908_ sky130_fd_sc_hd__mux2_1
XFILLER_0_54_80 VGND VGND VPWR VPWR sky130_fd_sc_hd__fill_2
XANTENNA__4613__A1 _1389_ VGND VGND VPWR VPWR sky130_fd_sc_hd__diode_2
X_7877_ _3871_ VGND VGND VPWR VPWR _0350_ sky130_fd_sc_hd__clkbuf_1
XFILLER_0_77_497 VGND VGND VPWR VPWR sky130_fd_sc_hd__fill_2
X_6828_ _3298_ VGND VGND VPWR VPWR _0898_ sky130_fd_sc_hd__clkbuf_1
XFILLER_0_9_241 VGND VGND VPWR VPWR sky130_fd_sc_hd__fill_2
XFILLER_0_108_728 VGND VGND VPWR VPWR sky130_fd_sc_hd__fill_2
XFILLER_0_92_456 VGND VGND VPWR VPWR sky130_fd_sc_hd__fill_2
XTAP_TAPCELL_ROW_98_1531 VGND VPWR sky130_fd_sc_hd__tapvpwrvgnd_1
X_9547_ clknet_leaf_51_clk _0644_ VGND VGND VPWR VPWR registers\[4\]\[11\] sky130_fd_sc_hd__dfxtp_1
XFILLER_0_92_489 VGND VGND VPWR VPWR sky130_fd_sc_hd__fill_1
X_6759_ _3249_ VGND VGND VPWR VPWR _3261_ sky130_fd_sc_hd__clkbuf_8
XANTENNA__6104__B _2515_ VGND VGND VPWR VPWR sky130_fd_sc_hd__diode_2
XANTENNA_clkbuf_leaf_93_clk_A clknet_4_9_0_clk VGND VGND VPWR VPWR sky130_fd_sc_hd__diode_2
X_9478_ clknet_leaf_36_clk _0575_ VGND VGND VPWR VPWR registers\[5\]\[6\] sky130_fd_sc_hd__dfxtp_1
XFILLER_0_73_692 VGND VGND VPWR VPWR sky130_fd_sc_hd__fill_2
XFILLER_0_72_191 VGND VGND VPWR VPWR sky130_fd_sc_hd__fill_2
X_8429_ _4163_ VGND VGND VPWR VPWR _0610_ sky130_fd_sc_hd__clkbuf_1
XFILLER_0_21_718 VGND VGND VPWR VPWR sky130_fd_sc_hd__decap_8
XFILLER_0_21_729 VGND VGND VPWR VPWR sky130_fd_sc_hd__fill_1
XANTENNA__5877__B1 _2276_ VGND VGND VPWR VPWR sky130_fd_sc_hd__diode_2
XFILLER_0_103_444 VGND VGND VPWR VPWR sky130_fd_sc_hd__fill_2
XANTENNA_clkbuf_leaf_31_clk_A clknet_4_5_0_clk VGND VGND VPWR VPWR sky130_fd_sc_hd__diode_2
XANTENNA__7886__A _3864_ VGND VGND VPWR VPWR sky130_fd_sc_hd__diode_2
XFILLER_0_83_401 VGND VGND VPWR VPWR sky130_fd_sc_hd__fill_2
XFILLER_0_56_648 VGND VGND VPWR VPWR sky130_fd_sc_hd__fill_2
XFILLER_0_71_607 VGND VGND VPWR VPWR sky130_fd_sc_hd__fill_2
XANTENNA__7825__S _3840_ VGND VGND VPWR VPWR sky130_fd_sc_hd__diode_2
XFILLER_0_113_219 VGND VGND VPWR VPWR sky130_fd_sc_hd__fill_2
XANTENNA_clkbuf_leaf_104_clk_A clknet_4_2_0_clk VGND VGND VPWR VPWR sky130_fd_sc_hd__diode_2
XTAP_TAPCELL_ROW_58_1014 VGND VPWR sky130_fd_sc_hd__tapvpwrvgnd_1
XFILLER_0_12_729 VGND VGND VPWR VPWR sky130_fd_sc_hd__decap_4
XFILLER_0_24_589 VPWR VGND VPWR VGND sky130_ef_sc_hd__decap_12
XANTENNA__7126__A net21 VGND VGND VPWR VPWR sky130_fd_sc_hd__diode_2
XFILLER_0_59_47 VGND VGND VPWR VPWR sky130_fd_sc_hd__fill_2
XANTENNA__7560__S _3695_ VGND VGND VPWR VPWR sky130_fd_sc_hd__diode_2
XANTENNA__4518__S1 _1199_ VGND VGND VPWR VPWR sky130_fd_sc_hd__diode_2
X_5090_ registers\[0\]\[10\] registers\[1\]\[10\] registers\[2\]\[10\] registers\[3\]\[10\]
+ _1742_ _1743_ VGND VGND VPWR VPWR _1848_ sky130_fd_sc_hd__mux4_1
XFILLER_0_75_57 VGND VGND VPWR VPWR sky130_fd_sc_hd__fill_2
XFILLER_0_38_9 VGND VGND VPWR VPWR sky130_fd_sc_hd__decap_3
XANTENNA__5080__S _1767_ VGND VGND VPWR VPWR sky130_fd_sc_hd__diode_2
XFILLER_0_79_729 VGND VGND VPWR VPWR sky130_fd_sc_hd__fill_1
XFILLER_0_78_206 VGND VGND VPWR VPWR sky130_fd_sc_hd__decap_4
XTAP_TAPCELL_ROW_69_1154 VGND VPWR sky130_fd_sc_hd__tapvpwrvgnd_1
XANTENNA__6904__S _3335_ VGND VGND VPWR VPWR sky130_fd_sc_hd__diode_2
X_8780_ clknet_leaf_14_clk _0901_ VGND VGND VPWR VPWR registers\[12\]\[12\] sky130_fd_sc_hd__dfxtp_1
X_5992_ _2710_ _2704_ VGND VGND VPWR VPWR _2712_ sky130_fd_sc_hd__and2b_1
X_7800_ _3071_ registers\[26\]\[1\] _3829_ VGND VGND VPWR VPWR _3831_ sky130_fd_sc_hd__mux2_1
XTAP_TAPCELL_ROW_35_713 VGND VPWR sky130_fd_sc_hd__tapvpwrvgnd_1
X_4943_ registers\[20\]\[4\] registers\[21\]\[4\] registers\[22\]\[4\] registers\[23\]\[4\]
+ _1705_ _1706_ VGND VGND VPWR VPWR _1707_ sky130_fd_sc_hd__mux4_1
XTAP_TAPCELL_ROW_82_1321 VGND VPWR sky130_fd_sc_hd__tapvpwrvgnd_1
XFILLER_0_59_464 VGND VGND VPWR VPWR sky130_fd_sc_hd__decap_3
X_7731_ _3794_ VGND VGND VPWR VPWR _0281_ sky130_fd_sc_hd__clkbuf_1
XFILLER_0_59_486 VGND VGND VPWR VPWR sky130_fd_sc_hd__decap_4
X_7662_ registers\[24\]\[0\] _3433_ _3757_ VGND VGND VPWR VPWR _3758_ sky130_fd_sc_hd__mux2_1
XANTENNA__6348__A1 _3022_ VGND VGND VPWR VPWR sky130_fd_sc_hd__diode_2
X_6613_ _3182_ VGND VGND VPWR VPWR _0799_ sky130_fd_sc_hd__clkbuf_1
X_4874_ _1641_ VGND VGND VPWR VPWR net81 sky130_fd_sc_hd__buf_2
X_9401_ clknet_leaf_82_clk _0498_ VGND VGND VPWR VPWR registers\[9\]\[25\] sky130_fd_sc_hd__dfxtp_1
XFILLER_0_117_569 VGND VGND VPWR VPWR sky130_fd_sc_hd__fill_2
XANTENNA__4454__S0 _1110_ VGND VGND VPWR VPWR sky130_fd_sc_hd__diode_2
X_7593_ _3065_ registers\[23\]\[0\] _3720_ VGND VGND VPWR VPWR _3721_ sky130_fd_sc_hd__mux2_1
X_6544_ registers\[7\]\[7\] _2976_ _3137_ VGND VGND VPWR VPWR _3145_ sky130_fd_sc_hd__mux2_1
Xclkbuf_4_12_0_clk clknet_0_clk VGND VGND VPWR VPWR clknet_4_12_0_clk sky130_fd_sc_hd__clkbuf_8
XFILLER_0_6_277 VGND VGND VPWR VPWR sky130_fd_sc_hd__decap_4
X_9332_ clknet_leaf_91_clk _0429_ VGND VGND VPWR VPWR registers\[2\]\[20\] sky130_fd_sc_hd__dfxtp_1
X_6475_ net22 VGND VGND VPWR VPWR _3100_ sky130_fd_sc_hd__clkbuf_2
X_9263_ clknet_leaf_66_clk _0360_ VGND VGND VPWR VPWR registers\[27\]\[15\] sky130_fd_sc_hd__dfxtp_1
X_8214_ registers\[6\]\[4\] _3443_ _4045_ VGND VGND VPWR VPWR _4050_ sky130_fd_sc_hd__mux2_1
XFILLER_0_71_3 VGND VGND VPWR VPWR sky130_fd_sc_hd__fill_2
XFILLER_0_70_684 VGND VGND VPWR VPWR sky130_fd_sc_hd__fill_1
X_5426_ registers\[0\]\[29\] registers\[1\]\[29\] registers\[2\]\[29\] registers\[3\]\[29\]
+ _2126_ _2127_ VGND VGND VPWR VPWR _2165_ sky130_fd_sc_hd__mux4_1
XFILLER_0_30_526 VGND VGND VPWR VPWR sky130_fd_sc_hd__fill_2
XFILLER_0_30_537 VGND VGND VPWR VPWR sky130_fd_sc_hd__fill_2
X_9194_ clknet_leaf_38_clk _0291_ VGND VGND VPWR VPWR registers\[25\]\[10\] sky130_fd_sc_hd__dfxtp_1
XFILLER_0_100_414 VGND VGND VPWR VPWR sky130_fd_sc_hd__decap_4
XTAP_TAPCELL_ROW_93_1472 VGND VPWR sky130_fd_sc_hd__tapvpwrvgnd_1
X_8145_ _4013_ VGND VGND VPWR VPWR _0476_ sky130_fd_sc_hd__clkbuf_1
XFILLER_0_49_91 VGND VGND VPWR VPWR sky130_fd_sc_hd__fill_2
X_5357_ _2026_ _2094_ _2096_ _2099_ _1960_ VGND VGND VPWR VPWR _2100_ sky130_fd_sc_hd__o221a_1
X_8076_ _2968_ registers\[30\]\[3\] _3973_ VGND VGND VPWR VPWR _3977_ sky130_fd_sc_hd__mux2_1
X_4308_ _1099_ _1101_ _1104_ _1034_ net8 VGND VGND VPWR VPWR _1105_ sky130_fd_sc_hd__a221o_1
X_5288_ _2034_ VGND VGND VPWR VPWR net94 sky130_fd_sc_hd__inv_2
X_7027_ _3081_ registers\[15\]\[6\] _3398_ VGND VGND VPWR VPWR _3405_ sky130_fd_sc_hd__mux2_1
X_4239_ a2[0] VGND VGND VPWR VPWR _1039_ sky130_fd_sc_hd__buf_4
XANTENNA__8025__A1 _3458_ VGND VGND VPWR VPWR sky130_fd_sc_hd__diode_2
XANTENNA__5182__S1 _1701_ VGND VGND VPWR VPWR sky130_fd_sc_hd__diode_2
XFILLER_0_97_559 VGND VGND VPWR VPWR sky130_fd_sc_hd__fill_1
X_8978_ clknet_leaf_61_clk _0075_ VGND VGND VPWR VPWR registers\[18\]\[18\] sky130_fd_sc_hd__dfxtp_1
XANTENNA__7784__A0 _3123_ VGND VGND VPWR VPWR sky130_fd_sc_hd__diode_2
X_7929_ _3898_ VGND VGND VPWR VPWR _0375_ sky130_fd_sc_hd__clkbuf_1
XFILLER_0_93_721 VGND VGND VPWR VPWR sky130_fd_sc_hd__fill_1
XFILLER_0_65_401 VGND VGND VPWR VPWR sky130_fd_sc_hd__decap_3
XANTENNA__4693__S0 _1320_ VGND VGND VPWR VPWR sky130_fd_sc_hd__diode_2
XANTENNA__6115__A _1500_ VGND VGND VPWR VPWR sky130_fd_sc_hd__diode_2
XTAP_TAPCELL_ROW_13_429 VGND VPWR sky130_fd_sc_hd__tapvpwrvgnd_1
XANTENNA__6339__A1 _3016_ VGND VGND VPWR VPWR sky130_fd_sc_hd__diode_2
XTAP_TAPCELL_ROW_102_1590 VGND VPWR sky130_fd_sc_hd__tapvpwrvgnd_1
XFILLER_0_92_275 VGND VGND VPWR VPWR sky130_fd_sc_hd__fill_1
XFILLER_0_92_253 VGND VGND VPWR VPWR sky130_fd_sc_hd__fill_2
XFILLER_0_80_426 VGND VGND VPWR VPWR sky130_fd_sc_hd__fill_2
XANTENNA__4445__S0 _1110_ VGND VGND VPWR VPWR sky130_fd_sc_hd__diode_2
XFILLER_0_53_629 VGND VGND VPWR VPWR sky130_fd_sc_hd__fill_2
XFILLER_0_52_106 VGND VGND VPWR VPWR sky130_fd_sc_hd__fill_2
XFILLER_0_46_670 VGND VGND VPWR VPWR sky130_fd_sc_hd__fill_1
XANTENNA__7645__S _3742_ VGND VGND VPWR VPWR sky130_fd_sc_hd__diode_2
XFILLER_0_18_361 VGND VGND VPWR VPWR sky130_fd_sc_hd__decap_3
XFILLER_0_18_383 VGND VGND VPWR VPWR sky130_fd_sc_hd__fill_2
XFILLER_0_61_673 VPWR VGND VPWR VGND sky130_ef_sc_hd__decap_12
XFILLER_0_103_285 VGND VGND VPWR VPWR sky130_fd_sc_hd__decap_8
XFILLER_0_21_548 VGND VGND VPWR VPWR sky130_fd_sc_hd__decap_3
XANTENNA__4748__S1 _1416_ VGND VGND VPWR VPWR sky130_fd_sc_hd__diode_2
XANTENNA__7380__S _3597_ VGND VGND VPWR VPWR sky130_fd_sc_hd__diode_2
XFILLER_0_29_28 VGND VGND VPWR VPWR sky130_fd_sc_hd__fill_2
XFILLER_0_29_39 VGND VGND VPWR VPWR sky130_fd_sc_hd__fill_1
XANTENNA__8264__A1 _3493_ VGND VGND VPWR VPWR sky130_fd_sc_hd__diode_2
XANTENNA__4509__S _1140_ VGND VGND VPWR VPWR sky130_fd_sc_hd__diode_2
XANTENNA__8016__A1 _3449_ VGND VGND VPWR VPWR sky130_fd_sc_hd__diode_2
XANTENNA__5173__S1 _1811_ VGND VGND VPWR VPWR sky130_fd_sc_hd__diode_2
XFILLER_0_88_526 VGND VGND VPWR VPWR sky130_fd_sc_hd__decap_3
XANTENNA__4920__S1 _1679_ VGND VGND VPWR VPWR sky130_fd_sc_hd__diode_2
XFILLER_0_45_49 VGND VGND VPWR VPWR sky130_fd_sc_hd__fill_1
XTAP_TAPCELL_ROW_105_1619 VGND VPWR sky130_fd_sc_hd__tapvpwrvgnd_1
XFILLER_0_0_29 VPWR VGND VPWR VGND sky130_ef_sc_hd__decap_12
XFILLER_0_96_570 VGND VGND VPWR VPWR sky130_fd_sc_hd__fill_2
XFILLER_0_84_721 VGND VGND VPWR VPWR sky130_fd_sc_hd__decap_8
XFILLER_0_68_261 VGND VGND VPWR VPWR sky130_fd_sc_hd__decap_3
XFILLER_0_29_626 VGND VGND VPWR VPWR sky130_fd_sc_hd__fill_2
XANTENNA__4684__S0 _1418_ VGND VGND VPWR VPWR sky130_fd_sc_hd__diode_2
XANTENNA__7527__A0 _3071_ VGND VGND VPWR VPWR sky130_fd_sc_hd__diode_2
XFILLER_0_83_275 VGND VGND VPWR VPWR sky130_fd_sc_hd__fill_2
XFILLER_0_83_253 VGND VGND VPWR VPWR sky130_fd_sc_hd__decap_3
XTAP_TAPCELL_ROW_64_1095 VGND VPWR sky130_fd_sc_hd__tapvpwrvgnd_1
XFILLER_0_16_309 VGND VGND VPWR VPWR sky130_fd_sc_hd__fill_2
XPHY_EDGE_ROW_104_Right_104 VGND VGND VPWR VPWR sky130_fd_sc_hd__decap_3
X_4590_ _1109_ VGND VGND VPWR VPWR _1372_ sky130_fd_sc_hd__buf_4
XFILLER_0_101_32 VGND VGND VPWR VPWR sky130_fd_sc_hd__fill_1
XTAP_TAPCELL_ROW_40_782 VGND VPWR sky130_fd_sc_hd__tapvpwrvgnd_1
XFILLER_0_101_54 VGND VGND VPWR VPWR sky130_fd_sc_hd__fill_2
XFILLER_0_12_515 VGND VGND VPWR VPWR sky130_fd_sc_hd__fill_2
XFILLER_0_12_526 VGND VGND VPWR VPWR sky130_fd_sc_hd__fill_2
XFILLER_0_12_537 VGND VGND VPWR VPWR sky130_fd_sc_hd__fill_1
XFILLER_0_110_701 VGND VGND VPWR VPWR sky130_fd_sc_hd__decap_8
XANTENNA__4739__S1 _1405_ VGND VGND VPWR VPWR sky130_fd_sc_hd__diode_2
X_6260_ _2963_ VGND VGND VPWR VPWR _0665_ sky130_fd_sc_hd__clkbuf_1
X_6191_ _2298_ _2843_ _2898_ VGND VGND VPWR VPWR _2899_ sky130_fd_sc_hd__a21o_1
XFILLER_0_86_45 VGND VGND VPWR VPWR sky130_fd_sc_hd__fill_2
X_5211_ registers\[20\]\[18\] registers\[21\]\[18\] registers\[22\]\[18\] registers\[23\]\[18\]
+ _1820_ _1821_ VGND VGND VPWR VPWR _1961_ sky130_fd_sc_hd__mux4_1
XANTENNA__8386__S _4139_ VGND VGND VPWR VPWR sky130_fd_sc_hd__diode_2
X_5142_ _1895_ _1896_ _1752_ VGND VGND VPWR VPWR _1897_ sky130_fd_sc_hd__mux2_1
XFILLER_0_19_61 VGND VGND VPWR VPWR sky130_fd_sc_hd__fill_2
XFILLER_0_19_72 VGND VGND VPWR VPWR sky130_fd_sc_hd__fill_2
XANTENNA__5104__A _1756_ VGND VGND VPWR VPWR sky130_fd_sc_hd__diode_2
XANTENNA__5164__S1 _1759_ VGND VGND VPWR VPWR sky130_fd_sc_hd__diode_2
X_5073_ registers\[12\]\[9\] registers\[13\]\[9\] registers\[14\]\[9\] registers\[15\]\[9\]
+ _1762_ _1764_ VGND VGND VPWR VPWR _1832_ sky130_fd_sc_hd__mux4_1
XANTENNA__4419__S net6 VGND VGND VPWR VPWR sky130_fd_sc_hd__diode_2
XANTENNA__6018__B1 _2560_ VGND VGND VPWR VPWR sky130_fd_sc_hd__diode_2
X_8901_ clknet_leaf_33_clk _1022_ VGND VGND VPWR VPWR registers\[16\]\[5\] sky130_fd_sc_hd__dfxtp_1
XFILLER_0_79_537 VGND VGND VPWR VPWR sky130_fd_sc_hd__fill_2
X_8832_ clknet_leaf_2_clk _0953_ VGND VGND VPWR VPWR registers\[14\]\[0\] sky130_fd_sc_hd__dfxtp_1
XTAP_TAPCELL_ROW_48_882 VGND VPWR sky130_fd_sc_hd__tapvpwrvgnd_1
X_5975_ net139 _2271_ VGND VGND VPWR VPWR _2695_ sky130_fd_sc_hd__and2_1
XFILLER_0_94_529 VGND VGND VPWR VPWR sky130_fd_sc_hd__decap_3
XFILLER_0_87_592 VGND VGND VPWR VPWR sky130_fd_sc_hd__fill_1
XANTENNA__5241__A1 _1689_ VGND VGND VPWR VPWR sky130_fd_sc_hd__diode_2
XFILLER_0_19_103 VGND VGND VPWR VPWR sky130_fd_sc_hd__fill_2
X_8763_ clknet_leaf_100_clk _0884_ VGND VGND VPWR VPWR registers\[11\]\[27\] sky130_fd_sc_hd__dfxtp_1
X_4926_ _1618_ VGND VGND VPWR VPWR _1691_ sky130_fd_sc_hd__buf_4
X_8694_ clknet_leaf_93_clk _0815_ VGND VGND VPWR VPWR registers\[0\]\[22\] sky130_fd_sc_hd__dfxtp_1
X_7714_ registers\[24\]\[25\] _3487_ _3779_ VGND VGND VPWR VPWR _3785_ sky130_fd_sc_hd__mux2_1
XFILLER_0_117_322 VGND VGND VPWR VPWR sky130_fd_sc_hd__decap_4
XFILLER_0_90_713 VPWR VGND VPWR VGND sky130_ef_sc_hd__decap_12
X_7645_ _3121_ registers\[23\]\[25\] _3742_ VGND VGND VPWR VPWR _3748_ sky130_fd_sc_hd__mux2_1
X_4857_ _1623_ _1624_ _1621_ VGND VGND VPWR VPWR _1625_ sky130_fd_sc_hd__mux2_1
XANTENNA__7465__S _3648_ VGND VGND VPWR VPWR sky130_fd_sc_hd__diode_2
X_7576_ _3711_ VGND VGND VPWR VPWR _0209_ sky130_fd_sc_hd__clkbuf_1
XFILLER_0_105_528 VGND VGND VPWR VPWR sky130_fd_sc_hd__decap_3
XANTENNA__5544__A2 _2216_ VGND VGND VPWR VPWR sky130_fd_sc_hd__diode_2
X_9315_ clknet_leaf_21_clk _0412_ VGND VGND VPWR VPWR registers\[2\]\[3\] sky130_fd_sc_hd__dfxtp_1
XANTENNA__6741__A1 _2964_ VGND VGND VPWR VPWR sky130_fd_sc_hd__diode_2
X_6527_ net13 net12 net11 VGND VGND VPWR VPWR _3135_ sky130_fd_sc_hd__or3b_4
X_4788_ _1554_ _1559_ _1381_ VGND VGND VPWR VPWR _1560_ sky130_fd_sc_hd__mux2_1
XFILLER_0_7_597 VGND VGND VPWR VPWR sky130_fd_sc_hd__fill_2
XFILLER_0_15_353 VGND VGND VPWR VPWR sky130_fd_sc_hd__decap_6
XFILLER_0_43_695 VGND VGND VPWR VPWR sky130_fd_sc_hd__fill_1
XFILLER_0_43_673 VGND VGND VPWR VPWR sky130_fd_sc_hd__fill_2
XFILLER_0_113_561 VGND VGND VPWR VPWR sky130_fd_sc_hd__fill_2
XANTENNA__8494__A1 net46 VGND VGND VPWR VPWR sky130_fd_sc_hd__diode_2
X_6458_ _3088_ VGND VGND VPWR VPWR _0738_ sky130_fd_sc_hd__clkbuf_1
X_9246_ clknet_leaf_98_clk _0343_ VGND VGND VPWR VPWR registers\[26\]\[30\] sky130_fd_sc_hd__dfxtp_1
XFILLER_0_113_594 VGND VGND VPWR VPWR sky130_fd_sc_hd__fill_2
X_6389_ _3046_ VGND VGND VPWR VPWR _0711_ sky130_fd_sc_hd__clkbuf_1
Xclkload90 clknet_leaf_49_clk VGND VGND VPWR VPWR clkload90/Y sky130_fd_sc_hd__inv_6
X_9177_ clknet_leaf_80_clk _0274_ VGND VGND VPWR VPWR registers\[24\]\[25\] sky130_fd_sc_hd__dfxtp_1
X_5409_ registers\[0\]\[28\] registers\[1\]\[28\] registers\[2\]\[28\] registers\[3\]\[28\]
+ _2072_ _2073_ VGND VGND VPWR VPWR _2149_ sky130_fd_sc_hd__mux4_1
XANTENNA__6809__S _3288_ VGND VGND VPWR VPWR sky130_fd_sc_hd__diode_2
X_8128_ _3020_ registers\[30\]\[28\] _3995_ VGND VGND VPWR VPWR _4004_ sky130_fd_sc_hd__mux2_1
XFILLER_0_100_299 VGND VGND VPWR VPWR sky130_fd_sc_hd__decap_3
X_8059_ _3967_ VGND VGND VPWR VPWR _0436_ sky130_fd_sc_hd__clkbuf_1
XANTENNA__4902__S1 _1643_ VGND VGND VPWR VPWR sky130_fd_sc_hd__diode_2
XANTENNA__6544__S _3137_ VGND VGND VPWR VPWR sky130_fd_sc_hd__diode_2
XFILLER_0_97_323 VGND VGND VPWR VPWR sky130_fd_sc_hd__fill_2
XANTENNA__4853__A net3 VGND VGND VPWR VPWR sky130_fd_sc_hd__diode_2
XFILLER_0_85_529 VGND VGND VPWR VPWR sky130_fd_sc_hd__fill_2
XFILLER_0_38_401 VGND VGND VPWR VPWR sky130_fd_sc_hd__decap_3
XANTENNA__4666__S0 _1386_ VGND VGND VPWR VPWR sky130_fd_sc_hd__diode_2
XTAP_TAPCELL_ROW_26_598 VGND VPWR sky130_fd_sc_hd__tapvpwrvgnd_1
XFILLER_0_93_573 VGND VGND VPWR VPWR sky130_fd_sc_hd__fill_1
XFILLER_0_81_702 VPWR VGND VPWR VGND sky130_ef_sc_hd__decap_12
XFILLER_0_65_253 VGND VGND VPWR VPWR sky130_fd_sc_hd__fill_1
XFILLER_0_31_29 VGND VGND VPWR VPWR sky130_fd_sc_hd__fill_2
XFILLER_0_93_595 VGND VGND VPWR VPWR sky130_fd_sc_hd__fill_2
XANTENNA__4418__S0 _1196_ VGND VGND VPWR VPWR sky130_fd_sc_hd__diode_2
XANTENNA__4969__S1 _1691_ VGND VGND VPWR VPWR sky130_fd_sc_hd__diode_2
XFILLER_0_34_673 VGND VGND VPWR VPWR sky130_fd_sc_hd__fill_2
XFILLER_0_34_695 VGND VGND VPWR VPWR sky130_fd_sc_hd__fill_2
XFILLER_0_1_729 VGND VGND VPWR VPWR sky130_fd_sc_hd__decap_4
XFILLER_0_21_323 VGND VGND VPWR VPWR sky130_fd_sc_hd__fill_2
XANTENNA__6719__S _3236_ VGND VGND VPWR VPWR sky130_fd_sc_hd__diode_2
XFILLER_0_21_389 VGND VGND VPWR VPWR sky130_fd_sc_hd__fill_1
XANTENNA__8237__A1 _3466_ VGND VGND VPWR VPWR sky130_fd_sc_hd__diode_2
XANTENNA__6248__B1 net124 VGND VGND VPWR VPWR sky130_fd_sc_hd__diode_2
XANTENNA__5146__S1 _1749_ VGND VGND VPWR VPWR sky130_fd_sc_hd__diode_2
XANTENNA__6799__A1 _3022_ VGND VGND VPWR VPWR sky130_fd_sc_hd__diode_2
XANTENNA__6454__S _3069_ VGND VGND VPWR VPWR sky130_fd_sc_hd__diode_2
XANTENNA__7748__A0 _3087_ VGND VGND VPWR VPWR sky130_fd_sc_hd__diode_2
XTAP_TAPCELL_ROW_66_1113 VGND VPWR sky130_fd_sc_hd__tapvpwrvgnd_1
XFILLER_0_88_389 VGND VGND VPWR VPWR sky130_fd_sc_hd__fill_1
XTAP_TAPCELL_ROW_45_841 VGND VPWR sky130_fd_sc_hd__tapvpwrvgnd_1
X_5760_ _2378_ _2389_ net135 VGND VGND VPWR VPWR _2491_ sky130_fd_sc_hd__mux2_1
XANTENNA__4431__C1 net8 VGND VGND VPWR VPWR sky130_fd_sc_hd__diode_2
XFILLER_0_84_584 VGND VGND VPWR VPWR sky130_fd_sc_hd__fill_1
X_5691_ net103 _2424_ VGND VGND VPWR VPWR _2425_ sky130_fd_sc_hd__xnor2_2
X_4711_ _1485_ _1486_ _1362_ VGND VGND VPWR VPWR _1487_ sky130_fd_sc_hd__mux2_1
XFILLER_0_17_607 VGND VGND VPWR VPWR sky130_fd_sc_hd__fill_2
XANTENNA__7285__S _3550_ VGND VGND VPWR VPWR sky130_fd_sc_hd__diode_2
XFILLER_0_71_234 VGND VGND VPWR VPWR sky130_fd_sc_hd__fill_2
XFILLER_0_44_448 VGND VGND VPWR VPWR sky130_fd_sc_hd__fill_2
XFILLER_0_16_128 VGND VGND VPWR VPWR sky130_fd_sc_hd__fill_1
XFILLER_0_16_139 VGND VGND VPWR VPWR sky130_fd_sc_hd__fill_1
X_7430_ _3611_ VGND VGND VPWR VPWR _3634_ sky130_fd_sc_hd__clkbuf_8
X_4642_ _1417_ _1420_ _1421_ VGND VGND VPWR VPWR _1422_ sky130_fd_sc_hd__mux2_1
XANTENNA__5082__S0 _1757_ VGND VGND VPWR VPWR sky130_fd_sc_hd__diode_2
XANTENNA__6723__A1 _3014_ VGND VGND VPWR VPWR sky130_fd_sc_hd__diode_2
XANTENNA__7920__A0 _3123_ VGND VGND VPWR VPWR sky130_fd_sc_hd__diode_2
X_4573_ _1109_ _1345_ _1352_ _1356_ VGND VGND VPWR VPWR net120 sky130_fd_sc_hd__o22a_2
XFILLER_0_4_567 VGND VGND VPWR VPWR sky130_fd_sc_hd__fill_2
XFILLER_0_4_545 VGND VGND VPWR VPWR sky130_fd_sc_hd__decap_4
XFILLER_0_12_312 VGND VGND VPWR VPWR sky130_fd_sc_hd__decap_3
XFILLER_0_25_673 VGND VGND VPWR VPWR sky130_fd_sc_hd__fill_1
X_7361_ _3574_ VGND VGND VPWR VPWR _3597_ sky130_fd_sc_hd__clkbuf_8
X_6312_ _2998_ VGND VGND VPWR VPWR _0682_ sky130_fd_sc_hd__clkbuf_1
X_9100_ clknet_leaf_42_clk _0197_ VGND VGND VPWR VPWR registers\[22\]\[12\] sky130_fd_sc_hd__dfxtp_1
XTAP_TAPCELL_ROW_77_1264 VGND VPWR sky130_fd_sc_hd__tapvpwrvgnd_1
X_7292_ _3560_ VGND VGND VPWR VPWR _0076_ sky130_fd_sc_hd__clkbuf_1
XFILLER_0_4_589 VGND VGND VPWR VPWR sky130_fd_sc_hd__fill_1
XFILLER_0_12_323 VGND VGND VPWR VPWR sky130_fd_sc_hd__fill_2
XANTENNA__6629__S _3186_ VGND VGND VPWR VPWR sky130_fd_sc_hd__diode_2
X_9031_ clknet_leaf_24_clk _0128_ VGND VGND VPWR VPWR registers\[20\]\[7\] sky130_fd_sc_hd__dfxtp_1
X_6243_ net136 _2515_ _2938_ VGND VGND VPWR VPWR _2948_ sky130_fd_sc_hd__a21oi_1
XFILLER_0_40_698 VGND VGND VPWR VPWR sky130_fd_sc_hd__fill_2
XTAP_TAPCELL_ROW_90_1431 VGND VPWR sky130_fd_sc_hd__tapvpwrvgnd_1
XFILLER_0_110_597 VGND VGND VPWR VPWR sky130_fd_sc_hd__decap_3
X_6174_ _2136_ _2882_ VGND VGND VPWR VPWR _2883_ sky130_fd_sc_hd__xnor2_1
XANTENNA__5137__S1 _1743_ VGND VGND VPWR VPWR sky130_fd_sc_hd__diode_2
X_5125_ _1754_ _1876_ _1878_ _1880_ _1778_ VGND VGND VPWR VPWR _1881_ sky130_fd_sc_hd__a221o_1
X_5056_ registers\[12\]\[8\] registers\[13\]\[8\] registers\[14\]\[8\] registers\[15\]\[8\]
+ _1757_ _1814_ VGND VGND VPWR VPWR _1816_ sky130_fd_sc_hd__mux4_1
XFILLER_0_79_334 VGND VGND VPWR VPWR sky130_fd_sc_hd__fill_2
XANTENNA__4896__S0 _1617_ VGND VGND VPWR VPWR sky130_fd_sc_hd__diode_2
XFILLER_0_94_304 VGND VGND VPWR VPWR sky130_fd_sc_hd__fill_2
X_8815_ clknet_leaf_46_clk _0936_ VGND VGND VPWR VPWR registers\[13\]\[15\] sky130_fd_sc_hd__dfxtp_1
XFILLER_0_67_518 VGND VGND VPWR VPWR sky130_fd_sc_hd__fill_2
XANTENNA__8400__A1 _3493_ VGND VGND VPWR VPWR sky130_fd_sc_hd__diode_2
X_8746_ clknet_leaf_35_clk _0867_ VGND VGND VPWR VPWR registers\[11\]\[10\] sky130_fd_sc_hd__dfxtp_1
XFILLER_0_94_359 VGND VGND VPWR VPWR sky130_fd_sc_hd__fill_2
X_5958_ _2543_ _2587_ _2639_ _2438_ _2678_ VGND VGND VPWR VPWR _2679_ sky130_fd_sc_hd__o221ai_1
XFILLER_0_63_724 VGND VGND VPWR VPWR sky130_fd_sc_hd__fill_1
X_4909_ _1669_ _1671_ _1674_ _1634_ net5 VGND VGND VPWR VPWR _1675_ sky130_fd_sc_hd__a221o_1
XFILLER_0_117_130 VGND VGND VPWR VPWR sky130_fd_sc_hd__fill_2
X_8677_ clknet_leaf_36_clk _0798_ VGND VGND VPWR VPWR registers\[0\]\[5\] sky130_fd_sc_hd__dfxtp_1
X_5889_ _2597_ _2600_ _2612_ VGND VGND VPWR VPWR _2614_ sky130_fd_sc_hd__o21ai_1
XFILLER_0_62_212 VGND VGND VPWR VPWR sky130_fd_sc_hd__fill_2
XFILLER_0_62_201 VGND VGND VPWR VPWR sky130_fd_sc_hd__fill_2
XANTENNA__4612__S _1346_ VGND VGND VPWR VPWR sky130_fd_sc_hd__diode_2
XFILLER_0_47_297 VGND VGND VPWR VPWR sky130_fd_sc_hd__decap_3
XTAP_TAPCELL_ROW_23_557 VGND VPWR sky130_fd_sc_hd__tapvpwrvgnd_1
XFILLER_0_35_426 VGND VGND VPWR VPWR sky130_fd_sc_hd__decap_8
X_7628_ _3104_ registers\[23\]\[17\] _3731_ VGND VGND VPWR VPWR _3739_ sky130_fd_sc_hd__mux2_1
XFILLER_0_117_185 VGND VGND VPWR VPWR sky130_fd_sc_hd__fill_1
XANTENNA__5073__S0 _1762_ VGND VGND VPWR VPWR sky130_fd_sc_hd__diode_2
XFILLER_0_90_598 VGND VGND VPWR VPWR sky130_fd_sc_hd__fill_2
X_7559_ _3702_ VGND VGND VPWR VPWR _0201_ sky130_fd_sc_hd__clkbuf_1
XFILLER_0_50_429 VGND VGND VPWR VPWR sky130_fd_sc_hd__decap_3
XFILLER_0_16_695 VGND VGND VPWR VPWR sky130_fd_sc_hd__fill_2
XFILLER_0_22_109 VGND VGND VPWR VPWR sky130_fd_sc_hd__fill_2
XANTENNA__5009__A _1655_ VGND VGND VPWR VPWR sky130_fd_sc_hd__diode_2
XFILLER_0_30_131 VGND VGND VPWR VPWR sky130_fd_sc_hd__fill_2
XANTENNA__4820__S0 _1347_ VGND VGND VPWR VPWR sky130_fd_sc_hd__diode_2
X_9229_ clknet_leaf_57_clk _0326_ VGND VGND VPWR VPWR registers\[26\]\[13\] sky130_fd_sc_hd__dfxtp_1
XFILLER_0_30_153 VGND VGND VPWR VPWR sky130_fd_sc_hd__fill_2
XFILLER_0_31_665 VGND VGND VPWR VPWR sky130_fd_sc_hd__fill_2
XANTENNA__4848__A net5 VGND VGND VPWR VPWR sky130_fd_sc_hd__diode_2
XFILLER_0_30_197 VGND VGND VPWR VPWR sky130_fd_sc_hd__fill_1
XFILLER_0_89_109 VGND VGND VPWR VPWR sky130_fd_sc_hd__decap_3
XFILLER_0_26_18 VGND VGND VPWR VPWR sky130_fd_sc_hd__fill_2
XFILLER_0_26_29 VGND VGND VPWR VPWR sky130_fd_sc_hd__fill_2
XANTENNA__6274__S _2962_ VGND VGND VPWR VPWR sky130_fd_sc_hd__diode_2
XFILLER_0_98_632 VGND VGND VPWR VPWR sky130_fd_sc_hd__fill_2
XANTENNA_input18_A wd3[11] VGND VGND VPWR VPWR sky130_fd_sc_hd__diode_2
XTAP_TAPCELL_ROW_3_293 VGND VPWR sky130_fd_sc_hd__tapvpwrvgnd_1
XFILLER_0_97_164 VGND VGND VPWR VPWR sky130_fd_sc_hd__fill_2
XFILLER_0_85_337 VGND VGND VPWR VPWR sky130_fd_sc_hd__fill_2
XTAP_TAPCELL_ROW_42_811 VGND VPWR sky130_fd_sc_hd__tapvpwrvgnd_1
XTAP_TAPCELL_ROW_42_800 VGND VPWR sky130_fd_sc_hd__tapvpwrvgnd_1
XFILLER_0_38_253 VGND VGND VPWR VPWR sky130_fd_sc_hd__decap_4
XFILLER_0_109_664 VGND VGND VPWR VPWR sky130_fd_sc_hd__decap_8
XFILLER_0_109_653 VGND VGND VPWR VPWR sky130_fd_sc_hd__fill_1
XFILLER_0_93_381 VGND VGND VPWR VPWR sky130_fd_sc_hd__decap_6
XFILLER_0_81_521 VGND VGND VPWR VPWR sky130_fd_sc_hd__fill_2
XTAP_TAPCELL_ROW_61_1054 VGND VPWR sky130_fd_sc_hd__tapvpwrvgnd_1
XFILLER_0_108_174 VGND VGND VPWR VPWR sky130_fd_sc_hd__fill_2
XANTENNA__5064__S0 _1820_ VGND VGND VPWR VPWR sky130_fd_sc_hd__diode_2
XFILLER_0_26_459 VGND VGND VPWR VPWR sky130_fd_sc_hd__fill_2
XFILLER_0_101_7 VGND VGND VPWR VPWR sky130_fd_sc_hd__fill_1
XFILLER_0_81_587 VGND VGND VPWR VPWR sky130_fd_sc_hd__fill_2
XANTENNA__7833__S _3840_ VGND VGND VPWR VPWR sky130_fd_sc_hd__diode_2
XANTENNA__8458__A1 net31 VGND VGND VPWR VPWR sky130_fd_sc_hd__diode_2
XANTENNA__4811__S0 _1550_ VGND VGND VPWR VPWR sky130_fd_sc_hd__diode_2
XTAP_TAPCELL_ROW_113_1729 VGND VPWR sky130_fd_sc_hd__tapvpwrvgnd_1
XANTENNA__5861__B _2587_ VGND VGND VPWR VPWR sky130_fd_sc_hd__diode_2
XFILLER_0_21_164 VGND VGND VPWR VPWR sky130_fd_sc_hd__fill_2
XFILLER_0_22_676 VGND VGND VPWR VPWR sky130_fd_sc_hd__fill_1
XANTENNA_output86_A net86 VGND VGND VPWR VPWR sky130_fd_sc_hd__diode_2
XANTENNA__7130__A1 _3466_ VGND VGND VPWR VPWR sky130_fd_sc_hd__diode_2
XANTENNA__7969__A0 _2997_ VGND VGND VPWR VPWR sky130_fd_sc_hd__diode_2
XANTENNA__5119__S1 _1764_ VGND VGND VPWR VPWR sky130_fd_sc_hd__diode_2
XTAP_TAPCELL_ROW_72_1194 VGND VPWR sky130_fd_sc_hd__tapvpwrvgnd_1
XFILLER_0_107_42 VPWR VGND VPWR VGND sky130_ef_sc_hd__decap_12
XFILLER_0_89_621 VGND VGND VPWR VPWR sky130_fd_sc_hd__fill_2
XFILLER_0_83_57 VGND VGND VPWR VPWR sky130_fd_sc_hd__fill_1
XANTENNA__5444__A1 _1977_ VGND VGND VPWR VPWR sky130_fd_sc_hd__diode_2
XANTENNA__4878__S0 _1642_ VGND VGND VPWR VPWR sky130_fd_sc_hd__diode_2
XFILLER_0_20_9 VGND VGND VPWR VPWR sky130_fd_sc_hd__fill_2
X_6930_ _3352_ VGND VGND VPWR VPWR _0946_ sky130_fd_sc_hd__clkbuf_1
XFILLER_0_76_304 VGND VGND VPWR VPWR sky130_fd_sc_hd__fill_2
X_6861_ registers\[12\]\[25\] _3014_ _3310_ VGND VGND VPWR VPWR _3316_ sky130_fd_sc_hd__mux2_1
X_5812_ _2538_ _2540_ _2295_ VGND VGND VPWR VPWR _2541_ sky130_fd_sc_hd__mux2_1
XANTENNA__6912__S _3335_ VGND VGND VPWR VPWR sky130_fd_sc_hd__diode_2
X_8600_ clknet_leaf_87_clk _0721_ VGND VGND VPWR VPWR registers\[3\]\[24\] sky130_fd_sc_hd__dfxtp_1
X_6792_ _3278_ VGND VGND VPWR VPWR _0882_ sky130_fd_sc_hd__clkbuf_1
X_5743_ _1049_ _1070_ _1089_ _1106_ _2394_ VGND VGND VPWR VPWR _2475_ sky130_fd_sc_hd__a41o_1
X_8531_ _4217_ VGND VGND VPWR VPWR _0658_ sky130_fd_sc_hd__clkbuf_1
XANTENNA__5528__S _1108_ VGND VGND VPWR VPWR sky130_fd_sc_hd__diode_2
XFILLER_0_8_158 VGND VGND VPWR VPWR sky130_fd_sc_hd__fill_2
XFILLER_0_29_297 VGND VGND VPWR VPWR sky130_fd_sc_hd__decap_3
X_5674_ _2298_ _2400_ _2407_ _2362_ VGND VGND VPWR VPWR _2408_ sky130_fd_sc_hd__a211o_1
XANTENNA__5055__S0 _1757_ VGND VGND VPWR VPWR sky130_fd_sc_hd__diode_2
XFILLER_0_60_705 VGND VGND VPWR VPWR sky130_fd_sc_hd__fill_2
X_8462_ registers\[8\]\[25\] net33 _4175_ VGND VGND VPWR VPWR _4181_ sky130_fd_sc_hd__mux2_1
XTAP_TAPCELL_ROW_20_516 VGND VPWR sky130_fd_sc_hd__tapvpwrvgnd_1
XFILLER_0_115_645 VPWR VGND VPWR VGND sky130_ef_sc_hd__decap_12
X_7413_ _3625_ VGND VGND VPWR VPWR _0132_ sky130_fd_sc_hd__clkbuf_1
XFILLER_0_114_111 VGND VGND VPWR VPWR sky130_fd_sc_hd__fill_2
X_4625_ registers\[8\]\[19\] registers\[9\]\[19\] registers\[10\]\[19\] registers\[11\]\[19\]
+ _1404_ _1405_ VGND VGND VPWR VPWR _1406_ sky130_fd_sc_hd__mux4_1
X_8393_ _4144_ VGND VGND VPWR VPWR _0593_ sky130_fd_sc_hd__clkbuf_1
XFILLER_0_25_470 VGND VGND VPWR VPWR sky130_fd_sc_hd__fill_2
X_7344_ _3588_ VGND VGND VPWR VPWR _0100_ sky130_fd_sc_hd__clkbuf_1
XANTENNA__8449__A1 net26 VGND VGND VPWR VPWR sky130_fd_sc_hd__diode_2
X_4556_ registers\[20\]\[16\] registers\[21\]\[16\] registers\[22\]\[16\] registers\[23\]\[16\]
+ _1338_ _1339_ VGND VGND VPWR VPWR _1340_ sky130_fd_sc_hd__mux4_1
XFILLER_0_4_353 VGND VGND VPWR VPWR sky130_fd_sc_hd__fill_2
XANTENNA__4802__S0 _1555_ VGND VGND VPWR VPWR sky130_fd_sc_hd__diode_2
XFILLER_0_114_188 VGND VGND VPWR VPWR sky130_fd_sc_hd__decap_4
XFILLER_0_4_397 VGND VGND VPWR VPWR sky130_fd_sc_hd__decap_3
X_7275_ registers\[18\]\[11\] _3458_ _3550_ VGND VGND VPWR VPWR _3552_ sky130_fd_sc_hd__mux2_1
X_4487_ registers\[24\]\[12\] registers\[25\]\[12\] registers\[26\]\[12\] registers\[27\]\[12\]
+ _1167_ _1168_ VGND VGND VPWR VPWR _1275_ sky130_fd_sc_hd__mux4_1
XANTENNA__6359__S _3030_ VGND VGND VPWR VPWR sky130_fd_sc_hd__diode_2
XFILLER_0_110_361 VGND VGND VPWR VPWR sky130_fd_sc_hd__decap_3
X_6226_ _2931_ _2861_ _2460_ VGND VGND VPWR VPWR _2932_ sky130_fd_sc_hd__mux2_1
XFILLER_0_0_570 VGND VGND VPWR VPWR sky130_fd_sc_hd__fill_2
X_9014_ clknet_leaf_92_clk _0111_ VGND VGND VPWR VPWR registers\[1\]\[22\] sky130_fd_sc_hd__dfxtp_1
X_6157_ _2258_ _2866_ VGND VGND VPWR VPWR _2867_ sky130_fd_sc_hd__nand2_1
X_5108_ _1771_ _1864_ _1778_ VGND VGND VPWR VPWR _1865_ sky130_fd_sc_hd__a21oi_1
XFILLER_0_57_91 VGND VGND VPWR VPWR sky130_fd_sc_hd__decap_8
XANTENNA__5499__A _2048_ VGND VGND VPWR VPWR sky130_fd_sc_hd__diode_2
X_6088_ _2777_ _2799_ _2801_ VGND VGND VPWR VPWR _2802_ sky130_fd_sc_hd__a21oi_1
XANTENNA__4869__S0 _1617_ VGND VGND VPWR VPWR sky130_fd_sc_hd__diode_2
X_5039_ _1691_ VGND VGND VPWR VPWR _1799_ sky130_fd_sc_hd__buf_4
XTAP_TAPCELL_ROW_28_627 VGND VPWR sky130_fd_sc_hd__tapvpwrvgnd_1
XFILLER_0_94_101 VGND VGND VPWR VPWR sky130_fd_sc_hd__decap_4
XTAP_TAPCELL_ROW_0_241 VGND VPWR sky130_fd_sc_hd__tapvpwrvgnd_1
XTAP_TAPCELL_ROW_0_252 VGND VPWR sky130_fd_sc_hd__tapvpwrvgnd_1
XTAP_TAPCELL_ROW_0_263 VGND VPWR sky130_fd_sc_hd__tapvpwrvgnd_1
XANTENNA__7188__A1 _3439_ VGND VGND VPWR VPWR sky130_fd_sc_hd__diode_2
XFILLER_0_95_668 VGND VGND VPWR VPWR sky130_fd_sc_hd__decap_4
XFILLER_0_94_112 VGND VGND VPWR VPWR sky130_fd_sc_hd__fill_2
XFILLER_0_79_197 VGND VGND VPWR VPWR sky130_fd_sc_hd__fill_2
XANTENNA__7918__S _3887_ VGND VGND VPWR VPWR sky130_fd_sc_hd__diode_2
XFILLER_0_82_307 VGND VGND VPWR VPWR sky130_fd_sc_hd__fill_1
XANTENNA__5294__S0 _1806_ VGND VGND VPWR VPWR sky130_fd_sc_hd__diode_2
X_8729_ clknet_leaf_82_clk _0850_ VGND VGND VPWR VPWR registers\[10\]\[25\] sky130_fd_sc_hd__dfxtp_1
XFILLER_0_106_623 VGND VGND VPWR VPWR sky130_fd_sc_hd__decap_8
XFILLER_0_90_340 VGND VGND VPWR VPWR sky130_fd_sc_hd__decap_8
XFILLER_0_63_554 VGND VGND VPWR VPWR sky130_fd_sc_hd__fill_2
XFILLER_0_8_670 VGND VGND VPWR VPWR sky130_fd_sc_hd__decap_3
XFILLER_0_63_598 VGND VGND VPWR VPWR sky130_fd_sc_hd__fill_2
XANTENNA__5962__A _1913_ VGND VGND VPWR VPWR sky130_fd_sc_hd__diode_2
XANTENNA__7653__S _3742_ VGND VGND VPWR VPWR sky130_fd_sc_hd__diode_2
XANTENNA__5371__B1 _1756_ VGND VGND VPWR VPWR sky130_fd_sc_hd__diode_2
XANTENNA__5349__S1 _2028_ VGND VGND VPWR VPWR sky130_fd_sc_hd__diode_2
Xoutput75 net75 VGND VGND VPWR VPWR alu_result[4] sky130_fd_sc_hd__buf_1
Xoutput53 net53 VGND VGND VPWR VPWR alu_result[13] sky130_fd_sc_hd__buf_1
Xoutput64 net64 VGND VGND VPWR VPWR alu_result[23] sky130_fd_sc_hd__buf_1
XTAP_TAPCELL_ROW_8_363 VGND VPWR sky130_fd_sc_hd__tapvpwrvgnd_1
XANTENNA__8484__S _4189_ VGND VGND VPWR VPWR sky130_fd_sc_hd__diode_2
Xoutput97 net97 VGND VGND VPWR VPWR rd1[24] sky130_fd_sc_hd__buf_1
Xoutput86 net86 VGND VGND VPWR VPWR rd1[14] sky130_fd_sc_hd__buf_1
XANTENNA_output124_A net124 VGND VGND VPWR VPWR sky130_fd_sc_hd__diode_2
XFILLER_0_98_462 VGND VGND VPWR VPWR sky130_fd_sc_hd__fill_2
XFILLER_0_86_624 VGND VGND VPWR VPWR sky130_fd_sc_hd__decap_4
XFILLER_0_58_315 VGND VGND VPWR VPWR sky130_fd_sc_hd__fill_2
XTAP_TAPCELL_ROW_55_980 VGND VPWR sky130_fd_sc_hd__tapvpwrvgnd_1
XFILLER_0_73_318 VGND VGND VPWR VPWR sky130_fd_sc_hd__fill_2
XANTENNA__5348__S _1756_ VGND VGND VPWR VPWR sky130_fd_sc_hd__diode_2
XANTENNA__8128__A0 _3020_ VGND VGND VPWR VPWR sky130_fd_sc_hd__diode_2
XFILLER_0_27_724 VGND VGND VPWR VPWR sky130_fd_sc_hd__fill_2
XANTENNA__7129__A net22 VGND VGND VPWR VPWR sky130_fd_sc_hd__diode_2
Xclkbuf_leaf_105_clk clknet_4_2_0_clk VGND VGND VPWR VPWR clknet_leaf_105_clk sky130_fd_sc_hd__clkbuf_8
XANTENNA__5037__S0 _1762_ VGND VGND VPWR VPWR sky130_fd_sc_hd__diode_2
XFILLER_0_54_598 VGND VGND VPWR VPWR sky130_fd_sc_hd__fill_2
XFILLER_0_14_418 VGND VGND VPWR VPWR sky130_fd_sc_hd__fill_2
XFILLER_0_14_429 VGND VGND VPWR VPWR sky130_fd_sc_hd__fill_2
X_4410_ _1202_ VGND VGND VPWR VPWR _1203_ sky130_fd_sc_hd__buf_4
XANTENNA__7351__A1 _3466_ VGND VGND VPWR VPWR sky130_fd_sc_hd__diode_2
XFILLER_0_78_24 VGND VGND VPWR VPWR sky130_fd_sc_hd__decap_4
XANTENNA__5872__A _1851_ VGND VGND VPWR VPWR sky130_fd_sc_hd__diode_2
XFILLER_0_111_125 VGND VGND VPWR VPWR sky130_fd_sc_hd__fill_2
XFILLER_0_78_57 VGND VGND VPWR VPWR sky130_fd_sc_hd__decap_4
XFILLER_0_1_312 VGND VGND VPWR VPWR sky130_fd_sc_hd__fill_2
XANTENNA__4260__S1 _1024_ VGND VGND VPWR VPWR sky130_fd_sc_hd__diode_2
X_5390_ _2076_ _2130_ _2026_ VGND VGND VPWR VPWR _2131_ sky130_fd_sc_hd__a21o_1
XANTENNA__5083__S _1767_ VGND VGND VPWR VPWR sky130_fd_sc_hd__diode_2
XFILLER_0_111_169 VGND VGND VPWR VPWR sky130_fd_sc_hd__decap_4
X_4341_ _1127_ VGND VGND VPWR VPWR _1137_ sky130_fd_sc_hd__buf_4
XTAP_TAPCELL_ROW_74_1223 VGND VPWR sky130_fd_sc_hd__tapvpwrvgnd_1
XANTENNA__6179__S net113 VGND VGND VPWR VPWR sky130_fd_sc_hd__diode_2
X_4272_ _1070_ VGND VGND VPWR VPWR _1071_ sky130_fd_sc_hd__inv_2
XFILLER_0_1_389 VGND VGND VPWR VPWR sky130_fd_sc_hd__fill_1
X_7060_ _3422_ VGND VGND VPWR VPWR _1006_ sky130_fd_sc_hd__clkbuf_1
X_6011_ _2720_ _2729_ VGND VGND VPWR VPWR _2730_ sky130_fd_sc_hd__or2_1
XANTENNA__5665__B2 _2399_ VGND VGND VPWR VPWR sky130_fd_sc_hd__diode_2
XANTENNA__8394__S _4139_ VGND VGND VPWR VPWR sky130_fd_sc_hd__diode_2
XFILLER_0_118_41 VPWR VGND VPWR VGND sky130_ef_sc_hd__decap_12
XFILLER_0_118_85 VPWR VGND VPWR VGND sky130_ef_sc_hd__decap_12
X_7962_ _3916_ VGND VGND VPWR VPWR _0390_ sky130_fd_sc_hd__clkbuf_1
XFILLER_0_89_462 VGND VGND VPWR VPWR sky130_fd_sc_hd__fill_1
X_6913_ _3343_ VGND VGND VPWR VPWR _0938_ sky130_fd_sc_hd__clkbuf_1
XFILLER_0_77_624 VGND VGND VPWR VPWR sky130_fd_sc_hd__fill_2
XFILLER_0_76_101 VGND VGND VPWR VPWR sky130_fd_sc_hd__decap_8
X_7893_ _3096_ registers\[27\]\[13\] _3876_ VGND VGND VPWR VPWR _3880_ sky130_fd_sc_hd__mux2_1
XANTENNA__7738__S _3793_ VGND VGND VPWR VPWR sky130_fd_sc_hd__diode_2
XTAP_TAPCELL_ROW_85_1363 VGND VPWR sky130_fd_sc_hd__tapvpwrvgnd_1
XFILLER_0_76_134 VGND VGND VPWR VPWR sky130_fd_sc_hd__decap_3
XANTENNA__5469__D _1337_ VGND VGND VPWR VPWR sky130_fd_sc_hd__diode_2
XFILLER_0_49_337 VGND VGND VPWR VPWR sky130_fd_sc_hd__fill_2
XANTENNA__6642__S _3197_ VGND VGND VPWR VPWR sky130_fd_sc_hd__diode_2
X_6844_ registers\[12\]\[17\] _2997_ _3299_ VGND VGND VPWR VPWR _3307_ sky130_fd_sc_hd__mux2_1
XANTENNA__5276__S0 _2020_ VGND VGND VPWR VPWR sky130_fd_sc_hd__diode_2
XFILLER_0_107_409 VGND VGND VPWR VPWR sky130_fd_sc_hd__fill_2
XFILLER_0_92_649 VGND VGND VPWR VPWR sky130_fd_sc_hd__fill_1
X_6775_ _3269_ VGND VGND VPWR VPWR _0874_ sky130_fd_sc_hd__clkbuf_1
XFILLER_0_76_189 VGND VGND VPWR VPWR sky130_fd_sc_hd__fill_2
XFILLER_0_45_510 VGND VGND VPWR VPWR sky130_fd_sc_hd__fill_2
X_9563_ clknet_leaf_100_clk _0660_ VGND VGND VPWR VPWR registers\[4\]\[27\] sky130_fd_sc_hd__dfxtp_1
X_5726_ _2200_ _2446_ _2458_ VGND VGND VPWR VPWR _2459_ sky130_fd_sc_hd__o21a_1
X_8514_ _4208_ VGND VGND VPWR VPWR _0650_ sky130_fd_sc_hd__clkbuf_1
X_9494_ clknet_leaf_93_clk _0591_ VGND VGND VPWR VPWR registers\[5\]\[22\] sky130_fd_sc_hd__dfxtp_1
XFILLER_0_17_223 VGND VGND VPWR VPWR sky130_fd_sc_hd__fill_1
XFILLER_0_17_234 VGND VGND VPWR VPWR sky130_fd_sc_hd__decap_3
XTAP_TAPCELL_ROW_33_685 VGND VPWR sky130_fd_sc_hd__tapvpwrvgnd_1
XANTENNA__5028__S0 _1705_ VGND VGND VPWR VPWR sky130_fd_sc_hd__diode_2
X_8445_ registers\[8\]\[17\] net24 _4164_ VGND VGND VPWR VPWR _4172_ sky130_fd_sc_hd__mux2_1
XFILLER_0_17_289 VGND VGND VPWR VPWR sky130_fd_sc_hd__decap_3
X_5657_ _2379_ _2391_ _1108_ VGND VGND VPWR VPWR _2392_ sky130_fd_sc_hd__mux2_1
XFILLER_0_60_546 VPWR VGND VPWR VGND sky130_ef_sc_hd__decap_12
XANTENNA__7473__S _3648_ VGND VGND VPWR VPWR sky130_fd_sc_hd__diode_2
XFILLER_0_4_150 VGND VGND VPWR VPWR sky130_fd_sc_hd__decap_3
X_5588_ net81 VGND VGND VPWR VPWR _2323_ sky130_fd_sc_hd__inv_2
X_8376_ _4135_ VGND VGND VPWR VPWR _0585_ sky130_fd_sc_hd__clkbuf_1
X_4608_ _1323_ VGND VGND VPWR VPWR _1390_ sky130_fd_sc_hd__buf_4
X_4539_ _1127_ VGND VGND VPWR VPWR _1324_ sky130_fd_sc_hd__buf_4
X_7327_ _3579_ VGND VGND VPWR VPWR _0092_ sky130_fd_sc_hd__clkbuf_1
X_7258_ registers\[18\]\[3\] _3441_ _3539_ VGND VGND VPWR VPWR _3543_ sky130_fd_sc_hd__mux2_1
XANTENNA__5200__S0 _1773_ VGND VGND VPWR VPWR sky130_fd_sc_hd__diode_2
XANTENNA__5656__A1 _2344_ VGND VGND VPWR VPWR sky130_fd_sc_hd__diode_2
X_6209_ net134 _2915_ VGND VGND VPWR VPWR _2916_ sky130_fd_sc_hd__xnor2_1
XTAP_TAPCELL_ROW_5_322 VGND VPWR sky130_fd_sc_hd__tapvpwrvgnd_1
XANTENNA__6817__S _3288_ VGND VGND VPWR VPWR sky130_fd_sc_hd__diode_2
X_7189_ _3506_ VGND VGND VPWR VPWR _0027_ sky130_fd_sc_hd__clkbuf_1
XANTENNA__4337__S _1132_ VGND VGND VPWR VPWR sky130_fd_sc_hd__diode_2
XFILLER_0_95_465 VGND VGND VPWR VPWR sky130_fd_sc_hd__fill_2
XFILLER_0_67_167 VGND VGND VPWR VPWR sky130_fd_sc_hd__fill_1
XFILLER_0_55_307 VGND VGND VPWR VPWR sky130_fd_sc_hd__fill_1
XANTENNA__4861__A _1618_ VGND VGND VPWR VPWR sky130_fd_sc_hd__diode_2
XFILLER_0_83_627 VGND VGND VPWR VPWR sky130_fd_sc_hd__fill_1
XFILLER_0_36_510 VGND VGND VPWR VPWR sky130_fd_sc_hd__decap_3
XANTENNA__4490__S1 _1204_ VGND VGND VPWR VPWR sky130_fd_sc_hd__diode_2
XFILLER_0_36_587 VGND VGND VPWR VPWR sky130_fd_sc_hd__fill_1
XANTENNA__6136__A2 _2840_ VGND VGND VPWR VPWR sky130_fd_sc_hd__diode_2
XANTENNA__5692__A _1660_ VGND VGND VPWR VPWR sky130_fd_sc_hd__diode_2
XFILLER_0_51_557 VGND VGND VPWR VPWR sky130_fd_sc_hd__decap_3
XANTENNA_clkbuf_leaf_5_clk_A clknet_4_1_0_clk VGND VGND VPWR VPWR sky130_fd_sc_hd__diode_2
XFILLER_0_2_109 VPWR VGND VPWR VGND sky130_ef_sc_hd__decap_12
XFILLER_0_23_248 VGND VGND VPWR VPWR sky130_fd_sc_hd__fill_2
XFILLER_0_106_486 VGND VGND VPWR VPWR sky130_fd_sc_hd__fill_2
XFILLER_0_48_38 VGND VGND VPWR VPWR sky130_fd_sc_hd__fill_2
XFILLER_0_101_180 VGND VGND VPWR VPWR sky130_fd_sc_hd__decap_3
XFILLER_0_3_18 VGND VGND VPWR VPWR sky130_fd_sc_hd__fill_2
XANTENNA__6727__S _3236_ VGND VGND VPWR VPWR sky130_fd_sc_hd__diode_2
XFILLER_0_64_37 VGND VGND VPWR VPWR sky130_fd_sc_hd__decap_6
XANTENNA__4247__S _1030_ VGND VGND VPWR VPWR sky130_fd_sc_hd__diode_2
XANTENNA__7558__S _3695_ VGND VGND VPWR VPWR sky130_fd_sc_hd__diode_2
XFILLER_0_59_635 VGND VGND VPWR VPWR sky130_fd_sc_hd__decap_6
XFILLER_0_74_616 VGND VGND VPWR VPWR sky130_fd_sc_hd__fill_2
XFILLER_0_74_605 VGND VGND VPWR VPWR sky130_fd_sc_hd__fill_2
X_4890_ registers\[0\]\[1\] registers\[1\]\[1\] registers\[2\]\[1\] registers\[3\]\[1\]
+ _1628_ _1629_ VGND VGND VPWR VPWR _1657_ sky130_fd_sc_hd__mux4_1
XFILLER_0_74_649 VGND VGND VPWR VPWR sky130_fd_sc_hd__fill_2
XFILLER_0_67_690 VGND VGND VPWR VPWR sky130_fd_sc_hd__decap_3
XTAP_TAPCELL_ROW_50_909 VGND VPWR sky130_fd_sc_hd__tapvpwrvgnd_1
XFILLER_0_46_329 VGND VGND VPWR VPWR sky130_fd_sc_hd__fill_1
XFILLER_0_46_318 VGND VGND VPWR VPWR sky130_fd_sc_hd__fill_2
XFILLER_0_117_729 VGND VGND VPWR VPWR sky130_fd_sc_hd__decap_4
X_6560_ _3153_ VGND VGND VPWR VPWR _0775_ sky130_fd_sc_hd__clkbuf_1
XFILLER_0_27_554 VGND VGND VPWR VPWR sky130_fd_sc_hd__decap_6
XTAP_TAPCELL_ROW_80_1293 VGND VPWR sky130_fd_sc_hd__tapvpwrvgnd_1
X_5511_ _2118_ _2213_ VGND VGND VPWR VPWR _2247_ sky130_fd_sc_hd__or2_1
XFILLER_0_54_373 VPWR VGND VPWR VGND sky130_ef_sc_hd__decap_12
XFILLER_0_6_437 VGND VGND VPWR VPWR sky130_fd_sc_hd__fill_2
XTAP_TAPCELL_ROW_30_644 VGND VPWR sky130_fd_sc_hd__tapvpwrvgnd_1
XTAP_TAPCELL_ROW_30_655 VGND VPWR sky130_fd_sc_hd__tapvpwrvgnd_1
XFILLER_0_54_395 VGND VGND VPWR VPWR sky130_fd_sc_hd__decap_4
XANTENNA__7324__A1 _3439_ VGND VGND VPWR VPWR sky130_fd_sc_hd__diode_2
X_6491_ _3068_ VGND VGND VPWR VPWR _3111_ sky130_fd_sc_hd__buf_4
XFILLER_0_112_434 VGND VGND VPWR VPWR sky130_fd_sc_hd__decap_6
X_8230_ _4058_ VGND VGND VPWR VPWR _0516_ sky130_fd_sc_hd__clkbuf_1
X_5442_ _2178_ _2179_ _1856_ VGND VGND VPWR VPWR _2180_ sky130_fd_sc_hd__mux2_1
X_8161_ registers\[9\]\[11\] _3458_ _4020_ VGND VGND VPWR VPWR _4022_ sky130_fd_sc_hd__mux2_1
XTAP_TAPCELL_ROW_10_390 VGND VPWR sky130_fd_sc_hd__tapvpwrvgnd_1
X_5373_ registers\[12\]\[26\] registers\[13\]\[26\] registers\[14\]\[26\] registers\[15\]\[26\]
+ _2020_ _2021_ VGND VGND VPWR VPWR _2115_ sky130_fd_sc_hd__mux4_1
X_8092_ _3985_ VGND VGND VPWR VPWR _0451_ sky130_fd_sc_hd__clkbuf_1
X_4324_ registers\[24\]\[4\] registers\[25\]\[4\] registers\[26\]\[4\] registers\[27\]\[4\]
+ _1111_ _1113_ VGND VGND VPWR VPWR _1120_ sky130_fd_sc_hd__mux4_1
X_7112_ _3454_ VGND VGND VPWR VPWR _0002_ sky130_fd_sc_hd__clkbuf_1
XFILLER_0_10_421 VGND VGND VPWR VPWR sky130_fd_sc_hd__fill_2
XFILLER_0_10_443 VGND VGND VPWR VPWR sky130_fd_sc_hd__fill_2
X_7043_ _3413_ VGND VGND VPWR VPWR _0998_ sky130_fd_sc_hd__clkbuf_1
XANTENNA__6637__S _3186_ VGND VGND VPWR VPWR sky130_fd_sc_hd__diode_2
X_4255_ a2[1] VGND VGND VPWR VPWR _1054_ sky130_fd_sc_hd__clkbuf_4
XFILLER_0_97_708 VPWR VGND VPWR VGND sky130_ef_sc_hd__decap_12
X_8994_ clknet_leaf_9_clk _0091_ VGND VGND VPWR VPWR registers\[1\]\[2\] sky130_fd_sc_hd__dfxtp_1
XTAP_TAPCELL_ROW_38_755 VGND VPWR sky130_fd_sc_hd__tapvpwrvgnd_1
XPHY_EDGE_ROW_118_Right_118 VGND VGND VPWR VPWR sky130_fd_sc_hd__decap_3
X_7945_ _3907_ VGND VGND VPWR VPWR _0382_ sky130_fd_sc_hd__clkbuf_1
XFILLER_0_54_92 VGND VGND VPWR VPWR sky130_fd_sc_hd__fill_2
X_7876_ _3079_ registers\[27\]\[5\] _3865_ VGND VGND VPWR VPWR _3871_ sky130_fd_sc_hd__mux2_1
XFILLER_0_49_156 VGND VGND VPWR VPWR sky130_fd_sc_hd__decap_3
XFILLER_0_49_134 VGND VGND VPWR VPWR sky130_fd_sc_hd__decap_3
XFILLER_0_37_307 VGND VGND VPWR VPWR sky130_fd_sc_hd__fill_1
XFILLER_0_108_707 VGND VGND VPWR VPWR sky130_fd_sc_hd__fill_1
XFILLER_0_92_413 VGND VGND VPWR VPWR sky130_fd_sc_hd__fill_2
X_6827_ registers\[12\]\[9\] _2980_ _3288_ VGND VGND VPWR VPWR _3298_ sky130_fd_sc_hd__mux2_1
XFILLER_0_65_638 VGND VGND VPWR VPWR sky130_fd_sc_hd__fill_1
XFILLER_0_9_220 VGND VGND VPWR VPWR sky130_fd_sc_hd__fill_1
XTAP_TAPCELL_ROW_18_490 VGND VPWR sky130_fd_sc_hd__tapvpwrvgnd_1
XFILLER_0_18_510 VGND VGND VPWR VPWR sky130_fd_sc_hd__fill_2
X_9546_ clknet_leaf_41_clk _0643_ VGND VGND VPWR VPWR registers\[4\]\[10\] sky130_fd_sc_hd__dfxtp_1
XFILLER_0_80_608 VGND VGND VPWR VPWR sky130_fd_sc_hd__decap_6
X_6758_ _3260_ VGND VGND VPWR VPWR _0866_ sky130_fd_sc_hd__clkbuf_1
XFILLER_0_9_297 VGND VGND VPWR VPWR sky130_fd_sc_hd__fill_2
XFILLER_0_18_587 VGND VGND VPWR VPWR sky130_fd_sc_hd__fill_1
X_9477_ clknet_leaf_32_clk _0574_ VGND VGND VPWR VPWR registers\[5\]\[5\] sky130_fd_sc_hd__dfxtp_1
XTAP_TAPCELL_ROW_98_1532 VGND VPWR sky130_fd_sc_hd__tapvpwrvgnd_1
XANTENNA__8299__S _4092_ VGND VGND VPWR VPWR sky130_fd_sc_hd__diode_2
X_6689_ registers\[10\]\[9\] _2980_ _3214_ VGND VGND VPWR VPWR _3224_ sky130_fd_sc_hd__mux2_1
X_5709_ _2232_ _2240_ _2242_ _2247_ _1071_ net113 VGND VGND VPWR VPWR _2442_ sky130_fd_sc_hd__mux4_1
XFILLER_0_103_423 VGND VGND VPWR VPWR sky130_fd_sc_hd__decap_3
XFILLER_0_103_412 VGND VGND VPWR VPWR sky130_fd_sc_hd__decap_4
X_8428_ registers\[8\]\[9\] net47 _4153_ VGND VGND VPWR VPWR _4163_ sky130_fd_sc_hd__mux2_1
XANTENNA__5412__A1_N _1977_ VGND VGND VPWR VPWR sky130_fd_sc_hd__diode_2
X_8359_ _4126_ VGND VGND VPWR VPWR _0577_ sky130_fd_sc_hd__clkbuf_1
XANTENNA__5421__S0 _2119_ VGND VGND VPWR VPWR sky130_fd_sc_hd__diode_2
XANTENNA__5629__A1 net138 VGND VGND VPWR VPWR sky130_fd_sc_hd__diode_2
XFILLER_0_88_719 VGND VGND VPWR VPWR sky130_fd_sc_hd__decap_3
XTAP_TAPCELL_ROW_107_1650 VGND VPWR sky130_fd_sc_hd__tapvpwrvgnd_1
XFILLER_0_68_421 VGND VGND VPWR VPWR sky130_fd_sc_hd__decap_4
XANTENNA__7378__S _3597_ VGND VGND VPWR VPWR sky130_fd_sc_hd__diode_2
XANTENNA__5262__C1 _1778_ VGND VGND VPWR VPWR sky130_fd_sc_hd__diode_2
XFILLER_0_95_273 VGND VGND VPWR VPWR sky130_fd_sc_hd__decap_3
XFILLER_0_56_616 VGND VGND VPWR VPWR sky130_fd_sc_hd__fill_2
XFILLER_0_83_468 VGND VGND VPWR VPWR sky130_fd_sc_hd__fill_2
XANTENNA__7306__A1 _3489_ VGND VGND VPWR VPWR sky130_fd_sc_hd__diode_2
XFILLER_0_106_272 VGND VGND VPWR VPWR sky130_fd_sc_hd__fill_2
XTAP_TAPCELL_ROW_58_1015 VGND VPWR sky130_fd_sc_hd__tapvpwrvgnd_1
XANTENNA__8002__S _3937_ VGND VGND VPWR VPWR sky130_fd_sc_hd__diode_2
XFILLER_0_24_568 VGND VGND VPWR VPWR sky130_fd_sc_hd__fill_2
XTAP_TAPCELL_ROW_118_1790 VGND VPWR sky130_fd_sc_hd__tapvpwrvgnd_1
XFILLER_0_75_36 VGND VGND VPWR VPWR sky130_fd_sc_hd__fill_2
XANTENNA__6457__S _3069_ VGND VGND VPWR VPWR sky130_fd_sc_hd__diode_2
XANTENNA__6293__A1 _2985_ VGND VGND VPWR VPWR sky130_fd_sc_hd__diode_2
XFILLER_0_79_708 VGND VGND VPWR VPWR sky130_fd_sc_hd__fill_1
XANTENNA__6045__A1 _2399_ VGND VGND VPWR VPWR sky130_fd_sc_hd__diode_2
XFILLER_0_99_590 VGND VGND VPWR VPWR sky130_fd_sc_hd__fill_1
XFILLER_0_91_57 VGND VGND VPWR VPWR sky130_fd_sc_hd__fill_2
XTAP_TAPCELL_ROW_69_1155 VGND VPWR sky130_fd_sc_hd__tapvpwrvgnd_1
X_5991_ _2704_ _2710_ VGND VGND VPWR VPWR _2711_ sky130_fd_sc_hd__and2b_1
XFILLER_0_59_421 VGND VGND VPWR VPWR sky130_fd_sc_hd__fill_2
XTAP_TAPCELL_ROW_35_714 VGND VPWR sky130_fd_sc_hd__tapvpwrvgnd_1
XTAP_TAPCELL_ROW_82_1322 VGND VPWR sky130_fd_sc_hd__tapvpwrvgnd_1
X_4942_ _1643_ VGND VGND VPWR VPWR _1706_ sky130_fd_sc_hd__buf_4
XANTENNA__4705__S _1421_ VGND VGND VPWR VPWR sky130_fd_sc_hd__diode_2
X_7730_ _3065_ registers\[25\]\[0\] _3793_ VGND VGND VPWR VPWR _3794_ sky130_fd_sc_hd__mux2_1
XFILLER_0_115_86 VGND VGND VPWR VPWR sky130_fd_sc_hd__decap_3
XFILLER_0_86_262 VGND VGND VPWR VPWR sky130_fd_sc_hd__decap_4
XFILLER_0_86_273 VGND VGND VPWR VPWR sky130_fd_sc_hd__fill_2
XFILLER_0_46_115 VGND VGND VPWR VPWR sky130_fd_sc_hd__fill_2
X_7661_ _3756_ VGND VGND VPWR VPWR _3757_ sky130_fd_sc_hd__clkbuf_8
XFILLER_0_19_318 VGND VGND VPWR VPWR sky130_fd_sc_hd__decap_3
X_6612_ registers\[0\]\[6\] _2974_ _3175_ VGND VGND VPWR VPWR _3182_ sky130_fd_sc_hd__mux2_1
X_9400_ clknet_leaf_89_clk _0497_ VGND VGND VPWR VPWR registers\[9\]\[24\] sky130_fd_sc_hd__dfxtp_1
XTAP_TAPCELL_ROW_15_460 VGND VPWR sky130_fd_sc_hd__tapvpwrvgnd_1
X_4873_ _1616_ _1626_ _1635_ _1640_ VGND VGND VPWR VPWR _1641_ sky130_fd_sc_hd__o22a_2
XFILLER_0_117_548 VGND VGND VPWR VPWR sky130_fd_sc_hd__decap_3
XANTENNA__4454__S1 _1112_ VGND VGND VPWR VPWR sky130_fd_sc_hd__diode_2
X_7592_ _3719_ VGND VGND VPWR VPWR _3720_ sky130_fd_sc_hd__clkbuf_8
X_6543_ _3144_ VGND VGND VPWR VPWR _0767_ sky130_fd_sc_hd__clkbuf_1
XFILLER_0_104_209 VPWR VGND VPWR VGND sky130_ef_sc_hd__decap_12
X_9331_ clknet_leaf_14_clk _0428_ VGND VGND VPWR VPWR registers\[2\]\[19\] sky130_fd_sc_hd__dfxtp_1
XFILLER_0_40_61 VGND VGND VPWR VPWR sky130_fd_sc_hd__fill_2
XFILLER_0_15_535 VGND VGND VPWR VPWR sky130_fd_sc_hd__fill_2
XFILLER_0_27_384 VGND VGND VPWR VPWR sky130_fd_sc_hd__decap_8
X_6474_ _3099_ VGND VGND VPWR VPWR _0743_ sky130_fd_sc_hd__clkbuf_1
X_9262_ clknet_leaf_38_clk _0359_ VGND VGND VPWR VPWR registers\[27\]\[14\] sky130_fd_sc_hd__dfxtp_1
XFILLER_0_113_721 VGND VGND VPWR VPWR sky130_fd_sc_hd__decap_6
XANTENNA__4440__S _1034_ VGND VGND VPWR VPWR sky130_fd_sc_hd__diode_2
XFILLER_0_42_365 VGND VGND VPWR VPWR sky130_fd_sc_hd__decap_3
XFILLER_0_112_242 VGND VGND VPWR VPWR sky130_fd_sc_hd__fill_2
X_8213_ _4049_ VGND VGND VPWR VPWR _0508_ sky130_fd_sc_hd__clkbuf_1
XFILLER_0_42_387 VGND VGND VPWR VPWR sky130_fd_sc_hd__fill_1
XFILLER_0_42_376 VGND VGND VPWR VPWR sky130_fd_sc_hd__fill_2
XPHY_EDGE_ROW_12_Right_12 VGND VGND VPWR VPWR sky130_fd_sc_hd__decap_3
X_5425_ registers\[4\]\[29\] registers\[5\]\[29\] registers\[6\]\[29\] registers\[7\]\[29\]
+ _2126_ _2127_ VGND VGND VPWR VPWR _2164_ sky130_fd_sc_hd__mux4_1
XANTENNA__7751__S _3804_ VGND VGND VPWR VPWR sky130_fd_sc_hd__diode_2
XFILLER_0_112_253 VGND VGND VPWR VPWR sky130_fd_sc_hd__decap_3
XFILLER_0_64_3 VGND VGND VPWR VPWR sky130_fd_sc_hd__fill_2
X_9193_ clknet_leaf_9_clk _0290_ VGND VGND VPWR VPWR registers\[25\]\[9\] sky130_fd_sc_hd__dfxtp_1
XFILLER_0_2_462 VGND VGND VPWR VPWR sky130_fd_sc_hd__decap_3
XFILLER_0_2_451 VGND VGND VPWR VPWR sky130_fd_sc_hd__fill_2
XTAP_TAPCELL_ROW_93_1473 VGND VPWR sky130_fd_sc_hd__tapvpwrvgnd_1
XTAP_TAPCELL_ROW_93_1462 VGND VPWR sky130_fd_sc_hd__tapvpwrvgnd_1
X_8144_ registers\[9\]\[3\] _3441_ _4009_ VGND VGND VPWR VPWR _4013_ sky130_fd_sc_hd__mux2_1
X_5356_ _2031_ _2098_ _1756_ VGND VGND VPWR VPWR _2099_ sky130_fd_sc_hd__a21o_1
XANTENNA__6367__S _3030_ VGND VGND VPWR VPWR sky130_fd_sc_hd__diode_2
X_4307_ _1102_ _1103_ net6 VGND VGND VPWR VPWR _1104_ sky130_fd_sc_hd__mux2_1
XANTENNA__4676__A _1454_ VGND VGND VPWR VPWR sky130_fd_sc_hd__diode_2
X_5287_ _1960_ _2018_ _2025_ _2033_ VGND VGND VPWR VPWR _2034_ sky130_fd_sc_hd__a2bb2o_4
XANTENNA__5271__S _1756_ VGND VGND VPWR VPWR sky130_fd_sc_hd__diode_2
X_8075_ _3976_ VGND VGND VPWR VPWR _0443_ sky130_fd_sc_hd__clkbuf_1
X_7026_ _3404_ VGND VGND VPWR VPWR _0990_ sky130_fd_sc_hd__clkbuf_1
X_4238_ _1034_ _1037_ VGND VGND VPWR VPWR _1038_ sky130_fd_sc_hd__nand2_1
XFILLER_0_4_50 VGND VGND VPWR VPWR sky130_fd_sc_hd__decap_4
XFILLER_0_97_505 VGND VGND VPWR VPWR sky130_fd_sc_hd__fill_2
XFILLER_0_69_218 VGND VGND VPWR VPWR sky130_fd_sc_hd__decap_4
XANTENNA__6036__A1 _1979_ VGND VGND VPWR VPWR sky130_fd_sc_hd__diode_2
Xclkbuf_leaf_94_clk clknet_4_9_0_clk VGND VGND VPWR VPWR clknet_leaf_94_clk sky130_fd_sc_hd__clkbuf_8
X_8977_ clknet_leaf_55_clk _0074_ VGND VGND VPWR VPWR registers\[18\]\[17\] sky130_fd_sc_hd__dfxtp_1
XFILLER_0_97_538 VGND VGND VPWR VPWR sky130_fd_sc_hd__fill_2
XANTENNA__7198__S _3503_ VGND VGND VPWR VPWR sky130_fd_sc_hd__diode_2
XPHY_EDGE_ROW_21_Right_21 VGND VGND VPWR VPWR sky130_fd_sc_hd__decap_3
X_7928_ _3131_ registers\[27\]\[30\] _3864_ VGND VGND VPWR VPWR _3898_ sky130_fd_sc_hd__mux2_1
XANTENNA__4693__S1 _1321_ VGND VGND VPWR VPWR sky130_fd_sc_hd__diode_2
XFILLER_0_92_232 VGND VGND VPWR VPWR sky130_fd_sc_hd__decap_3
X_7859_ _3861_ VGND VGND VPWR VPWR _0342_ sky130_fd_sc_hd__clkbuf_1
XANTENNA__7926__S _3887_ VGND VGND VPWR VPWR sky130_fd_sc_hd__diode_2
XFILLER_0_37_137 VGND VGND VPWR VPWR sky130_fd_sc_hd__fill_2
XFILLER_0_108_537 VGND VGND VPWR VPWR sky130_fd_sc_hd__decap_6
XTAP_TAPCELL_ROW_102_1591 VGND VPWR sky130_fd_sc_hd__tapvpwrvgnd_1
XTAP_TAPCELL_ROW_102_1580 VGND VPWR sky130_fd_sc_hd__tapvpwrvgnd_1
XANTENNA__6830__S _3299_ VGND VGND VPWR VPWR sky130_fd_sc_hd__diode_2
XFILLER_0_80_416 VGND VGND VPWR VPWR sky130_fd_sc_hd__fill_2
XANTENNA__4445__S1 _1112_ VGND VGND VPWR VPWR sky130_fd_sc_hd__diode_2
X_9529_ clknet_leaf_82_clk _0626_ VGND VGND VPWR VPWR registers\[8\]\[25\] sky130_fd_sc_hd__dfxtp_1
XFILLER_0_61_663 VGND VGND VPWR VPWR sky130_fd_sc_hd__fill_1
XFILLER_0_61_652 VGND VGND VPWR VPWR sky130_fd_sc_hd__fill_2
XFILLER_0_61_641 VGND VGND VPWR VPWR sky130_fd_sc_hd__fill_1
XFILLER_0_21_505 VGND VGND VPWR VPWR sky130_fd_sc_hd__fill_1
XPHY_EDGE_ROW_30_Right_30 VGND VGND VPWR VPWR sky130_fd_sc_hd__decap_3
XFILLER_0_33_332 VGND VGND VPWR VPWR sky130_fd_sc_hd__fill_2
XFILLER_0_61_685 VGND VGND VPWR VPWR sky130_fd_sc_hd__decap_4
XANTENNA__6277__S _2962_ VGND VGND VPWR VPWR sky130_fd_sc_hd__diode_2
XANTENNA_input48_A we3 VGND VGND VPWR VPWR sky130_fd_sc_hd__diode_2
XFILLER_0_45_28 VGND VGND VPWR VPWR sky130_fd_sc_hd__decap_4
XFILLER_0_45_17 VGND VGND VPWR VPWR sky130_fd_sc_hd__fill_2
XANTENNA__4286__B1 _1024_ VGND VGND VPWR VPWR sky130_fd_sc_hd__diode_2
XANTENNA__8492__S _4189_ VGND VGND VPWR VPWR sky130_fd_sc_hd__diode_2
Xclkbuf_leaf_85_clk clknet_4_8_0_clk VGND VGND VPWR VPWR clknet_leaf_85_clk sky130_fd_sc_hd__clkbuf_8
XANTENNA__5786__B1 _2515_ VGND VGND VPWR VPWR sky130_fd_sc_hd__diode_2
XFILLER_0_61_16 VGND VGND VPWR VPWR sky130_fd_sc_hd__decap_4
XFILLER_0_96_582 VGND VGND VPWR VPWR sky130_fd_sc_hd__fill_2
XFILLER_0_84_711 VGND VGND VPWR VPWR sky130_fd_sc_hd__fill_1
XFILLER_0_61_38 VGND VGND VPWR VPWR sky130_fd_sc_hd__fill_2
XFILLER_0_61_27 VGND VGND VPWR VPWR sky130_fd_sc_hd__fill_2
XFILLER_0_56_413 VGND VGND VPWR VPWR sky130_fd_sc_hd__fill_2
XANTENNA__5210__A _1677_ VGND VGND VPWR VPWR sky130_fd_sc_hd__diode_2
XANTENNA__4684__S1 _1419_ VGND VGND VPWR VPWR sky130_fd_sc_hd__diode_2
XPHY_EDGE_ROW_14_Left_134 VGND VGND VPWR VPWR sky130_fd_sc_hd__decap_3
XFILLER_0_96_593 VGND VGND VPWR VPWR sky130_fd_sc_hd__fill_2
XFILLER_0_83_232 VGND VGND VPWR VPWR sky130_fd_sc_hd__fill_2
XFILLER_0_83_221 VGND VGND VPWR VPWR sky130_fd_sc_hd__decap_3
XTAP_TAPCELL_ROW_64_1085 VGND VPWR sky130_fd_sc_hd__tapvpwrvgnd_1
XFILLER_0_28_126 VGND VGND VPWR VPWR sky130_fd_sc_hd__decap_3
XFILLER_0_29_649 VGND VGND VPWR VPWR sky130_fd_sc_hd__fill_1
XTAP_TAPCELL_ROW_64_1096 VGND VPWR sky130_fd_sc_hd__tapvpwrvgnd_1
XFILLER_0_44_619 VGND VGND VPWR VPWR sky130_fd_sc_hd__fill_1
XFILLER_0_37_671 VGND VGND VPWR VPWR sky130_fd_sc_hd__fill_1
XFILLER_0_114_529 VGND VGND VPWR VPWR sky130_fd_sc_hd__decap_3
XFILLER_0_101_22 VGND VGND VPWR VPWR sky130_fd_sc_hd__fill_2
XFILLER_0_101_11 VGND VGND VPWR VPWR sky130_fd_sc_hd__fill_2
XTAP_TAPCELL_ROW_40_783 VGND VPWR sky130_fd_sc_hd__tapvpwrvgnd_1
XFILLER_0_24_365 VGND VGND VPWR VPWR sky130_fd_sc_hd__fill_2
XFILLER_0_101_99 VGND VGND VPWR VPWR sky130_fd_sc_hd__fill_2
X_5210_ _1677_ VGND VGND VPWR VPWR _1960_ sky130_fd_sc_hd__clkbuf_8
XPHY_EDGE_ROW_23_Left_143 VGND VGND VPWR VPWR sky130_fd_sc_hd__decap_3
XANTENNA__7571__S _3706_ VGND VGND VPWR VPWR sky130_fd_sc_hd__diode_2
XFILLER_0_86_24 VGND VGND VPWR VPWR sky130_fd_sc_hd__fill_2
X_6190_ _2321_ _2897_ _2467_ VGND VGND VPWR VPWR _2898_ sky130_fd_sc_hd__a21o_1
X_5141_ registers\[0\]\[13\] registers\[1\]\[13\] registers\[2\]\[13\] registers\[3\]\[13\]
+ _1748_ _1749_ VGND VGND VPWR VPWR _1896_ sky130_fd_sc_hd__mux4_1
XANTENNA__5091__S _1746_ VGND VGND VPWR VPWR sky130_fd_sc_hd__diode_2
X_5072_ registers\[8\]\[9\] registers\[9\]\[9\] registers\[10\]\[9\] registers\[11\]\[9\]
+ _1762_ _1764_ VGND VGND VPWR VPWR _1831_ sky130_fd_sc_hd__mux4_1
X_8900_ clknet_leaf_29_clk _1021_ VGND VGND VPWR VPWR registers\[16\]\[4\] sky130_fd_sc_hd__dfxtp_1
XFILLER_0_79_505 VGND VGND VPWR VPWR sky130_fd_sc_hd__fill_2
Xclkbuf_leaf_76_clk clknet_4_11_0_clk VGND VGND VPWR VPWR clknet_leaf_76_clk sky130_fd_sc_hd__clkbuf_8
XANTENNA_clkbuf_leaf_92_clk_A clknet_4_9_0_clk VGND VGND VPWR VPWR sky130_fd_sc_hd__diode_2
X_8831_ clknet_leaf_2_clk _0952_ VGND VGND VPWR VPWR registers\[13\]\[31\] sky130_fd_sc_hd__dfxtp_1
XFILLER_0_35_50 VGND VGND VPWR VPWR sky130_fd_sc_hd__decap_4
XFILLER_0_35_61 VGND VGND VPWR VPWR sky130_fd_sc_hd__fill_2
XANTENNA__6216__A net138 VGND VGND VPWR VPWR sky130_fd_sc_hd__diode_2
XTAP_TAPCELL_ROW_48_883 VGND VPWR sky130_fd_sc_hd__tapvpwrvgnd_1
X_8762_ clknet_leaf_90_clk _0883_ VGND VGND VPWR VPWR registers\[11\]\[26\] sky130_fd_sc_hd__dfxtp_1
XPHY_EDGE_ROW_32_Left_152 VGND VGND VPWR VPWR sky130_fd_sc_hd__decap_3
X_5974_ net124 _2417_ VGND VGND VPWR VPWR _2694_ sky130_fd_sc_hd__nor2_1
XFILLER_0_59_251 VGND VGND VPWR VPWR sky130_fd_sc_hd__fill_2
XFILLER_0_47_402 VGND VGND VPWR VPWR sky130_fd_sc_hd__fill_2
X_7713_ _3784_ VGND VGND VPWR VPWR _0273_ sky130_fd_sc_hd__clkbuf_1
X_4925_ _1628_ VGND VGND VPWR VPWR _1690_ sky130_fd_sc_hd__buf_6
XANTENNA__7746__S _3793_ VGND VGND VPWR VPWR sky130_fd_sc_hd__diode_2
XFILLER_0_47_446 VGND VGND VPWR VPWR sky130_fd_sc_hd__fill_2
X_8693_ clknet_leaf_83_clk _0814_ VGND VGND VPWR VPWR registers\[0\]\[21\] sky130_fd_sc_hd__dfxtp_1
XFILLER_0_90_725 VGND VGND VPWR VPWR sky130_fd_sc_hd__fill_2
X_4856_ registers\[24\]\[0\] registers\[25\]\[0\] registers\[26\]\[0\] registers\[27\]\[0\]
+ net1 net2 VGND VGND VPWR VPWR _1624_ sky130_fd_sc_hd__mux4_1
XANTENNA__6650__S _3197_ VGND VGND VPWR VPWR sky130_fd_sc_hd__diode_2
X_7644_ _3747_ VGND VGND VPWR VPWR _0241_ sky130_fd_sc_hd__clkbuf_1
XFILLER_0_34_107 VGND VGND VPWR VPWR sky130_fd_sc_hd__fill_2
XFILLER_0_117_356 VGND VGND VPWR VPWR sky130_fd_sc_hd__fill_2
XFILLER_0_117_345 VGND VGND VPWR VPWR sky130_fd_sc_hd__fill_2
XANTENNA_clkbuf_leaf_30_clk_A clknet_4_5_0_clk VGND VGND VPWR VPWR sky130_fd_sc_hd__diode_2
XFILLER_0_51_82 VGND VGND VPWR VPWR sky130_fd_sc_hd__fill_1
XFILLER_0_43_630 VGND VGND VPWR VPWR sky130_fd_sc_hd__fill_2
X_7575_ _3119_ registers\[22\]\[24\] _3706_ VGND VGND VPWR VPWR _3711_ sky130_fd_sc_hd__mux2_1
XFILLER_0_34_118 VGND VGND VPWR VPWR sky130_fd_sc_hd__fill_1
XFILLER_0_43_641 VGND VGND VPWR VPWR sky130_fd_sc_hd__decap_3
X_9314_ clknet_leaf_3_clk _0411_ VGND VGND VPWR VPWR registers\[2\]\[2\] sky130_fd_sc_hd__dfxtp_1
X_4787_ _1557_ _1558_ _1513_ VGND VGND VPWR VPWR _1559_ sky130_fd_sc_hd__mux2_1
X_6526_ _3134_ VGND VGND VPWR VPWR _0760_ sky130_fd_sc_hd__clkbuf_1
XFILLER_0_42_151 VGND VGND VPWR VPWR sky130_fd_sc_hd__fill_2
XPHY_EDGE_ROW_41_Left_161 VGND VGND VPWR VPWR sky130_fd_sc_hd__decap_3
XFILLER_0_113_584 VGND VGND VPWR VPWR sky130_fd_sc_hd__decap_3
X_6457_ _3087_ registers\[29\]\[9\] _3069_ VGND VGND VPWR VPWR _3088_ sky130_fd_sc_hd__mux2_1
X_9245_ clknet_leaf_103_clk _0342_ VGND VGND VPWR VPWR registers\[26\]\[29\] sky130_fd_sc_hd__dfxtp_1
Xclkload80 clknet_leaf_84_clk VGND VGND VPWR VPWR clkload80/Y sky130_fd_sc_hd__clkinv_4
X_6388_ registers\[3\]\[14\] _2991_ _3041_ VGND VGND VPWR VPWR _3046_ sky130_fd_sc_hd__mux2_1
XFILLER_0_100_234 VGND VGND VPWR VPWR sky130_fd_sc_hd__fill_2
XFILLER_0_100_201 VGND VGND VPWR VPWR sky130_fd_sc_hd__fill_2
XANTENNA_clkbuf_leaf_45_clk_A clknet_4_6_0_clk VGND VGND VPWR VPWR sky130_fd_sc_hd__diode_2
Xclkload91 clknet_leaf_66_clk VGND VGND VPWR VPWR clkload91/Y sky130_fd_sc_hd__clkinv_1
X_9176_ clknet_leaf_85_clk _0273_ VGND VGND VPWR VPWR registers\[24\]\[24\] sky130_fd_sc_hd__dfxtp_1
X_5408_ registers\[4\]\[28\] registers\[5\]\[28\] registers\[6\]\[28\] registers\[7\]\[28\]
+ _2072_ _2073_ VGND VGND VPWR VPWR _2148_ sky130_fd_sc_hd__mux4_1
X_5339_ _2019_ _2082_ _1960_ VGND VGND VPWR VPWR _2083_ sky130_fd_sc_hd__o21ai_1
X_8127_ _4003_ VGND VGND VPWR VPWR _0468_ sky130_fd_sc_hd__clkbuf_1
XFILLER_0_100_289 VGND VGND VPWR VPWR sky130_fd_sc_hd__fill_2
X_8058_ registers\[2\]\[27\] _3491_ _3959_ VGND VGND VPWR VPWR _3967_ sky130_fd_sc_hd__mux2_1
XANTENNA__6825__S _3288_ VGND VGND VPWR VPWR sky130_fd_sc_hd__diode_2
Xclkbuf_leaf_67_clk clknet_4_14_0_clk VGND VGND VPWR VPWR clknet_leaf_67_clk sky130_fd_sc_hd__clkbuf_8
XPHY_EDGE_ROW_50_Left_170 VGND VGND VPWR VPWR sky130_fd_sc_hd__decap_3
X_7009_ _3394_ VGND VGND VPWR VPWR _0983_ sky130_fd_sc_hd__clkbuf_1
XFILLER_0_97_335 VGND VGND VPWR VPWR sky130_fd_sc_hd__fill_1
XANTENNA_clkbuf_leaf_103_clk_A clknet_4_8_0_clk VGND VGND VPWR VPWR sky130_fd_sc_hd__diode_2
XANTENNA__4345__S _1140_ VGND VGND VPWR VPWR sky130_fd_sc_hd__diode_2
XANTENNA__5030__A _1687_ VGND VGND VPWR VPWR sky130_fd_sc_hd__diode_2
XANTENNA__4666__S1 _1159_ VGND VGND VPWR VPWR sky130_fd_sc_hd__diode_2
XFILLER_0_78_593 VGND VGND VPWR VPWR sky130_fd_sc_hd__fill_2
XFILLER_0_108_334 VGND VGND VPWR VPWR sky130_fd_sc_hd__decap_3
XFILLER_0_81_714 VGND VGND VPWR VPWR sky130_fd_sc_hd__decap_4
XANTENNA__8182__A1 _3479_ VGND VGND VPWR VPWR sky130_fd_sc_hd__diode_2
XTAP_TAPCELL_ROW_26_599 VGND VPWR sky130_fd_sc_hd__tapvpwrvgnd_1
XFILLER_0_31_19 VGND VGND VPWR VPWR sky130_fd_sc_hd__fill_2
XFILLER_0_108_356 VGND VGND VPWR VPWR sky130_fd_sc_hd__fill_2
XANTENNA__4418__S1 _1202_ VGND VGND VPWR VPWR sky130_fd_sc_hd__diode_2
XFILLER_0_53_449 VGND VGND VPWR VPWR sky130_fd_sc_hd__fill_1
XFILLER_0_19_671 VGND VGND VPWR VPWR sky130_fd_sc_hd__fill_1
XFILLER_0_19_693 VGND VGND VPWR VPWR sky130_fd_sc_hd__fill_2
XFILLER_0_61_471 VGND VGND VPWR VPWR sky130_fd_sc_hd__decap_4
XFILLER_0_104_551 VGND VGND VPWR VPWR sky130_fd_sc_hd__fill_2
XFILLER_0_0_218 VGND VGND VPWR VPWR sky130_fd_sc_hd__decap_6
XFILLER_0_0_207 VGND VGND VPWR VPWR sky130_fd_sc_hd__fill_2
XANTENNA__7391__S _3612_ VGND VGND VPWR VPWR sky130_fd_sc_hd__diode_2
XTAP_TAPCELL_ROW_115_1760 VGND VPWR sky130_fd_sc_hd__tapvpwrvgnd_1
XFILLER_0_104_584 VGND VGND VPWR VPWR sky130_fd_sc_hd__fill_2
XFILLER_0_56_16 VGND VGND VPWR VPWR sky130_fd_sc_hd__fill_2
Xclkbuf_leaf_58_clk clknet_4_15_0_clk VGND VGND VPWR VPWR clknet_leaf_58_clk sky130_fd_sc_hd__clkbuf_8
XFILLER_0_88_324 VGND VGND VPWR VPWR sky130_fd_sc_hd__fill_2
Xclkbuf_4_11_0_clk clknet_0_clk VGND VGND VPWR VPWR clknet_4_11_0_clk sky130_fd_sc_hd__clkbuf_8
XTAP_TAPCELL_ROW_66_1114 VGND VPWR sky130_fd_sc_hd__tapvpwrvgnd_1
XTAP_TAPCELL_ROW_45_842 VGND VPWR sky130_fd_sc_hd__tapvpwrvgnd_1
XFILLER_0_29_413 VGND VGND VPWR VPWR sky130_fd_sc_hd__fill_2
XFILLER_0_8_318 VGND VGND VPWR VPWR sky130_fd_sc_hd__decap_4
XFILLER_0_29_435 VGND VGND VPWR VPWR sky130_fd_sc_hd__fill_2
XANTENNA__6470__S _3090_ VGND VGND VPWR VPWR sky130_fd_sc_hd__diode_2
XFILLER_0_84_563 VGND VGND VPWR VPWR sky130_fd_sc_hd__decap_4
XANTENNA__8173__A1 _3470_ VGND VGND VPWR VPWR sky130_fd_sc_hd__diode_2
X_5690_ _2295_ _2423_ VGND VGND VPWR VPWR _2424_ sky130_fd_sc_hd__xnor2_2
X_4710_ registers\[28\]\[24\] registers\[29\]\[24\] registers\[30\]\[24\] registers\[31\]\[24\]
+ _1418_ _1419_ VGND VGND VPWR VPWR _1486_ sky130_fd_sc_hd__mux4_1
XFILLER_0_71_213 VGND VGND VPWR VPWR sky130_fd_sc_hd__decap_4
X_4641_ _1140_ VGND VGND VPWR VPWR _1421_ sky130_fd_sc_hd__buf_4
XANTENNA__5082__S1 _1814_ VGND VGND VPWR VPWR sky130_fd_sc_hd__diode_2
XFILLER_0_4_524 VGND VGND VPWR VPWR sky130_fd_sc_hd__fill_2
X_4572_ _1159_ _1355_ _1143_ VGND VGND VPWR VPWR _1356_ sky130_fd_sc_hd__a21o_1
X_7360_ _3596_ VGND VGND VPWR VPWR _0108_ sky130_fd_sc_hd__clkbuf_1
XFILLER_0_21_85 VGND VGND VPWR VPWR sky130_fd_sc_hd__fill_2
XFILLER_0_21_96 VGND VGND VPWR VPWR sky130_fd_sc_hd__decap_4
XFILLER_0_25_685 VGND VGND VPWR VPWR sky130_fd_sc_hd__decap_3
X_6311_ registers\[19\]\[17\] _2997_ _2983_ VGND VGND VPWR VPWR _2998_ sky130_fd_sc_hd__mux2_1
XANTENNA__5814__S net135 VGND VGND VPWR VPWR sky130_fd_sc_hd__diode_2
XTAP_TAPCELL_ROW_77_1265 VGND VPWR sky130_fd_sc_hd__tapvpwrvgnd_1
XTAP_TAPCELL_ROW_77_1254 VGND VPWR sky130_fd_sc_hd__tapvpwrvgnd_1
X_7291_ registers\[18\]\[19\] _3474_ _3550_ VGND VGND VPWR VPWR _3560_ sky130_fd_sc_hd__mux2_1
XFILLER_0_110_510 VGND VGND VPWR VPWR sky130_fd_sc_hd__decap_8
XFILLER_0_97_78 VGND VGND VPWR VPWR sky130_fd_sc_hd__decap_3
X_9030_ clknet_leaf_42_clk _0127_ VGND VGND VPWR VPWR registers\[20\]\[6\] sky130_fd_sc_hd__dfxtp_1
X_6242_ _2940_ _2945_ _2941_ VGND VGND VPWR VPWR _2947_ sky130_fd_sc_hd__o21bai_1
XFILLER_0_40_666 VGND VGND VPWR VPWR sky130_fd_sc_hd__decap_6
XTAP_TAPCELL_ROW_90_1432 VGND VPWR sky130_fd_sc_hd__tapvpwrvgnd_1
XFILLER_0_110_587 VGND VGND VPWR VPWR sky130_fd_sc_hd__fill_1
X_6173_ net132 _2707_ _2879_ _2881_ VGND VGND VPWR VPWR _2882_ sky130_fd_sc_hd__o2bb2a_1
X_5124_ _1809_ _1879_ _1655_ VGND VGND VPWR VPWR _1880_ sky130_fd_sc_hd__o21a_1
XANTENNA__4954__A _1714_ VGND VGND VPWR VPWR sky130_fd_sc_hd__diode_2
Xclkbuf_leaf_49_clk clknet_4_12_0_clk VGND VGND VPWR VPWR clknet_leaf_49_clk sky130_fd_sc_hd__clkbuf_8
X_5055_ registers\[8\]\[8\] registers\[9\]\[8\] registers\[10\]\[8\] registers\[11\]\[8\]
+ _1757_ _1814_ VGND VGND VPWR VPWR _1815_ sky130_fd_sc_hd__mux4_1
XANTENNA__4896__S1 _1618_ VGND VGND VPWR VPWR sky130_fd_sc_hd__diode_2
XFILLER_0_27_3 VGND VGND VPWR VPWR sky130_fd_sc_hd__decap_4
X_8814_ clknet_leaf_53_clk _0935_ VGND VGND VPWR VPWR registers\[13\]\[14\] sky130_fd_sc_hd__dfxtp_1
XFILLER_0_1_51 VGND VGND VPWR VPWR sky130_fd_sc_hd__decap_4
XANTENNA__6411__A1 _3014_ VGND VGND VPWR VPWR sky130_fd_sc_hd__diode_2
XFILLER_0_109_109 VGND VGND VPWR VPWR sky130_fd_sc_hd__fill_1
X_5957_ _2536_ _2586_ VGND VGND VPWR VPWR _2678_ sky130_fd_sc_hd__nand2_1
X_8745_ clknet_leaf_19_clk _0866_ VGND VGND VPWR VPWR registers\[11\]\[9\] sky130_fd_sc_hd__dfxtp_1
XFILLER_0_75_530 VGND VGND VPWR VPWR sky130_fd_sc_hd__fill_2
XFILLER_0_62_81 VGND VGND VPWR VPWR sky130_fd_sc_hd__decap_3
XFILLER_0_118_621 VPWR VGND VPWR VGND sky130_ef_sc_hd__decap_12
X_8676_ clknet_leaf_31_clk _0797_ VGND VGND VPWR VPWR registers\[0\]\[4\] sky130_fd_sc_hd__dfxtp_1
XANTENNA__6380__S _3041_ VGND VGND VPWR VPWR sky130_fd_sc_hd__diode_2
X_4908_ _1672_ _1673_ _1631_ VGND VGND VPWR VPWR _1674_ sky130_fd_sc_hd__mux2_1
XFILLER_0_90_533 VGND VGND VPWR VPWR sky130_fd_sc_hd__fill_2
X_5888_ _2597_ _2600_ _2612_ VGND VGND VPWR VPWR _2613_ sky130_fd_sc_hd__or3_1
X_7627_ _3738_ VGND VGND VPWR VPWR _0233_ sky130_fd_sc_hd__clkbuf_1
XTAP_TAPCELL_ROW_23_558 VGND VPWR sky130_fd_sc_hd__tapvpwrvgnd_1
XFILLER_0_105_304 VGND VGND VPWR VPWR sky130_fd_sc_hd__fill_1
XFILLER_0_90_566 VGND VGND VPWR VPWR sky130_fd_sc_hd__fill_1
XANTENNA__5073__S1 _1764_ VGND VGND VPWR VPWR sky130_fd_sc_hd__diode_2
X_4839_ registers\[12\]\[31\] registers\[13\]\[31\] registers\[14\]\[31\] registers\[15\]\[31\]
+ _1382_ _1383_ VGND VGND VPWR VPWR _1608_ sky130_fd_sc_hd__mux4_1
X_7558_ _3102_ registers\[22\]\[16\] _3695_ VGND VGND VPWR VPWR _3702_ sky130_fd_sc_hd__mux2_1
XFILLER_0_50_419 VGND VGND VPWR VPWR sky130_fd_sc_hd__fill_1
X_7489_ _3665_ VGND VGND VPWR VPWR _0168_ sky130_fd_sc_hd__clkbuf_1
X_6509_ net34 VGND VGND VPWR VPWR _3123_ sky130_fd_sc_hd__buf_2
XANTENNA__4820__S1 _1348_ VGND VGND VPWR VPWR sky130_fd_sc_hd__diode_2
X_9228_ clknet_leaf_43_clk _0325_ VGND VGND VPWR VPWR registers\[26\]\[12\] sky130_fd_sc_hd__dfxtp_1
XFILLER_0_101_598 VGND VGND VPWR VPWR sky130_fd_sc_hd__fill_1
X_9159_ clknet_leaf_25_clk _0256_ VGND VGND VPWR VPWR registers\[24\]\[7\] sky130_fd_sc_hd__dfxtp_1
XANTENNA__4584__S0 _1201_ VGND VGND VPWR VPWR sky130_fd_sc_hd__diode_2
XFILLER_0_11_390 VGND VGND VPWR VPWR sky130_fd_sc_hd__fill_2
XTAP_TAPCELL_ROW_110_1690 VGND VPWR sky130_fd_sc_hd__tapvpwrvgnd_1
XANTENNA__6555__S _3148_ VGND VGND VPWR VPWR sky130_fd_sc_hd__diode_2
XTAP_TAPCELL_ROW_3_294 VGND VPWR sky130_fd_sc_hd__tapvpwrvgnd_1
XFILLER_0_98_699 VGND VGND VPWR VPWR sky130_fd_sc_hd__fill_1
XTAP_TAPCELL_ROW_42_801 VGND VPWR sky130_fd_sc_hd__tapvpwrvgnd_1
XANTENNA__6290__S _2983_ VGND VGND VPWR VPWR sky130_fd_sc_hd__diode_2
XFILLER_0_66_563 VGND VGND VPWR VPWR sky130_fd_sc_hd__decap_4
XFILLER_0_66_541 VGND VGND VPWR VPWR sky130_fd_sc_hd__fill_2
XFILLER_0_38_232 VGND VGND VPWR VPWR sky130_fd_sc_hd__fill_2
XFILLER_0_109_643 VGND VGND VPWR VPWR sky130_fd_sc_hd__fill_2
XFILLER_0_81_533 VGND VGND VPWR VPWR sky130_fd_sc_hd__fill_2
XFILLER_0_81_500 VGND VGND VPWR VPWR sky130_fd_sc_hd__fill_2
XTAP_TAPCELL_ROW_61_1055 VGND VPWR sky130_fd_sc_hd__tapvpwrvgnd_1
XFILLER_0_81_555 VGND VGND VPWR VPWR sky130_fd_sc_hd__decap_4
XFILLER_0_81_577 VGND VGND VPWR VPWR sky130_fd_sc_hd__fill_2
XANTENNA__5064__S1 _1821_ VGND VGND VPWR VPWR sky130_fd_sc_hd__diode_2
XFILLER_0_53_268 VGND VGND VPWR VPWR sky130_fd_sc_hd__fill_2
XFILLER_0_34_460 VGND VGND VPWR VPWR sky130_fd_sc_hd__decap_3
XFILLER_0_22_622 VGND VGND VPWR VPWR sky130_fd_sc_hd__fill_2
XANTENNA__8010__S _3937_ VGND VGND VPWR VPWR sky130_fd_sc_hd__diode_2
XFILLER_0_104_381 VGND VGND VPWR VPWR sky130_fd_sc_hd__decap_8
XFILLER_0_6_29 VGND VGND VPWR VPWR sky130_fd_sc_hd__fill_2
XFILLER_0_21_143 VGND VGND VPWR VPWR sky130_fd_sc_hd__fill_1
XFILLER_0_67_37 VPWR VGND VPWR VGND sky130_ef_sc_hd__decap_12
XANTENNA__4575__S0 _1136_ VGND VGND VPWR VPWR sky130_fd_sc_hd__diode_2
XTAP_TAPCELL_ROW_72_1195 VGND VPWR sky130_fd_sc_hd__tapvpwrvgnd_1
XANTENNA__4878__S1 _1643_ VGND VGND VPWR VPWR sky130_fd_sc_hd__diode_2
XFILLER_0_89_666 VGND VGND VPWR VPWR sky130_fd_sc_hd__fill_2
XFILLER_0_89_688 VGND VGND VPWR VPWR sky130_fd_sc_hd__decap_8
XANTENNA__8394__A1 _3487_ VGND VGND VPWR VPWR sky130_fd_sc_hd__diode_2
X_6860_ _3315_ VGND VGND VPWR VPWR _0913_ sky130_fd_sc_hd__clkbuf_1
XFILLER_0_16_85 VGND VGND VPWR VPWR sky130_fd_sc_hd__fill_2
X_5811_ _2493_ _2539_ _2293_ VGND VGND VPWR VPWR _2540_ sky130_fd_sc_hd__mux2_1
XFILLER_0_76_338 VGND VGND VPWR VPWR sky130_fd_sc_hd__decap_3
XFILLER_0_69_390 VGND VGND VPWR VPWR sky130_fd_sc_hd__fill_2
X_6791_ registers\[11\]\[25\] _3014_ _3272_ VGND VGND VPWR VPWR _3278_ sky130_fd_sc_hd__mux2_1
XFILLER_0_119_429 VGND VGND VPWR VPWR sky130_fd_sc_hd__fill_1
X_5742_ _2200_ _2466_ _2473_ _2420_ VGND VGND VPWR VPWR _2474_ sky130_fd_sc_hd__o211a_1
XFILLER_0_8_126 VPWR VGND VPWR VGND sky130_ef_sc_hd__decap_12
X_8530_ registers\[4\]\[25\] net33 _4211_ VGND VGND VPWR VPWR _4217_ sky130_fd_sc_hd__mux2_1
XANTENNA__7296__S _3561_ VGND VGND VPWR VPWR sky130_fd_sc_hd__diode_2
XANTENNA__8146__A1 _3443_ VGND VGND VPWR VPWR sky130_fd_sc_hd__diode_2
XFILLER_0_45_725 VGND VGND VPWR VPWR sky130_fd_sc_hd__decap_3
XFILLER_0_17_427 VGND VGND VPWR VPWR sky130_fd_sc_hd__decap_4
XFILLER_0_29_265 VGND VGND VPWR VPWR sky130_fd_sc_hd__fill_2
X_5673_ _2279_ _2404_ _2405_ _2406_ VGND VGND VPWR VPWR _2407_ sky130_fd_sc_hd__a22o_1
XFILLER_0_72_533 VGND VGND VPWR VPWR sky130_fd_sc_hd__fill_2
X_8461_ _4180_ VGND VGND VPWR VPWR _0625_ sky130_fd_sc_hd__clkbuf_1
XTAP_TAPCELL_ROW_20_517 VGND VPWR sky130_fd_sc_hd__tapvpwrvgnd_1
XFILLER_0_115_657 VPWR VGND VPWR VGND sky130_ef_sc_hd__decap_12
X_7412_ registers\[20\]\[11\] _3458_ _3623_ VGND VGND VPWR VPWR _3625_ sky130_fd_sc_hd__mux2_1
XFILLER_0_114_134 VGND VGND VPWR VPWR sky130_fd_sc_hd__fill_2
XANTENNA__5055__S1 _1814_ VGND VGND VPWR VPWR sky130_fd_sc_hd__diode_2
X_4624_ _1324_ VGND VGND VPWR VPWR _1405_ sky130_fd_sc_hd__buf_4
XPHY_EDGE_ROW_6_Right_6 VGND VGND VPWR VPWR sky130_fd_sc_hd__decap_3
X_8392_ registers\[5\]\[24\] _3485_ _4139_ VGND VGND VPWR VPWR _4144_ sky130_fd_sc_hd__mux2_1
XFILLER_0_25_460 VGND VGND VPWR VPWR sky130_fd_sc_hd__fill_2
X_7343_ registers\[1\]\[11\] _3458_ _3586_ VGND VGND VPWR VPWR _3588_ sky130_fd_sc_hd__mux2_1
X_4555_ _1204_ VGND VGND VPWR VPWR _1339_ sky130_fd_sc_hd__clkbuf_4
XANTENNA__4802__S1 _1556_ VGND VGND VPWR VPWR sky130_fd_sc_hd__diode_2
XFILLER_0_25_482 VGND VGND VPWR VPWR sky130_fd_sc_hd__fill_2
X_7274_ _3551_ VGND VGND VPWR VPWR _0067_ sky130_fd_sc_hd__clkbuf_1
XFILLER_0_110_340 VGND VGND VPWR VPWR sky130_fd_sc_hd__decap_3
X_4486_ registers\[28\]\[12\] registers\[29\]\[12\] registers\[30\]\[12\] registers\[31\]\[12\]
+ _1167_ _1168_ VGND VGND VPWR VPWR _1274_ sky130_fd_sc_hd__mux4_1
XFILLER_0_12_187 VGND VGND VPWR VPWR sky130_fd_sc_hd__decap_3
X_9013_ clknet_leaf_85_clk _0110_ VGND VGND VPWR VPWR registers\[1\]\[21\] sky130_fd_sc_hd__dfxtp_1
X_6225_ _2688_ _2732_ _2308_ VGND VGND VPWR VPWR _2931_ sky130_fd_sc_hd__mux2_1
XANTENNA__4566__S0 _1126_ VGND VGND VPWR VPWR sky130_fd_sc_hd__diode_2
XFILLER_0_110_395 VGND VGND VPWR VPWR sky130_fd_sc_hd__decap_4
X_6156_ _2353_ _2260_ VGND VGND VPWR VPWR _2866_ sky130_fd_sc_hd__and2_1
XFILLER_0_57_70 VGND VGND VPWR VPWR sky130_fd_sc_hd__fill_1
XANTENNA__4318__S0 _1111_ VGND VGND VPWR VPWR sky130_fd_sc_hd__diode_2
X_5107_ _1862_ _1863_ _1746_ VGND VGND VPWR VPWR _1864_ sky130_fd_sc_hd__mux2_1
XANTENNA__6375__S _3030_ VGND VGND VPWR VPWR sky130_fd_sc_hd__diode_2
X_6087_ _2034_ _2782_ _2800_ VGND VGND VPWR VPWR _2801_ sky130_fd_sc_hd__a21oi_1
XANTENNA__4869__S1 _1618_ VGND VGND VPWR VPWR sky130_fd_sc_hd__diode_2
X_5038_ _1731_ VGND VGND VPWR VPWR _1798_ sky130_fd_sc_hd__clkbuf_8
XTAP_TAPCELL_ROW_28_617 VGND VPWR sky130_fd_sc_hd__tapvpwrvgnd_1
XTAP_TAPCELL_ROW_28_628 VGND VPWR sky130_fd_sc_hd__tapvpwrvgnd_1
XFILLER_0_67_305 VGND VGND VPWR VPWR sky130_fd_sc_hd__fill_2
XTAP_TAPCELL_ROW_0_242 VGND VPWR sky130_fd_sc_hd__tapvpwrvgnd_1
XTAP_TAPCELL_ROW_0_253 VGND VPWR sky130_fd_sc_hd__tapvpwrvgnd_1
XFILLER_0_94_135 VGND VGND VPWR VPWR sky130_fd_sc_hd__fill_2
XTAP_TAPCELL_ROW_0_264 VGND VPWR sky130_fd_sc_hd__tapvpwrvgnd_1
XANTENNA__5294__S1 _1759_ VGND VGND VPWR VPWR sky130_fd_sc_hd__diode_2
X_8728_ clknet_leaf_89_clk _0849_ VGND VGND VPWR VPWR registers\[10\]\[24\] sky130_fd_sc_hd__dfxtp_1
X_6989_ _3384_ VGND VGND VPWR VPWR _0973_ sky130_fd_sc_hd__clkbuf_1
XFILLER_0_75_382 VGND VGND VPWR VPWR sky130_fd_sc_hd__decap_8
XFILLER_0_48_574 VGND VGND VPWR VPWR sky130_fd_sc_hd__decap_3
X_8659_ clknet_leaf_14_clk _0780_ VGND VGND VPWR VPWR registers\[7\]\[19\] sky130_fd_sc_hd__dfxtp_1
XANTENNA__7934__S _3901_ VGND VGND VPWR VPWR sky130_fd_sc_hd__diode_2
XFILLER_0_105_123 VGND VGND VPWR VPWR sky130_fd_sc_hd__fill_2
XFILLER_0_8_693 VGND VGND VPWR VPWR sky130_fd_sc_hd__decap_4
XFILLER_0_50_249 VGND VGND VPWR VPWR sky130_fd_sc_hd__fill_1
XANTENNA__5371__A1 _2081_ VGND VGND VPWR VPWR sky130_fd_sc_hd__diode_2
XANTENNA__4859__A _1621_ VGND VGND VPWR VPWR sky130_fd_sc_hd__diode_2
XFILLER_0_105_189 VGND VGND VPWR VPWR sky130_fd_sc_hd__decap_4
Xoutput76 net76 VGND VGND VPWR VPWR alu_result[5] sky130_fd_sc_hd__buf_1
Xoutput54 net54 VGND VGND VPWR VPWR alu_result[14] sky130_fd_sc_hd__buf_1
Xoutput65 net65 VGND VGND VPWR VPWR alu_result[24] sky130_fd_sc_hd__buf_1
XANTENNA__4557__S0 _1320_ VGND VGND VPWR VPWR sky130_fd_sc_hd__diode_2
XTAP_TAPCELL_ROW_8_364 VGND VPWR sky130_fd_sc_hd__tapvpwrvgnd_1
Xoutput98 net98 VGND VGND VPWR VPWR rd1[25] sky130_fd_sc_hd__buf_1
Xoutput87 net87 VGND VGND VPWR VPWR rd1[15] sky130_fd_sc_hd__buf_1
XANTENNA_input30_A wd3[22] VGND VGND VPWR VPWR sky130_fd_sc_hd__diode_2
XANTENNA__6623__A1 _2985_ VGND VGND VPWR VPWR sky130_fd_sc_hd__diode_2
XFILLER_0_98_474 VGND VGND VPWR VPWR sky130_fd_sc_hd__fill_2
XFILLER_0_86_603 VGND VGND VPWR VPWR sky130_fd_sc_hd__fill_2
XFILLER_0_85_113 VGND VGND VPWR VPWR sky130_fd_sc_hd__fill_1
XFILLER_0_85_102 VGND VGND VPWR VPWR sky130_fd_sc_hd__decap_4
XFILLER_0_58_349 VGND VGND VPWR VPWR sky130_fd_sc_hd__decap_3
XTAP_TAPCELL_ROW_55_970 VGND VPWR sky130_fd_sc_hd__tapvpwrvgnd_1
XFILLER_0_39_530 VGND VGND VPWR VPWR sky130_fd_sc_hd__fill_1
XFILLER_0_86_669 VGND VGND VPWR VPWR sky130_fd_sc_hd__fill_2
XFILLER_0_73_308 VGND VGND VPWR VPWR sky130_fd_sc_hd__fill_2
XFILLER_0_66_360 VGND VGND VPWR VPWR sky130_fd_sc_hd__fill_2
XFILLER_0_109_473 VGND VGND VPWR VPWR sky130_fd_sc_hd__fill_2
XPHY_EDGE_ROW_59_Right_59 VGND VGND VPWR VPWR sky130_fd_sc_hd__decap_3
XANTENNA__7844__S _3851_ VGND VGND VPWR VPWR sky130_fd_sc_hd__diode_2
XFILLER_0_81_374 VGND VGND VPWR VPWR sky130_fd_sc_hd__fill_2
XANTENNA__5037__S1 _1764_ VGND VGND VPWR VPWR sky130_fd_sc_hd__diode_2
XANTENNA__4769__A _1386_ VGND VGND VPWR VPWR sky130_fd_sc_hd__diode_2
XANTENNA__7145__A _3434_ VGND VGND VPWR VPWR sky130_fd_sc_hd__diode_2
X_4340_ _1125_ VGND VGND VPWR VPWR _1136_ sky130_fd_sc_hd__clkbuf_8
XTAP_TAPCELL_ROW_74_1224 VGND VPWR sky130_fd_sc_hd__tapvpwrvgnd_1
XANTENNA__4548__S0 _1198_ VGND VGND VPWR VPWR sky130_fd_sc_hd__diode_2
X_4271_ _1052_ _1059_ _1069_ VGND VGND VPWR VPWR _1070_ sky130_fd_sc_hd__o21ai_4
XFILLER_0_10_658 VGND VGND VPWR VPWR sky130_fd_sc_hd__decap_4
XFILLER_0_94_13 VGND VGND VPWR VPWR sky130_fd_sc_hd__fill_1
X_6010_ _2721_ _2392_ _2582_ _2692_ _2728_ VGND VGND VPWR VPWR _2729_ sky130_fd_sc_hd__a221o_1
XPHY_EDGE_ROW_68_Right_68 VGND VGND VPWR VPWR sky130_fd_sc_hd__decap_3
XFILLER_0_118_53 VPWR VGND VPWR VGND sky130_ef_sc_hd__decap_12
XANTENNA__6614__A1 _2976_ VGND VGND VPWR VPWR sky130_fd_sc_hd__diode_2
XFILLER_0_118_97 VGND VGND VPWR VPWR sky130_fd_sc_hd__decap_8
X_7961_ _2989_ registers\[28\]\[13\] _3912_ VGND VGND VPWR VPWR _3916_ sky130_fd_sc_hd__mux2_1
XFILLER_0_89_441 VGND VGND VPWR VPWR sky130_fd_sc_hd__fill_2
XPHY_EDGE_ROW_6_Left_126 VGND VGND VPWR VPWR sky130_fd_sc_hd__decap_3
X_7892_ _3879_ VGND VGND VPWR VPWR _0357_ sky130_fd_sc_hd__clkbuf_1
X_6912_ _3104_ registers\[13\]\[17\] _3335_ VGND VGND VPWR VPWR _3343_ sky130_fd_sc_hd__mux2_1
XANTENNA__6923__S _3346_ VGND VGND VPWR VPWR sky130_fd_sc_hd__diode_2
XANTENNA__4720__S0 _1382_ VGND VGND VPWR VPWR sky130_fd_sc_hd__diode_2
XTAP_TAPCELL_ROW_85_1364 VGND VPWR sky130_fd_sc_hd__tapvpwrvgnd_1
X_6843_ _3306_ VGND VGND VPWR VPWR _0905_ sky130_fd_sc_hd__clkbuf_1
XANTENNA__5276__S1 _2021_ VGND VGND VPWR VPWR sky130_fd_sc_hd__diode_2
XFILLER_0_85_691 VGND VGND VPWR VPWR sky130_fd_sc_hd__decap_3
X_6774_ registers\[11\]\[17\] _2997_ _3261_ VGND VGND VPWR VPWR _3269_ sky130_fd_sc_hd__mux2_1
XPHY_EDGE_ROW_77_Right_77 VGND VGND VPWR VPWR sky130_fd_sc_hd__decap_3
XFILLER_0_64_319 VGND VGND VPWR VPWR sky130_fd_sc_hd__fill_1
XFILLER_0_45_522 VGND VGND VPWR VPWR sky130_fd_sc_hd__decap_3
X_9562_ clknet_leaf_93_clk _0659_ VGND VGND VPWR VPWR registers\[4\]\[26\] sky130_fd_sc_hd__dfxtp_1
X_5725_ _2273_ _2449_ _2457_ _2276_ VGND VGND VPWR VPWR _2458_ sky130_fd_sc_hd__o211a_1
X_8513_ registers\[4\]\[17\] net24 _4200_ VGND VGND VPWR VPWR _4208_ sky130_fd_sc_hd__mux2_1
X_9493_ clknet_leaf_91_clk _0590_ VGND VGND VPWR VPWR registers\[5\]\[21\] sky130_fd_sc_hd__dfxtp_1
XTAP_TAPCELL_ROW_33_686 VGND VPWR sky130_fd_sc_hd__tapvpwrvgnd_1
XFILLER_0_115_421 VGND VGND VPWR VPWR sky130_fd_sc_hd__fill_2
XFILLER_0_94_3 VGND VGND VPWR VPWR sky130_fd_sc_hd__fill_2
XANTENNA__5028__S1 _1706_ VGND VGND VPWR VPWR sky130_fd_sc_hd__diode_2
X_5656_ _2344_ _2384_ _2390_ VGND VGND VPWR VPWR _2391_ sky130_fd_sc_hd__o21ai_2
X_8444_ _4171_ VGND VGND VPWR VPWR _0617_ sky130_fd_sc_hd__clkbuf_1
XFILLER_0_115_443 VGND VGND VPWR VPWR sky130_fd_sc_hd__fill_2
X_4607_ _1159_ VGND VGND VPWR VPWR _1389_ sky130_fd_sc_hd__buf_4
XFILLER_0_32_216 VGND VGND VPWR VPWR sky130_fd_sc_hd__fill_2
XFILLER_0_103_649 VGND VGND VPWR VPWR sky130_fd_sc_hd__fill_2
X_5587_ _1145_ _2271_ VGND VGND VPWR VPWR _2322_ sky130_fd_sc_hd__and2_2
X_8375_ registers\[5\]\[16\] _3468_ _4128_ VGND VGND VPWR VPWR _4135_ sky130_fd_sc_hd__mux2_1
XFILLER_0_60_569 VGND VGND VPWR VPWR sky130_fd_sc_hd__fill_2
XFILLER_0_60_558 VGND VGND VPWR VPWR sky130_fd_sc_hd__decap_8
XFILLER_0_4_184 VGND VGND VPWR VPWR sky130_fd_sc_hd__fill_2
X_4538_ _1125_ VGND VGND VPWR VPWR _1323_ sky130_fd_sc_hd__buf_4
X_7326_ registers\[1\]\[3\] _3441_ _3575_ VGND VGND VPWR VPWR _3579_ sky130_fd_sc_hd__mux2_1
XFILLER_0_7_61 VGND VGND VPWR VPWR sky130_fd_sc_hd__fill_2
XFILLER_0_13_496 VGND VGND VPWR VPWR sky130_fd_sc_hd__decap_3
X_4469_ registers\[28\]\[11\] registers\[29\]\[11\] registers\[30\]\[11\] registers\[31\]\[11\]
+ _1197_ _1203_ VGND VGND VPWR VPWR _1258_ sky130_fd_sc_hd__mux4_1
X_7257_ _3542_ VGND VGND VPWR VPWR _0059_ sky130_fd_sc_hd__clkbuf_1
XPHY_EDGE_ROW_86_Right_86 VGND VGND VPWR VPWR sky130_fd_sc_hd__decap_3
XANTENNA__5200__S1 _1775_ VGND VGND VPWR VPWR sky130_fd_sc_hd__diode_2
XFILLER_0_68_91 VGND VGND VPWR VPWR sky130_fd_sc_hd__fill_2
X_6208_ _1569_ _2880_ _2707_ VGND VGND VPWR VPWR _2915_ sky130_fd_sc_hd__a21o_1
XANTENNA__6596__C_N net48 VGND VGND VPWR VPWR sky130_fd_sc_hd__diode_2
XTAP_TAPCELL_ROW_5_323 VGND VPWR sky130_fd_sc_hd__tapvpwrvgnd_1
X_7188_ registers\[17\]\[2\] _3439_ _3503_ VGND VGND VPWR VPWR _3506_ sky130_fd_sc_hd__mux2_1
X_6139_ _2809_ _2849_ _2308_ VGND VGND VPWR VPWR _2850_ sky130_fd_sc_hd__mux2_1
XANTENNA__4618__S _1344_ VGND VGND VPWR VPWR sky130_fd_sc_hd__diode_2
XANTENNA__5303__A _2048_ VGND VGND VPWR VPWR sky130_fd_sc_hd__diode_2
XANTENNA__8358__A1 _3451_ VGND VGND VPWR VPWR sky130_fd_sc_hd__diode_2
XFILLER_0_67_113 VGND VGND VPWR VPWR sky130_fd_sc_hd__decap_3
XPHY_EDGE_ROW_95_Right_95 VGND VGND VPWR VPWR sky130_fd_sc_hd__decap_3
XFILLER_0_83_606 VGND VGND VPWR VPWR sky130_fd_sc_hd__fill_1
XFILLER_0_67_157 VGND VGND VPWR VPWR sky130_fd_sc_hd__fill_2
XFILLER_0_67_146 VGND VGND VPWR VPWR sky130_fd_sc_hd__decap_4
XTAP_TAPCELL_ROW_52_940 VGND VPWR sky130_fd_sc_hd__tapvpwrvgnd_1
XFILLER_0_36_533 VGND VGND VPWR VPWR sky130_fd_sc_hd__fill_2
XFILLER_0_36_555 VGND VGND VPWR VPWR sky130_fd_sc_hd__fill_2
XFILLER_0_106_421 VPWR VGND VPWR VGND sky130_ef_sc_hd__decap_12
XFILLER_0_51_514 VGND VGND VPWR VPWR sky130_fd_sc_hd__decap_3
XFILLER_0_8_490 VGND VGND VPWR VPWR sky130_fd_sc_hd__fill_2
XANTENNA__7664__S _3757_ VGND VGND VPWR VPWR sky130_fd_sc_hd__diode_2
XFILLER_0_24_706 VGND VGND VPWR VPWR sky130_fd_sc_hd__fill_2
XFILLER_0_24_717 VGND VGND VPWR VPWR sky130_fd_sc_hd__fill_2
XFILLER_0_106_454 VGND VGND VPWR VPWR sky130_fd_sc_hd__fill_2
XFILLER_0_90_182 VGND VGND VPWR VPWR sky130_fd_sc_hd__decap_3
XANTENNA__8530__A1 net33 VGND VGND VPWR VPWR sky130_fd_sc_hd__diode_2
XANTENNA__4589__A _1371_ VGND VGND VPWR VPWR sky130_fd_sc_hd__diode_2
XFILLER_0_102_682 VGND VGND VPWR VPWR sky130_fd_sc_hd__decap_6
XFILLER_0_102_660 VGND VGND VPWR VPWR sky130_fd_sc_hd__fill_2
XANTENNA__6844__A1 _2997_ VGND VGND VPWR VPWR sky130_fd_sc_hd__diode_2
XPHY_EDGE_ROW_79_Left_199 VGND VGND VPWR VPWR sky130_fd_sc_hd__decap_3
XANTENNA__6743__S _3250_ VGND VGND VPWR VPWR sky130_fd_sc_hd__diode_2
XFILLER_0_59_647 VGND VGND VPWR VPWR sky130_fd_sc_hd__decap_8
XFILLER_0_59_625 VGND VGND VPWR VPWR sky130_fd_sc_hd__fill_1
XFILLER_0_104_33 VGND VGND VPWR VPWR sky130_fd_sc_hd__decap_4
XFILLER_0_86_477 VGND VGND VPWR VPWR sky130_fd_sc_hd__decap_3
XFILLER_0_74_628 VGND VGND VPWR VPWR sky130_fd_sc_hd__fill_2
XFILLER_0_39_393 VGND VGND VPWR VPWR sky130_fd_sc_hd__decap_8
XFILLER_0_6_416 VGND VGND VPWR VPWR sky130_fd_sc_hd__fill_1
XANTENNA__5883__A _2560_ VGND VGND VPWR VPWR sky130_fd_sc_hd__diode_2
XTAP_TAPCELL_ROW_80_1294 VGND VPWR sky130_fd_sc_hd__tapvpwrvgnd_1
X_5510_ _2217_ _2245_ VGND VGND VPWR VPWR _2246_ sky130_fd_sc_hd__nand2_1
XFILLER_0_27_588 VGND VGND VPWR VPWR sky130_fd_sc_hd__fill_2
XTAP_TAPCELL_ROW_30_645 VGND VPWR sky130_fd_sc_hd__tapvpwrvgnd_1
XFILLER_0_89_35 VGND VGND VPWR VPWR sky130_fd_sc_hd__fill_2
XFILLER_0_81_160 VGND VGND VPWR VPWR sky130_fd_sc_hd__decap_4
XFILLER_0_54_385 VGND VGND VPWR VPWR sky130_fd_sc_hd__decap_4
XFILLER_0_42_547 VGND VGND VPWR VPWR sky130_fd_sc_hd__fill_1
X_6490_ net28 VGND VGND VPWR VPWR _3110_ sky130_fd_sc_hd__clkbuf_2
XANTENNA__4499__A _1286_ VGND VGND VPWR VPWR sky130_fd_sc_hd__diode_2
X_5441_ registers\[12\]\[30\] registers\[13\]\[30\] registers\[14\]\[30\] registers\[15\]\[30\]
+ _1758_ _1760_ VGND VGND VPWR VPWR _2179_ sky130_fd_sc_hd__mux4_1
XFILLER_0_2_622 VGND VGND VPWR VPWR sky130_fd_sc_hd__fill_1
X_8160_ _4021_ VGND VGND VPWR VPWR _0483_ sky130_fd_sc_hd__clkbuf_1
XTAP_TAPCELL_ROW_10_391 VGND VPWR sky130_fd_sc_hd__tapvpwrvgnd_1
X_5372_ registers\[8\]\[26\] registers\[9\]\[26\] registers\[10\]\[26\] registers\[11\]\[26\]
+ _2020_ _2021_ VGND VGND VPWR VPWR _2114_ sky130_fd_sc_hd__mux4_1
X_8091_ _2982_ registers\[30\]\[10\] _3984_ VGND VGND VPWR VPWR _3985_ sky130_fd_sc_hd__mux2_1
X_4323_ registers\[28\]\[4\] registers\[29\]\[4\] registers\[30\]\[4\] registers\[31\]\[4\]
+ _1111_ _1113_ VGND VGND VPWR VPWR _1119_ sky130_fd_sc_hd__mux4_1
X_7111_ registers\[16\]\[9\] _3453_ _3435_ VGND VGND VPWR VPWR _3454_ sky130_fd_sc_hd__mux2_1
X_7042_ _3096_ registers\[15\]\[13\] _3409_ VGND VGND VPWR VPWR _3413_ sky130_fd_sc_hd__mux2_1
XANTENNA__5194__S0 _1757_ VGND VGND VPWR VPWR sky130_fd_sc_hd__diode_2
X_4254_ a2[0] VGND VGND VPWR VPWR _1053_ sky130_fd_sc_hd__buf_4
X_8993_ clknet_leaf_7_clk _0090_ VGND VGND VPWR VPWR registers\[1\]\[1\] sky130_fd_sc_hd__dfxtp_1
XANTENNA__7260__A1 _3443_ VGND VGND VPWR VPWR sky130_fd_sc_hd__diode_2
X_7944_ _2972_ registers\[28\]\[5\] _3901_ VGND VGND VPWR VPWR _3907_ sky130_fd_sc_hd__mux2_1
XANTENNA__4962__A _1725_ VGND VGND VPWR VPWR sky130_fd_sc_hd__diode_2
XTAP_TAPCELL_ROW_38_756 VGND VPWR sky130_fd_sc_hd__tapvpwrvgnd_1
XFILLER_0_89_293 VGND VGND VPWR VPWR sky130_fd_sc_hd__decap_4
XFILLER_0_77_400 VGND VGND VPWR VPWR sky130_fd_sc_hd__fill_2
X_7875_ _3870_ VGND VGND VPWR VPWR _0349_ sky130_fd_sc_hd__clkbuf_1
X_6826_ _3297_ VGND VGND VPWR VPWR _0897_ sky130_fd_sc_hd__clkbuf_1
XFILLER_0_65_617 VGND VGND VPWR VPWR sky130_fd_sc_hd__fill_2
XFILLER_0_37_319 VGND VGND VPWR VPWR sky130_fd_sc_hd__fill_1
XTAP_TAPCELL_ROW_18_491 VGND VPWR sky130_fd_sc_hd__tapvpwrvgnd_1
X_9545_ clknet_leaf_18_clk _0642_ VGND VGND VPWR VPWR registers\[4\]\[9\] sky130_fd_sc_hd__dfxtp_1
X_6757_ registers\[11\]\[9\] _2980_ _3250_ VGND VGND VPWR VPWR _3260_ sky130_fd_sc_hd__mux2_1
XFILLER_0_9_254 VGND VGND VPWR VPWR sky130_fd_sc_hd__decap_4
XFILLER_0_18_533 VGND VGND VPWR VPWR sky130_fd_sc_hd__fill_2
XANTENNA__7484__S _3659_ VGND VGND VPWR VPWR sky130_fd_sc_hd__diode_2
X_5708_ _2438_ _2440_ _2403_ VGND VGND VPWR VPWR _2441_ sky130_fd_sc_hd__mux2_1
XANTENNA__5793__A _1740_ VGND VGND VPWR VPWR sky130_fd_sc_hd__diode_2
XFILLER_0_70_81 VGND VGND VPWR VPWR sky130_fd_sc_hd__decap_3
XANTENNA__4901__S _1634_ VGND VGND VPWR VPWR sky130_fd_sc_hd__diode_2
X_9476_ clknet_leaf_30_clk _0573_ VGND VGND VPWR VPWR registers\[5\]\[4\] sky130_fd_sc_hd__dfxtp_1
XTAP_TAPCELL_ROW_98_1533 VGND VPWR sky130_fd_sc_hd__tapvpwrvgnd_1
X_6688_ _3223_ VGND VGND VPWR VPWR _0833_ sky130_fd_sc_hd__clkbuf_1
XFILLER_0_33_514 VGND VGND VPWR VPWR sky130_fd_sc_hd__fill_2
X_5639_ _2267_ _2227_ VGND VGND VPWR VPWR _2374_ sky130_fd_sc_hd__nand2_1
X_8427_ _4162_ VGND VGND VPWR VPWR _0609_ sky130_fd_sc_hd__clkbuf_1
XFILLER_0_60_344 VGND VGND VPWR VPWR sky130_fd_sc_hd__fill_2
XFILLER_0_103_457 VGND VGND VPWR VPWR sky130_fd_sc_hd__fill_1
X_8358_ registers\[5\]\[8\] _3451_ _4117_ VGND VGND VPWR VPWR _4126_ sky130_fd_sc_hd__mux2_1
XANTENNA__5421__S1 _2120_ VGND VGND VPWR VPWR sky130_fd_sc_hd__diode_2
XANTENNA__8276__A0 _2964_ VGND VGND VPWR VPWR sky130_fd_sc_hd__diode_2
X_7309_ _3569_ VGND VGND VPWR VPWR _0084_ sky130_fd_sc_hd__clkbuf_1
XANTENNA__5732__S net135 VGND VGND VPWR VPWR sky130_fd_sc_hd__diode_2
X_8289_ _4089_ VGND VGND VPWR VPWR _0544_ sky130_fd_sc_hd__clkbuf_1
XANTENNA__5185__S0 _1742_ VGND VGND VPWR VPWR sky130_fd_sc_hd__diode_2
XANTENNA__6563__S _3148_ VGND VGND VPWR VPWR sky130_fd_sc_hd__diode_2
XTAP_TAPCELL_ROW_107_1651 VGND VPWR sky130_fd_sc_hd__tapvpwrvgnd_1
XFILLER_0_68_499 VGND VGND VPWR VPWR sky130_fd_sc_hd__decap_3
XFILLER_0_68_477 VGND VGND VPWR VPWR sky130_fd_sc_hd__fill_2
XFILLER_0_83_447 VGND VGND VPWR VPWR sky130_fd_sc_hd__fill_1
XFILLER_0_55_138 VGND VGND VPWR VPWR sky130_fd_sc_hd__fill_2
XFILLER_0_50_29 VGND VGND VPWR VPWR sky130_fd_sc_hd__decap_3
XANTENNA__4999__S0 _1758_ VGND VGND VPWR VPWR sky130_fd_sc_hd__diode_2
XANTENNA__8503__A1 net19 VGND VGND VPWR VPWR sky130_fd_sc_hd__diode_2
XFILLER_0_36_374 VGND VGND VPWR VPWR sky130_fd_sc_hd__decap_3
XTAP_TAPCELL_ROW_58_1016 VGND VPWR sky130_fd_sc_hd__tapvpwrvgnd_1
XFILLER_0_51_333 VGND VGND VPWR VPWR sky130_fd_sc_hd__decap_3
XTAP_TAPCELL_ROW_118_1791 VGND VPWR sky130_fd_sc_hd__tapvpwrvgnd_1
XFILLER_0_11_219 VGND VGND VPWR VPWR sky130_fd_sc_hd__fill_2
XPHY_EDGE_ROW_87_Left_207 VGND VGND VPWR VPWR sky130_fd_sc_hd__decap_3
XFILLER_0_75_48 VGND VGND VPWR VPWR sky130_fd_sc_hd__fill_2
XANTENNA__6473__S _3090_ VGND VGND VPWR VPWR sky130_fd_sc_hd__diode_2
XANTENNA__6045__A2 _2754_ VGND VGND VPWR VPWR sky130_fd_sc_hd__diode_2
XANTENNA__7242__A1 _3493_ VGND VGND VPWR VPWR sky130_fd_sc_hd__diode_2
XANTENNA__7569__S _3706_ VGND VGND VPWR VPWR sky130_fd_sc_hd__diode_2
XFILLER_0_91_47 VGND VGND VPWR VPWR sky130_fd_sc_hd__fill_2
XTAP_TAPCELL_ROW_69_1156 VGND VPWR sky130_fd_sc_hd__tapvpwrvgnd_1
X_5990_ net88 _2709_ VGND VGND VPWR VPWR _2710_ sky130_fd_sc_hd__xnor2_1
XTAP_TAPCELL_ROW_82_1323 VGND VPWR sky130_fd_sc_hd__tapvpwrvgnd_1
XFILLER_0_59_444 VGND VGND VPWR VPWR sky130_fd_sc_hd__fill_2
X_4941_ _1642_ VGND VGND VPWR VPWR _1705_ sky130_fd_sc_hd__clkbuf_8
XTAP_TAPCELL_ROW_35_715 VGND VPWR sky130_fd_sc_hd__tapvpwrvgnd_1
XFILLER_0_115_98 VGND VGND VPWR VPWR sky130_fd_sc_hd__fill_2
XPHY_EDGE_ROW_96_Left_216 VGND VGND VPWR VPWR sky130_fd_sc_hd__decap_3
XFILLER_0_47_617 VGND VGND VPWR VPWR sky130_fd_sc_hd__fill_2
XFILLER_0_24_63 VGND VGND VPWR VPWR sky130_fd_sc_hd__fill_2
X_4872_ _1636_ _1639_ net5 VGND VGND VPWR VPWR _1640_ sky130_fd_sc_hd__a21o_1
X_7660_ _3285_ _3755_ VGND VGND VPWR VPWR _3756_ sky130_fd_sc_hd__and2_2
XFILLER_0_117_505 VGND VGND VPWR VPWR sky130_fd_sc_hd__decap_4
X_6611_ _3181_ VGND VGND VPWR VPWR _0798_ sky130_fd_sc_hd__clkbuf_1
XANTENNA__5100__S0 _1856_ VGND VGND VPWR VPWR sky130_fd_sc_hd__diode_2
XFILLER_0_86_285 VGND VGND VPWR VPWR sky130_fd_sc_hd__decap_4
XFILLER_0_7_714 VPWR VGND VPWR VGND sky130_ef_sc_hd__decap_12
XTAP_TAPCELL_ROW_15_450 VGND VPWR sky130_fd_sc_hd__tapvpwrvgnd_1
XFILLER_0_117_527 VGND VGND VPWR VPWR sky130_fd_sc_hd__fill_2
XFILLER_0_61_108 VGND VGND VPWR VPWR sky130_fd_sc_hd__fill_2
X_9330_ clknet_leaf_66_clk _0427_ VGND VGND VPWR VPWR registers\[2\]\[18\] sky130_fd_sc_hd__dfxtp_1
X_7591_ _3396_ _3610_ VGND VGND VPWR VPWR _3719_ sky130_fd_sc_hd__nand2_4
X_6542_ registers\[7\]\[6\] _2974_ _3137_ VGND VGND VPWR VPWR _3144_ sky130_fd_sc_hd__mux2_1
XFILLER_0_54_182 VGND VGND VPWR VPWR sky130_fd_sc_hd__fill_1
XFILLER_0_15_525 VGND VGND VPWR VPWR sky130_fd_sc_hd__fill_1
X_6473_ _3098_ registers\[29\]\[14\] _3090_ VGND VGND VPWR VPWR _3099_ sky130_fd_sc_hd__mux2_1
X_9261_ clknet_leaf_57_clk _0358_ VGND VGND VPWR VPWR registers\[27\]\[13\] sky130_fd_sc_hd__dfxtp_1
XFILLER_0_15_547 VGND VGND VPWR VPWR sky130_fd_sc_hd__decap_8
X_9192_ clknet_leaf_19_clk _0289_ VGND VGND VPWR VPWR registers\[25\]\[8\] sky130_fd_sc_hd__dfxtp_1
X_8212_ registers\[6\]\[3\] _3441_ _4045_ VGND VGND VPWR VPWR _4049_ sky130_fd_sc_hd__mux2_1
X_5424_ _2026_ _2162_ VGND VGND VPWR VPWR _2163_ sky130_fd_sc_hd__nor2_1
X_8143_ _4012_ VGND VGND VPWR VPWR _0475_ sky130_fd_sc_hd__clkbuf_1
XFILLER_0_23_580 VGND VGND VPWR VPWR sky130_fd_sc_hd__fill_2
XTAP_TAPCELL_ROW_93_1474 VGND VPWR sky130_fd_sc_hd__tapvpwrvgnd_1
XTAP_TAPCELL_ROW_93_1463 VGND VPWR sky130_fd_sc_hd__tapvpwrvgnd_1
XANTENNA__6648__S _3197_ VGND VGND VPWR VPWR sky130_fd_sc_hd__diode_2
X_5355_ registers\[0\]\[25\] registers\[1\]\[25\] registers\[2\]\[25\] registers\[3\]\[25\]
+ _2097_ _2021_ VGND VGND VPWR VPWR _2098_ sky130_fd_sc_hd__mux4_1
X_4306_ registers\[12\]\[3\] registers\[13\]\[3\] registers\[14\]\[3\] registers\[15\]\[3\]
+ _1039_ _1040_ VGND VGND VPWR VPWR _1103_ sky130_fd_sc_hd__mux4_1
X_5286_ _2026_ _2032_ _1977_ VGND VGND VPWR VPWR _2033_ sky130_fd_sc_hd__a21oi_1
X_8074_ _2966_ registers\[30\]\[2\] _3973_ VGND VGND VPWR VPWR _3976_ sky130_fd_sc_hd__mux2_1
X_7025_ _3079_ registers\[15\]\[5\] _3398_ VGND VGND VPWR VPWR _3404_ sky130_fd_sc_hd__mux2_1
X_4237_ _1035_ _1036_ _1031_ VGND VGND VPWR VPWR _1037_ sky130_fd_sc_hd__mux2_1
XANTENNA__5788__A _1780_ VGND VGND VPWR VPWR sky130_fd_sc_hd__diode_2
XFILLER_0_65_92 VGND VGND VPWR VPWR sky130_fd_sc_hd__fill_2
XANTENNA_clkbuf_leaf_4_clk_A clknet_4_0_0_clk VGND VGND VPWR VPWR sky130_fd_sc_hd__diode_2
X_8976_ clknet_leaf_63_clk _0073_ VGND VGND VPWR VPWR registers\[18\]\[16\] sky130_fd_sc_hd__dfxtp_1
X_7927_ _3897_ VGND VGND VPWR VPWR _0374_ sky130_fd_sc_hd__clkbuf_1
XFILLER_0_93_701 VPWR VGND VPWR VGND sky130_ef_sc_hd__decap_12
X_7858_ _3129_ registers\[26\]\[29\] _3851_ VGND VGND VPWR VPWR _3861_ sky130_fd_sc_hd__mux2_1
XANTENNA__5547__A1 _1929_ VGND VGND VPWR VPWR sky130_fd_sc_hd__diode_2
XFILLER_0_77_285 VGND VGND VPWR VPWR sky130_fd_sc_hd__decap_3
XFILLER_0_65_425 VGND VGND VPWR VPWR sky130_fd_sc_hd__fill_2
X_6809_ registers\[12\]\[0\] _2958_ _3288_ VGND VGND VPWR VPWR _3289_ sky130_fd_sc_hd__mux2_1
XTAP_TAPCELL_ROW_102_1581 VGND VPWR sky130_fd_sc_hd__tapvpwrvgnd_1
XFILLER_0_65_469 VGND VGND VPWR VPWR sky130_fd_sc_hd__fill_1
XFILLER_0_53_609 VGND VGND VPWR VPWR sky130_fd_sc_hd__fill_1
X_7789_ _3824_ VGND VGND VPWR VPWR _0309_ sky130_fd_sc_hd__clkbuf_1
XANTENNA__8103__S _3984_ VGND VGND VPWR VPWR sky130_fd_sc_hd__diode_2
XANTENNA__4631__S _1346_ VGND VGND VPWR VPWR sky130_fd_sc_hd__diode_2
X_9528_ clknet_leaf_91_clk _0625_ VGND VGND VPWR VPWR registers\[8\]\[24\] sky130_fd_sc_hd__dfxtp_1
XFILLER_0_60_141 VGND VGND VPWR VPWR sky130_fd_sc_hd__fill_2
X_9459_ clknet_leaf_14_clk _0556_ VGND VGND VPWR VPWR registers\[31\]\[19\] sky130_fd_sc_hd__dfxtp_1
XANTENNA__7942__S _3901_ VGND VGND VPWR VPWR sky130_fd_sc_hd__diode_2
XFILLER_0_103_254 VGND VGND VPWR VPWR sky130_fd_sc_hd__fill_2
XFILLER_0_103_243 VGND VGND VPWR VPWR sky130_fd_sc_hd__decap_4
XANTENNA__4286__A1 net6 VGND VGND VPWR VPWR sky130_fd_sc_hd__diode_2
XANTENNA__7389__S _3612_ VGND VGND VPWR VPWR sky130_fd_sc_hd__diode_2
XANTENNA__6293__S _2983_ VGND VGND VPWR VPWR sky130_fd_sc_hd__diode_2
XFILLER_0_68_241 VGND VGND VPWR VPWR sky130_fd_sc_hd__fill_2
XANTENNA__5330__S0 _2072_ VGND VGND VPWR VPWR sky130_fd_sc_hd__diode_2
XFILLER_0_29_617 VGND VGND VPWR VPWR sky130_fd_sc_hd__fill_2
XTAP_TAPCELL_ROW_64_1097 VGND VPWR sky130_fd_sc_hd__tapvpwrvgnd_1
XTAP_TAPCELL_ROW_64_1086 VGND VPWR sky130_fd_sc_hd__tapvpwrvgnd_1
XTAP_TAPCELL_ROW_12_420 VGND VPWR sky130_fd_sc_hd__tapvpwrvgnd_1
XFILLER_0_9_18 VGND VGND VPWR VPWR sky130_fd_sc_hd__fill_1
XFILLER_0_4_717 VPWR VGND VPWR VGND sky130_ef_sc_hd__decap_12
XFILLER_0_52_653 VGND VGND VPWR VPWR sky130_fd_sc_hd__fill_2
XFILLER_0_52_642 VGND VGND VPWR VPWR sky130_fd_sc_hd__fill_2
XTAP_TAPCELL_ROW_40_784 VGND VPWR sky130_fd_sc_hd__tapvpwrvgnd_1
XTAP_TAPCELL_ROW_40_773 VGND VPWR sky130_fd_sc_hd__tapvpwrvgnd_1
XFILLER_0_52_697 VGND VGND VPWR VPWR sky130_fd_sc_hd__decap_3
XFILLER_0_51_152 VGND VGND VPWR VPWR sky130_fd_sc_hd__fill_2
XANTENNA__7852__S _3851_ VGND VGND VPWR VPWR sky130_fd_sc_hd__diode_2
XANTENNA__5397__S0 _2097_ VGND VGND VPWR VPWR sky130_fd_sc_hd__diode_2
XFILLER_0_24_399 VGND VGND VPWR VPWR sky130_fd_sc_hd__fill_2
XANTENNA__4777__A _1549_ VGND VGND VPWR VPWR sky130_fd_sc_hd__diode_2
XFILLER_0_20_561 VGND VGND VPWR VPWR sky130_fd_sc_hd__fill_2
XANTENNA__5149__S0 _1748_ VGND VGND VPWR VPWR sky130_fd_sc_hd__diode_2
X_5140_ registers\[4\]\[13\] registers\[5\]\[13\] registers\[6\]\[13\] registers\[7\]\[13\]
+ _1748_ _1749_ VGND VGND VPWR VPWR _1895_ sky130_fd_sc_hd__mux4_1
X_5071_ _1809_ _1829_ _1655_ VGND VGND VPWR VPWR _1830_ sky130_fd_sc_hd__o21a_1
XANTENNA__7215__A1 _3466_ VGND VGND VPWR VPWR sky130_fd_sc_hd__diode_2
X_8830_ clknet_leaf_97_clk _0951_ VGND VGND VPWR VPWR registers\[13\]\[30\] sky130_fd_sc_hd__dfxtp_1
X_5973_ _2565_ _2692_ VGND VGND VPWR VPWR _2693_ sky130_fd_sc_hd__and2b_1
XANTENNA__5777__A1 net113 VGND VGND VPWR VPWR sky130_fd_sc_hd__diode_2
XTAP_TAPCELL_ROW_48_884 VGND VPWR sky130_fd_sc_hd__tapvpwrvgnd_1
XANTENNA__5321__S0 _2020_ VGND VGND VPWR VPWR sky130_fd_sc_hd__diode_2
X_8761_ clknet_leaf_82_clk _0882_ VGND VGND VPWR VPWR registers\[11\]\[25\] sky130_fd_sc_hd__dfxtp_1
XFILLER_0_35_73 VGND VGND VPWR VPWR sky130_fd_sc_hd__fill_2
XFILLER_0_87_561 VGND VGND VPWR VPWR sky130_fd_sc_hd__fill_2
X_4924_ _1631_ VGND VGND VPWR VPWR _1689_ sky130_fd_sc_hd__buf_6
X_7712_ registers\[24\]\[24\] _3485_ _3779_ VGND VGND VPWR VPWR _3784_ sky130_fd_sc_hd__mux2_1
XANTENNA__6931__S _3346_ VGND VGND VPWR VPWR sky130_fd_sc_hd__diode_2
XFILLER_0_74_222 VGND VGND VPWR VPWR sky130_fd_sc_hd__fill_1
X_8692_ clknet_leaf_84_clk _0813_ VGND VGND VPWR VPWR registers\[0\]\[20\] sky130_fd_sc_hd__dfxtp_1
XFILLER_0_51_61 VGND VGND VPWR VPWR sky130_fd_sc_hd__fill_2
X_7643_ _3119_ registers\[23\]\[24\] _3742_ VGND VGND VPWR VPWR _3747_ sky130_fd_sc_hd__mux2_1
X_4855_ registers\[28\]\[0\] registers\[29\]\[0\] registers\[30\]\[0\] registers\[31\]\[0\]
+ _1617_ net2 VGND VGND VPWR VPWR _1623_ sky130_fd_sc_hd__mux4_1
XFILLER_0_28_661 VGND VGND VPWR VPWR sky130_fd_sc_hd__fill_2
XFILLER_0_35_609 VGND VGND VPWR VPWR sky130_fd_sc_hd__fill_2
X_7574_ _3710_ VGND VGND VPWR VPWR _0208_ sky130_fd_sc_hd__clkbuf_1
X_4786_ registers\[24\]\[28\] registers\[25\]\[28\] registers\[26\]\[28\] registers\[27\]\[28\]
+ _1555_ _1556_ VGND VGND VPWR VPWR _1558_ sky130_fd_sc_hd__mux4_1
X_9313_ clknet_leaf_7_clk _0410_ VGND VGND VPWR VPWR registers\[2\]\[1\] sky130_fd_sc_hd__dfxtp_1
X_6525_ _3133_ registers\[29\]\[31\] _3068_ VGND VGND VPWR VPWR _3134_ sky130_fd_sc_hd__mux2_1
XFILLER_0_70_472 VGND VGND VPWR VPWR sky130_fd_sc_hd__fill_2
X_9244_ clknet_leaf_103_clk _0341_ VGND VGND VPWR VPWR registers\[26\]\[28\] sky130_fd_sc_hd__dfxtp_1
XFILLER_0_15_366 VGND VGND VPWR VPWR sky130_fd_sc_hd__decap_4
XFILLER_0_15_388 VGND VGND VPWR VPWR sky130_fd_sc_hd__fill_2
X_6456_ net47 VGND VGND VPWR VPWR _3087_ sky130_fd_sc_hd__clkbuf_2
Xclkload70 clknet_leaf_94_clk VGND VGND VPWR VPWR clkload70/Y sky130_fd_sc_hd__clkinvlp_2
X_6387_ _3045_ VGND VGND VPWR VPWR _0710_ sky130_fd_sc_hd__clkbuf_1
Xclkload92 clknet_leaf_48_clk VGND VGND VPWR VPWR clkload92/Y sky130_fd_sc_hd__bufinv_16
Xclkload81 clknet_leaf_68_clk VGND VGND VPWR VPWR clkload81/Y sky130_fd_sc_hd__clkinvlp_4
X_5407_ _2026_ _2146_ VGND VGND VPWR VPWR _2147_ sky130_fd_sc_hd__nor2_1
XFILLER_0_11_561 VGND VGND VPWR VPWR sky130_fd_sc_hd__decap_8
X_9175_ clknet_leaf_70_clk _0272_ VGND VGND VPWR VPWR registers\[24\]\[23\] sky130_fd_sc_hd__dfxtp_1
X_5338_ _2079_ _2080_ _2081_ VGND VGND VPWR VPWR _2082_ sky130_fd_sc_hd__mux2_1
X_8126_ _3018_ registers\[30\]\[27\] _3995_ VGND VGND VPWR VPWR _4003_ sky130_fd_sc_hd__mux2_1
X_8057_ _3966_ VGND VGND VPWR VPWR _0435_ sky130_fd_sc_hd__clkbuf_1
XFILLER_0_76_80 VGND VGND VPWR VPWR sky130_fd_sc_hd__fill_2
X_7008_ _3131_ registers\[14\]\[30\] _3360_ VGND VGND VPWR VPWR _3394_ sky130_fd_sc_hd__mux2_1
X_5269_ registers\[24\]\[21\] registers\[25\]\[21\] registers\[26\]\[21\] registers\[27\]\[21\]
+ _1968_ _1969_ VGND VGND VPWR VPWR _2016_ sky130_fd_sc_hd__mux4_1
XANTENNA__7002__S _3383_ VGND VGND VPWR VPWR sky130_fd_sc_hd__diode_2
XFILLER_0_97_358 VGND VGND VPWR VPWR sky130_fd_sc_hd__decap_4
XTAP_TAPCELL_ROW_104_1610 VGND VPWR sky130_fd_sc_hd__tapvpwrvgnd_1
XFILLER_0_66_701 VGND VGND VPWR VPWR sky130_fd_sc_hd__fill_2
X_8959_ clknet_leaf_100_clk _0056_ VGND VGND VPWR VPWR registers\[17\]\[31\] sky130_fd_sc_hd__dfxtp_1
XANTENNA__4976__C1 net5 VGND VGND VPWR VPWR sky130_fd_sc_hd__diode_2
XFILLER_0_38_447 VGND VGND VPWR VPWR sky130_fd_sc_hd__fill_2
XFILLER_0_93_553 VGND VGND VPWR VPWR sky130_fd_sc_hd__fill_2
XANTENNA__5457__S _2076_ VGND VGND VPWR VPWR sky130_fd_sc_hd__diode_2
XFILLER_0_53_417 VPWR VGND VPWR VGND sky130_ef_sc_hd__decap_12
XFILLER_0_34_642 VGND VGND VPWR VPWR sky130_fd_sc_hd__fill_2
XANTENNA__7672__S _3757_ VGND VGND VPWR VPWR sky130_fd_sc_hd__diode_2
XANTENNA__5981__A net87 VGND VGND VPWR VPWR sky130_fd_sc_hd__diode_2
XFILLER_0_61_494 VGND VGND VPWR VPWR sky130_fd_sc_hd__decap_8
XTAP_TAPCELL_ROW_115_1750 VGND VPWR sky130_fd_sc_hd__tapvpwrvgnd_1
XANTENNA__7693__A1 _3466_ VGND VGND VPWR VPWR sky130_fd_sc_hd__diode_2
XANTENNA__4597__A _1153_ VGND VGND VPWR VPWR sky130_fd_sc_hd__diode_2
XFILLER_0_21_369 VGND VGND VPWR VPWR sky130_fd_sc_hd__fill_2
XANTENNA__8069__A _3972_ VGND VGND VPWR VPWR sky130_fd_sc_hd__diode_2
XANTENNA__7445__A1 _3491_ VGND VGND VPWR VPWR sky130_fd_sc_hd__diode_2
XANTENNA__8008__S _3937_ VGND VGND VPWR VPWR sky130_fd_sc_hd__diode_2
XANTENNA__6956__A0 _3079_ VGND VGND VPWR VPWR sky130_fd_sc_hd__diode_2
XANTENNA_clkload6_A clknet_4_7_0_clk VGND VGND VPWR VPWR sky130_fd_sc_hd__diode_2
XFILLER_0_72_38 VGND VGND VPWR VPWR sky130_fd_sc_hd__fill_2
XFILLER_0_72_27 VGND VGND VPWR VPWR sky130_fd_sc_hd__fill_1
XTAP_TAPCELL_ROW_66_1115 VGND VPWR sky130_fd_sc_hd__tapvpwrvgnd_1
XANTENNA__6751__S _3250_ VGND VGND VPWR VPWR sky130_fd_sc_hd__diode_2
XTAP_TAPCELL_ROW_45_843 VGND VPWR sky130_fd_sc_hd__tapvpwrvgnd_1
XFILLER_0_96_380 VGND VGND VPWR VPWR sky130_fd_sc_hd__fill_2
XFILLER_0_84_531 VGND VGND VPWR VPWR sky130_fd_sc_hd__fill_1
XANTENNA__4431__B2 _1034_ VGND VGND VPWR VPWR sky130_fd_sc_hd__diode_2
XFILLER_0_72_715 VGND VGND VPWR VPWR sky130_fd_sc_hd__fill_2
XFILLER_0_71_225 VGND VGND VPWR VPWR sky130_fd_sc_hd__decap_3
XFILLER_0_44_417 VGND VGND VPWR VPWR sky130_fd_sc_hd__decap_3
X_4640_ registers\[16\]\[20\] registers\[17\]\[20\] registers\[18\]\[20\] registers\[19\]\[20\]
+ _1418_ _1419_ VGND VGND VPWR VPWR _1420_ sky130_fd_sc_hd__mux4_1
XANTENNA__7148__A net29 VGND VGND VPWR VPWR sky130_fd_sc_hd__diode_2
XFILLER_0_112_77 VGND VGND VPWR VPWR sky130_fd_sc_hd__decap_4
XFILLER_0_112_55 VGND VGND VPWR VPWR sky130_fd_sc_hd__fill_1
XFILLER_0_107_390 VGND VGND VPWR VPWR sky130_fd_sc_hd__fill_2
X_6310_ net24 VGND VGND VPWR VPWR _2997_ sky130_fd_sc_hd__buf_2
X_4571_ _1353_ _1354_ _1140_ VGND VGND VPWR VPWR _1355_ sky130_fd_sc_hd__mux2_1
XFILLER_0_4_558 VGND VGND VPWR VPWR sky130_fd_sc_hd__decap_3
XFILLER_0_97_35 VGND VGND VPWR VPWR sky130_fd_sc_hd__decap_4
XTAP_TAPCELL_ROW_77_1255 VGND VPWR sky130_fd_sc_hd__tapvpwrvgnd_1
X_7290_ _3559_ VGND VGND VPWR VPWR _0075_ sky130_fd_sc_hd__clkbuf_1
XFILLER_0_52_483 VGND VGND VPWR VPWR sky130_fd_sc_hd__fill_2
XFILLER_0_40_645 VGND VGND VPWR VPWR sky130_fd_sc_hd__fill_2
XFILLER_0_24_185 VGND VGND VPWR VPWR sky130_fd_sc_hd__decap_4
X_6241_ _2930_ _2936_ _2937_ _2946_ _2399_ VGND VGND VPWR VPWR net72 sky130_fd_sc_hd__o32a_1
XTAP_TAPCELL_ROW_77_1266 VGND VPWR sky130_fd_sc_hd__tapvpwrvgnd_1
XTAP_TAPCELL_ROW_90_1433 VGND VPWR sky130_fd_sc_hd__tapvpwrvgnd_1
XANTENNA__4498__A1 _1109_ VGND VGND VPWR VPWR sky130_fd_sc_hd__diode_2
X_6172_ _2707_ _2880_ VGND VGND VPWR VPWR _2881_ sky130_fd_sc_hd__or2_1
X_5123_ registers\[0\]\[12\] registers\[1\]\[12\] registers\[2\]\[12\] registers\[3\]\[12\]
+ _1810_ _1811_ VGND VGND VPWR VPWR _1879_ sky130_fd_sc_hd__mux4_1
X_5054_ _1706_ VGND VGND VPWR VPWR _1814_ sky130_fd_sc_hd__clkbuf_4
X_8813_ clknet_leaf_57_clk _0934_ VGND VGND VPWR VPWR registers\[13\]\[13\] sky130_fd_sc_hd__dfxtp_1
XFILLER_0_79_358 VGND VGND VPWR VPWR sky130_fd_sc_hd__fill_1
XANTENNA__7757__S _3804_ VGND VGND VPWR VPWR sky130_fd_sc_hd__diode_2
XFILLER_0_48_701 VGND VGND VPWR VPWR sky130_fd_sc_hd__decap_6
X_5956_ _2541_ _2676_ _2445_ VGND VGND VPWR VPWR _2677_ sky130_fd_sc_hd__mux2_1
XANTENNA__4970__A _1631_ VGND VGND VPWR VPWR sky130_fd_sc_hd__diode_2
X_8744_ clknet_leaf_42_clk _0865_ VGND VGND VPWR VPWR registers\[11\]\[8\] sky130_fd_sc_hd__dfxtp_1
XFILLER_0_118_633 VGND VGND VPWR VPWR sky130_fd_sc_hd__decap_8
X_5887_ _1866_ _2611_ VGND VGND VPWR VPWR _2612_ sky130_fd_sc_hd__xnor2_1
X_8675_ clknet_leaf_20_clk _0796_ VGND VGND VPWR VPWR registers\[0\]\[3\] sky130_fd_sc_hd__dfxtp_1
XFILLER_0_63_715 VGND VGND VPWR VPWR sky130_fd_sc_hd__fill_2
X_4907_ registers\[12\]\[2\] registers\[13\]\[2\] registers\[14\]\[2\] registers\[15\]\[2\]
+ _1642_ _1643_ VGND VGND VPWR VPWR _1673_ sky130_fd_sc_hd__mux4_1
XFILLER_0_90_523 VGND VGND VPWR VPWR sky130_fd_sc_hd__fill_1
XFILLER_0_90_512 VGND VGND VPWR VPWR sky130_fd_sc_hd__decap_3
X_7626_ _3102_ registers\[23\]\[16\] _3731_ VGND VGND VPWR VPWR _3738_ sky130_fd_sc_hd__mux2_1
XFILLER_0_7_330 VGND VGND VPWR VPWR sky130_fd_sc_hd__fill_2
XANTENNA__5277__S _1856_ VGND VGND VPWR VPWR sky130_fd_sc_hd__diode_2
XTAP_TAPCELL_ROW_23_559 VGND VPWR sky130_fd_sc_hd__tapvpwrvgnd_1
X_4838_ registers\[8\]\[31\] registers\[9\]\[31\] registers\[10\]\[31\] registers\[11\]\[31\]
+ _1433_ _1434_ VGND VGND VPWR VPWR _1607_ sky130_fd_sc_hd__mux4_1
XFILLER_0_118_699 VGND VGND VPWR VPWR sky130_fd_sc_hd__fill_1
XFILLER_0_90_556 VGND VGND VPWR VPWR sky130_fd_sc_hd__fill_1
XFILLER_0_62_225 VGND VGND VPWR VPWR sky130_fd_sc_hd__decap_4
XFILLER_0_16_620 VGND VGND VPWR VPWR sky130_fd_sc_hd__fill_1
XFILLER_0_16_642 VGND VGND VPWR VPWR sky130_fd_sc_hd__fill_2
XFILLER_0_16_653 VGND VGND VPWR VPWR sky130_fd_sc_hd__fill_1
XANTENNA__7492__S _3659_ VGND VGND VPWR VPWR sky130_fd_sc_hd__diode_2
XFILLER_0_90_589 VGND VGND VPWR VPWR sky130_fd_sc_hd__fill_1
X_7557_ _3701_ VGND VGND VPWR VPWR _0200_ sky130_fd_sc_hd__clkbuf_1
XANTENNA__6897__A _3323_ VGND VGND VPWR VPWR sky130_fd_sc_hd__diode_2
XFILLER_0_16_675 VGND VGND VPWR VPWR sky130_fd_sc_hd__fill_2
X_4769_ _1386_ _1541_ VGND VGND VPWR VPWR _1542_ sky130_fd_sc_hd__and2_1
XFILLER_0_70_291 VGND VGND VPWR VPWR sky130_fd_sc_hd__fill_1
X_7488_ _3100_ registers\[21\]\[15\] _3659_ VGND VGND VPWR VPWR _3665_ sky130_fd_sc_hd__mux2_1
X_6508_ _3122_ VGND VGND VPWR VPWR _0754_ sky130_fd_sc_hd__clkbuf_1
X_9227_ clknet_leaf_59_clk _0324_ VGND VGND VPWR VPWR registers\[26\]\[11\] sky130_fd_sc_hd__dfxtp_1
X_6439_ _3075_ registers\[29\]\[3\] _3069_ VGND VGND VPWR VPWR _3076_ sky130_fd_sc_hd__mux2_1
XFILLER_0_113_393 VGND VGND VPWR VPWR sky130_fd_sc_hd__decap_3
XFILLER_0_101_566 VGND VGND VPWR VPWR sky130_fd_sc_hd__decap_3
XFILLER_0_101_555 VGND VGND VPWR VPWR sky130_fd_sc_hd__fill_2
X_9158_ clknet_leaf_42_clk _0255_ VGND VGND VPWR VPWR registers\[24\]\[6\] sky130_fd_sc_hd__dfxtp_1
XFILLER_0_30_188 VGND VGND VPWR VPWR sky130_fd_sc_hd__fill_2
XFILLER_0_101_577 VGND VGND VPWR VPWR sky130_fd_sc_hd__decap_4
XANTENNA__4584__S1 _1204_ VGND VGND VPWR VPWR sky130_fd_sc_hd__diode_2
X_8109_ _3001_ registers\[30\]\[19\] _3984_ VGND VGND VPWR VPWR _3994_ sky130_fd_sc_hd__mux2_1
XANTENNA__6836__S _3299_ VGND VGND VPWR VPWR sky130_fd_sc_hd__diode_2
X_9089_ clknet_leaf_111_clk _0186_ VGND VGND VPWR VPWR registers\[22\]\[1\] sky130_fd_sc_hd__dfxtp_1
XTAP_TAPCELL_ROW_110_1691 VGND VPWR sky130_fd_sc_hd__tapvpwrvgnd_1
XANTENNA__6137__A _2490_ VGND VGND VPWR VPWR sky130_fd_sc_hd__diode_2
XFILLER_0_98_645 VPWR VGND VPWR VGND sky130_ef_sc_hd__decap_12
XFILLER_0_97_122 VGND VGND VPWR VPWR sky130_fd_sc_hd__fill_2
XTAP_TAPCELL_ROW_3_295 VGND VPWR sky130_fd_sc_hd__tapvpwrvgnd_1
XFILLER_0_97_155 VGND VGND VPWR VPWR sky130_fd_sc_hd__decap_3
XFILLER_0_39_701 VGND VGND VPWR VPWR sky130_fd_sc_hd__decap_6
XFILLER_0_66_531 VGND VGND VPWR VPWR sky130_fd_sc_hd__fill_1
XTAP_TAPCELL_ROW_42_802 VGND VPWR sky130_fd_sc_hd__tapvpwrvgnd_1
XFILLER_0_42_19 VGND VGND VPWR VPWR sky130_fd_sc_hd__decap_3
XFILLER_0_39_723 VGND VGND VPWR VPWR sky130_fd_sc_hd__fill_1
XFILLER_0_38_211 VGND VGND VPWR VPWR sky130_fd_sc_hd__fill_2
XFILLER_0_108_132 VGND VGND VPWR VPWR sky130_fd_sc_hd__decap_3
XFILLER_0_93_361 VGND VGND VPWR VPWR sky130_fd_sc_hd__fill_2
XTAP_TAPCELL_ROW_61_1056 VGND VPWR sky130_fd_sc_hd__tapvpwrvgnd_1
XFILLER_0_54_726 VGND VGND VPWR VPWR sky130_fd_sc_hd__fill_2
XANTENNA__6166__A1 _2101_ VGND VGND VPWR VPWR sky130_fd_sc_hd__diode_2
XFILLER_0_109_699 VPWR VGND VPWR VGND sky130_ef_sc_hd__decap_12
XFILLER_0_81_545 VGND VGND VPWR VPWR sky130_fd_sc_hd__fill_2
XFILLER_0_53_225 VGND VGND VPWR VPWR sky130_fd_sc_hd__decap_3
XANTENNA_clkbuf_leaf_91_clk_A clknet_4_8_0_clk VGND VGND VPWR VPWR sky130_fd_sc_hd__diode_2
XFILLER_0_21_100 VGND VGND VPWR VPWR sky130_fd_sc_hd__fill_1
XFILLER_0_22_645 VGND VGND VPWR VPWR sky130_fd_sc_hd__fill_2
XFILLER_0_34_472 VGND VGND VPWR VPWR sky130_fd_sc_hd__fill_2
XANTENNA__7666__A1 _3439_ VGND VGND VPWR VPWR sky130_fd_sc_hd__diode_2
XFILLER_0_22_656 VGND VGND VPWR VPWR sky130_fd_sc_hd__fill_2
XANTENNA__4575__S1 _1137_ VGND VGND VPWR VPWR sky130_fd_sc_hd__diode_2
XFILLER_0_67_49 VGND VGND VPWR VPWR sky130_fd_sc_hd__decap_6
XTAP_TAPCELL_ROW_72_1196 VGND VPWR sky130_fd_sc_hd__tapvpwrvgnd_1
XFILLER_0_88_111 VGND VGND VPWR VPWR sky130_fd_sc_hd__fill_2
XFILLER_0_107_99 VGND VGND VPWR VPWR sky130_fd_sc_hd__fill_1
XFILLER_0_88_166 VGND VGND VPWR VPWR sky130_fd_sc_hd__fill_2
XANTENNA__5886__A _1270_ VGND VGND VPWR VPWR sky130_fd_sc_hd__diode_2
XANTENNA__7577__S _3706_ VGND VGND VPWR VPWR sky130_fd_sc_hd__diode_2
X_5810_ _2347_ _2349_ VGND VGND VPWR VPWR _2539_ sky130_fd_sc_hd__and2_1
XANTENNA_clkbuf_leaf_44_clk_A clknet_4_6_0_clk VGND VGND VPWR VPWR sky130_fd_sc_hd__diode_2
XFILLER_0_9_617 VGND VGND VPWR VPWR sky130_fd_sc_hd__fill_2
XFILLER_0_16_97 VGND VGND VPWR VPWR sky130_fd_sc_hd__fill_2
X_6790_ _3277_ VGND VGND VPWR VPWR _0881_ sky130_fd_sc_hd__clkbuf_1
XFILLER_0_119_419 VGND VGND VPWR VPWR sky130_fd_sc_hd__fill_1
X_5741_ _2468_ _2472_ VGND VGND VPWR VPWR _2473_ sky130_fd_sc_hd__nand2_1
XFILLER_0_45_704 VPWR VGND VPWR VGND sky130_ef_sc_hd__decap_12
XFILLER_0_29_244 VGND VGND VPWR VPWR sky130_fd_sc_hd__fill_1
XFILLER_0_72_501 VGND VGND VPWR VPWR sky130_fd_sc_hd__fill_2
XFILLER_0_8_138 VGND VGND VPWR VPWR sky130_fd_sc_hd__fill_2
X_8460_ registers\[8\]\[24\] net32 _4175_ VGND VGND VPWR VPWR _4180_ sky130_fd_sc_hd__mux2_1
X_7411_ _3624_ VGND VGND VPWR VPWR _0131_ sky130_fd_sc_hd__clkbuf_1
X_5672_ net124 _2313_ _2321_ VGND VGND VPWR VPWR _2406_ sky130_fd_sc_hd__o21a_1
XFILLER_0_4_300 VGND VGND VPWR VPWR sky130_fd_sc_hd__fill_2
XTAP_TAPCELL_ROW_20_518 VGND VPWR sky130_fd_sc_hd__tapvpwrvgnd_1
XANTENNA_clkbuf_leaf_59_clk_A clknet_4_15_0_clk VGND VGND VPWR VPWR sky130_fd_sc_hd__diode_2
XFILLER_0_114_124 VGND VGND VPWR VPWR sky130_fd_sc_hd__fill_2
XANTENNA__5904__A1 net83 VGND VGND VPWR VPWR sky130_fd_sc_hd__diode_2
X_4623_ _1323_ VGND VGND VPWR VPWR _1404_ sky130_fd_sc_hd__clkbuf_8
XANTENNA__4263__S0 _1060_ VGND VGND VPWR VPWR sky130_fd_sc_hd__diode_2
X_8391_ _4143_ VGND VGND VPWR VPWR _0592_ sky130_fd_sc_hd__clkbuf_1
XFILLER_0_115_669 VGND VGND VPWR VPWR sky130_fd_sc_hd__decap_3
X_7342_ _3587_ VGND VGND VPWR VPWR _0099_ sky130_fd_sc_hd__clkbuf_1
X_4554_ _1201_ VGND VGND VPWR VPWR _1338_ sky130_fd_sc_hd__buf_4
XANTENNA_clkbuf_leaf_102_clk_A clknet_4_8_0_clk VGND VGND VPWR VPWR sky130_fd_sc_hd__diode_2
X_7273_ registers\[18\]\[10\] _3455_ _3550_ VGND VGND VPWR VPWR _3551_ sky130_fd_sc_hd__mux2_1
X_4485_ _1271_ _1272_ _1117_ VGND VGND VPWR VPWR _1273_ sky130_fd_sc_hd__mux2_1
X_6224_ _2413_ _2894_ _2420_ VGND VGND VPWR VPWR _2930_ sky130_fd_sc_hd__o21ai_1
XFILLER_0_13_689 VGND VGND VPWR VPWR sky130_fd_sc_hd__fill_2
X_9012_ clknet_leaf_92_clk _0109_ VGND VGND VPWR VPWR registers\[1\]\[20\] sky130_fd_sc_hd__dfxtp_1
XANTENNA__4566__S1 _1128_ VGND VGND VPWR VPWR sky130_fd_sc_hd__diode_2
XFILLER_0_0_583 VGND VGND VPWR VPWR sky130_fd_sc_hd__decap_3
XANTENNA__5560__S _2295_ VGND VGND VPWR VPWR sky130_fd_sc_hd__diode_2
X_6155_ net138 _2734_ _2864_ _2560_ VGND VGND VPWR VPWR _2865_ sky130_fd_sc_hd__a211o_1
XANTENNA__6656__S _3197_ VGND VGND VPWR VPWR sky130_fd_sc_hd__diode_2
X_5106_ registers\[0\]\[11\] registers\[1\]\[11\] registers\[2\]\[11\] registers\[3\]\[11\]
+ _1773_ _1775_ VGND VGND VPWR VPWR _1863_ sky130_fd_sc_hd__mux4_1
XANTENNA__4318__S1 _1113_ VGND VGND VPWR VPWR sky130_fd_sc_hd__diode_2
XFILLER_0_57_82 VGND VGND VPWR VPWR sky130_fd_sc_hd__decap_3
X_6086_ _2011_ _2771_ _2782_ _2034_ VGND VGND VPWR VPWR _2800_ sky130_fd_sc_hd__o22a_1
X_5037_ registers\[20\]\[8\] registers\[21\]\[8\] registers\[22\]\[8\] registers\[23\]\[8\]
+ _1762_ _1764_ VGND VGND VPWR VPWR _1797_ sky130_fd_sc_hd__mux4_1
XFILLER_0_79_111 VGND VGND VPWR VPWR sky130_fd_sc_hd__fill_1
XTAP_TAPCELL_ROW_28_618 VGND VPWR sky130_fd_sc_hd__tapvpwrvgnd_1
XTAP_TAPCELL_ROW_28_629 VGND VPWR sky130_fd_sc_hd__tapvpwrvgnd_1
XTAP_TAPCELL_ROW_0_243 VGND VPWR sky130_fd_sc_hd__tapvpwrvgnd_1
XTAP_TAPCELL_ROW_0_254 VGND VPWR sky130_fd_sc_hd__tapvpwrvgnd_1
XFILLER_0_95_637 VGND VGND VPWR VPWR sky130_fd_sc_hd__decap_6
XANTENNA__7593__A0 _3065_ VGND VGND VPWR VPWR sky130_fd_sc_hd__diode_2
XTAP_TAPCELL_ROW_0_265 VGND VPWR sky130_fd_sc_hd__tapvpwrvgnd_1
XFILLER_0_82_309 VGND VGND VPWR VPWR sky130_fd_sc_hd__decap_8
XFILLER_0_48_542 VGND VGND VPWR VPWR sky130_fd_sc_hd__fill_2
X_8727_ clknet_leaf_68_clk _0848_ VGND VGND VPWR VPWR registers\[10\]\[23\] sky130_fd_sc_hd__dfxtp_1
X_6988_ _3110_ registers\[14\]\[20\] _3383_ VGND VGND VPWR VPWR _3384_ sky130_fd_sc_hd__mux2_1
X_5939_ _1319_ _2660_ VGND VGND VPWR VPWR _2661_ sky130_fd_sc_hd__xnor2_2
XFILLER_0_35_214 VGND VGND VPWR VPWR sky130_fd_sc_hd__decap_4
XFILLER_0_36_715 VGND VGND VPWR VPWR sky130_fd_sc_hd__fill_2
XFILLER_0_106_603 VGND VGND VPWR VPWR sky130_fd_sc_hd__decap_8
X_8658_ clknet_leaf_67_clk _0779_ VGND VGND VPWR VPWR registers\[7\]\[18\] sky130_fd_sc_hd__dfxtp_1
XFILLER_0_8_683 VGND VGND VPWR VPWR sky130_fd_sc_hd__fill_1
XFILLER_0_35_225 VGND VGND VPWR VPWR sky130_fd_sc_hd__decap_4
XFILLER_0_105_113 VGND VGND VPWR VPWR sky130_fd_sc_hd__fill_1
X_8589_ clknet_leaf_52_clk _0710_ VGND VGND VPWR VPWR registers\[3\]\[13\] sky130_fd_sc_hd__dfxtp_1
X_7609_ _3085_ registers\[23\]\[8\] _3720_ VGND VGND VPWR VPWR _3729_ sky130_fd_sc_hd__mux2_1
XFILLER_0_7_160 VGND VGND VPWR VPWR sky130_fd_sc_hd__fill_2
Xclkbuf_4_10_0_clk clknet_0_clk VGND VGND VPWR VPWR clknet_4_10_0_clk sky130_fd_sc_hd__clkbuf_8
XFILLER_0_31_420 VGND VGND VPWR VPWR sky130_fd_sc_hd__decap_3
XFILLER_0_31_453 VGND VGND VPWR VPWR sky130_fd_sc_hd__fill_2
XTAP_TAPCELL_ROW_112_1720 VGND VPWR sky130_fd_sc_hd__tapvpwrvgnd_1
XFILLER_0_101_330 VGND VGND VPWR VPWR sky130_fd_sc_hd__decap_4
XANTENNA__5036__A _1796_ VGND VGND VPWR VPWR sky130_fd_sc_hd__diode_2
XANTENNA__7950__S _3901_ VGND VGND VPWR VPWR sky130_fd_sc_hd__diode_2
Xoutput55 net55 VGND VGND VPWR VPWR alu_result[15] sky130_fd_sc_hd__buf_1
Xoutput66 net66 VGND VGND VPWR VPWR alu_result[25] sky130_fd_sc_hd__buf_1
XANTENNA__4557__S1 _1321_ VGND VGND VPWR VPWR sky130_fd_sc_hd__diode_2
Xoutput77 net77 VGND VGND VPWR VPWR alu_result[6] sky130_fd_sc_hd__buf_1
XTAP_TAPCELL_ROW_8_365 VGND VPWR sky130_fd_sc_hd__tapvpwrvgnd_1
Xoutput99 net99 VGND VGND VPWR VPWR rd1[26] sky130_fd_sc_hd__buf_1
Xoutput88 net88 VGND VGND VPWR VPWR rd1[16] sky130_fd_sc_hd__buf_1
XANTENNA__7251__A _3538_ VGND VGND VPWR VPWR sky130_fd_sc_hd__diode_2
XANTENNA_input23_A wd3[16] VGND VGND VPWR VPWR sky130_fd_sc_hd__diode_2
XANTENNA__7397__S _3612_ VGND VGND VPWR VPWR sky130_fd_sc_hd__diode_2
XFILLER_0_98_486 VGND VGND VPWR VPWR sky130_fd_sc_hd__fill_2
XTAP_TAPCELL_ROW_55_971 VGND VPWR sky130_fd_sc_hd__tapvpwrvgnd_1
XFILLER_0_39_553 VGND VGND VPWR VPWR sky130_fd_sc_hd__decap_4
XFILLER_0_109_441 VGND VGND VPWR VPWR sky130_fd_sc_hd__fill_2
XFILLER_0_66_350 VGND VGND VPWR VPWR sky130_fd_sc_hd__decap_8
XFILLER_0_54_512 VGND VGND VPWR VPWR sky130_fd_sc_hd__fill_2
XFILLER_0_54_523 VGND VGND VPWR VPWR sky130_fd_sc_hd__fill_2
XFILLER_0_109_485 VGND VGND VPWR VPWR sky130_fd_sc_hd__decap_6
XFILLER_0_81_353 VGND VGND VPWR VPWR sky130_fd_sc_hd__fill_2
XFILLER_0_42_707 VGND VGND VPWR VPWR sky130_fd_sc_hd__fill_1
XFILLER_0_14_409 VGND VGND VPWR VPWR sky130_fd_sc_hd__decap_3
XANTENNA__4245__S0 _1039_ VGND VGND VPWR VPWR sky130_fd_sc_hd__diode_2
XFILLER_0_78_37 VGND VGND VPWR VPWR sky130_fd_sc_hd__fill_1
XFILLER_0_34_291 VGND VGND VPWR VPWR sky130_fd_sc_hd__fill_2
XFILLER_0_105_691 VGND VGND VPWR VPWR sky130_fd_sc_hd__fill_2
XFILLER_0_104_190 VGND VGND VPWR VPWR sky130_fd_sc_hd__fill_2
XTAP_TAPCELL_ROW_74_1225 VGND VPWR sky130_fd_sc_hd__tapvpwrvgnd_1
XANTENNA__7860__S _3828_ VGND VGND VPWR VPWR sky130_fd_sc_hd__diode_2
XANTENNA__6311__A1 _2997_ VGND VGND VPWR VPWR sky130_fd_sc_hd__diode_2
XANTENNA__4548__S1 _1199_ VGND VGND VPWR VPWR sky130_fd_sc_hd__diode_2
X_4270_ _1063_ _1065_ _1068_ _1024_ net8 VGND VGND VPWR VPWR _1069_ sky130_fd_sc_hd__a221o_1
XANTENNA__6476__S _3090_ VGND VGND VPWR VPWR sky130_fd_sc_hd__diode_2
XANTENNA__4873__A1 _1616_ VGND VGND VPWR VPWR sky130_fd_sc_hd__diode_2
XFILLER_0_118_65 VPWR VGND VPWR VGND sky130_ef_sc_hd__decap_12
XFILLER_0_27_41 VGND VGND VPWR VPWR sky130_fd_sc_hd__fill_2
XFILLER_0_27_52 VGND VGND VPWR VPWR sky130_fd_sc_hd__fill_2
X_7960_ _3915_ VGND VGND VPWR VPWR _0389_ sky130_fd_sc_hd__clkbuf_1
XFILLER_0_89_453 VGND VGND VPWR VPWR sky130_fd_sc_hd__decap_6
X_7891_ _3094_ registers\[27\]\[12\] _3876_ VGND VGND VPWR VPWR _3879_ sky130_fd_sc_hd__mux2_1
X_6911_ _3342_ VGND VGND VPWR VPWR _0937_ sky130_fd_sc_hd__clkbuf_1
XANTENNA__4720__S1 _1383_ VGND VGND VPWR VPWR sky130_fd_sc_hd__diode_2
XTAP_TAPCELL_ROW_85_1365 VGND VPWR sky130_fd_sc_hd__tapvpwrvgnd_1
X_6842_ registers\[12\]\[16\] _2995_ _3299_ VGND VGND VPWR VPWR _3306_ sky130_fd_sc_hd__mux2_1
XANTENNA__4389__B1 _1142_ VGND VGND VPWR VPWR sky130_fd_sc_hd__diode_2
XFILLER_0_92_607 VGND VGND VPWR VPWR sky130_fd_sc_hd__fill_2
XFILLER_0_92_629 VGND VGND VPWR VPWR sky130_fd_sc_hd__fill_2
XFILLER_0_91_106 VGND VGND VPWR VPWR sky130_fd_sc_hd__decap_4
XANTENNA__4484__S0 _1111_ VGND VGND VPWR VPWR sky130_fd_sc_hd__diode_2
X_6773_ _3268_ VGND VGND VPWR VPWR _0873_ sky130_fd_sc_hd__clkbuf_1
XFILLER_0_64_309 VGND VGND VPWR VPWR sky130_fd_sc_hd__decap_4
XFILLER_0_45_501 VGND VGND VPWR VPWR sky130_fd_sc_hd__decap_3
X_9561_ clknet_leaf_85_clk _0658_ VGND VGND VPWR VPWR registers\[4\]\[25\] sky130_fd_sc_hd__dfxtp_1
XFILLER_0_17_203 VGND VGND VPWR VPWR sky130_fd_sc_hd__fill_2
XFILLER_0_18_704 VPWR VGND VPWR VGND sky130_ef_sc_hd__decap_12
X_5724_ _1108_ _2452_ _2454_ _2456_ VGND VGND VPWR VPWR _2457_ sky130_fd_sc_hd__a211o_1
X_8512_ _4207_ VGND VGND VPWR VPWR _0649_ sky130_fd_sc_hd__clkbuf_1
X_9492_ clknet_leaf_92_clk _0589_ VGND VGND VPWR VPWR registers\[5\]\[20\] sky130_fd_sc_hd__dfxtp_1
XTAP_TAPCELL_ROW_33_687 VGND VPWR sky130_fd_sc_hd__tapvpwrvgnd_1
X_5655_ _2344_ _2389_ VGND VGND VPWR VPWR _2390_ sky130_fd_sc_hd__nand2_1
X_8443_ registers\[8\]\[16\] net23 _4164_ VGND VGND VPWR VPWR _4171_ sky130_fd_sc_hd__mux2_1
XFILLER_0_60_504 VGND VGND VPWR VPWR sky130_fd_sc_hd__fill_2
XFILLER_0_33_729 VGND VGND VPWR VPWR sky130_fd_sc_hd__fill_1
X_8374_ _4134_ VGND VGND VPWR VPWR _0584_ sky130_fd_sc_hd__clkbuf_1
X_4606_ _1381_ _1387_ VGND VGND VPWR VPWR _1388_ sky130_fd_sc_hd__nand2_1
XANTENNA__4236__S0 _1026_ VGND VGND VPWR VPWR sky130_fd_sc_hd__diode_2
XFILLER_0_115_499 VGND VGND VPWR VPWR sky130_fd_sc_hd__decap_3
XPHY_EDGE_ROW_107_Left_227 VGND VGND VPWR VPWR sky130_fd_sc_hd__decap_3
X_5586_ _2270_ VGND VGND VPWR VPWR _2321_ sky130_fd_sc_hd__clkbuf_4
XFILLER_0_103_617 VGND VGND VPWR VPWR sky130_fd_sc_hd__decap_3
X_7325_ _3578_ VGND VGND VPWR VPWR _0091_ sky130_fd_sc_hd__clkbuf_1
XFILLER_0_4_163 VGND VGND VPWR VPWR sky130_fd_sc_hd__fill_2
XFILLER_0_13_453 VGND VGND VPWR VPWR sky130_fd_sc_hd__fill_2
X_4537_ registers\[24\]\[15\] registers\[25\]\[15\] registers\[26\]\[15\] registers\[27\]\[15\]
+ _1320_ _1321_ VGND VGND VPWR VPWR _1322_ sky130_fd_sc_hd__mux4_1
X_4468_ _1255_ _1256_ _1116_ VGND VGND VPWR VPWR _1257_ sky130_fd_sc_hd__mux2_1
XANTENNA__6302__A1 _2991_ VGND VGND VPWR VPWR sky130_fd_sc_hd__diode_2
X_7256_ registers\[18\]\[2\] _3439_ _3539_ VGND VGND VPWR VPWR _3542_ sky130_fd_sc_hd__mux2_1
XANTENNA__6386__S _3041_ VGND VGND VPWR VPWR sky130_fd_sc_hd__diode_2
X_6207_ _2900_ _2901_ _2399_ _2914_ VGND VGND VPWR VPWR net69 sky130_fd_sc_hd__o2bb2a_1
XFILLER_0_0_391 VGND VGND VPWR VPWR sky130_fd_sc_hd__fill_1
X_7187_ _3505_ VGND VGND VPWR VPWR _0026_ sky130_fd_sc_hd__clkbuf_1
XFILLER_0_110_193 VGND VGND VPWR VPWR sky130_fd_sc_hd__fill_1
X_4399_ registers\[8\]\[7\] registers\[9\]\[7\] registers\[10\]\[7\] registers\[11\]\[7\]
+ _1136_ _1137_ VGND VGND VPWR VPWR _1192_ sky130_fd_sc_hd__mux4_1
X_6138_ _2240_ _2242_ net113 VGND VGND VPWR VPWR _2849_ sky130_fd_sc_hd__mux2_1
XTAP_TAPCELL_ROW_5_324 VGND VPWR sky130_fd_sc_hd__tapvpwrvgnd_1
XPHY_EDGE_ROW_116_Left_236 VGND VGND VPWR VPWR sky130_fd_sc_hd__decap_3
X_6069_ _2779_ _2780_ _2783_ VGND VGND VPWR VPWR _2784_ sky130_fd_sc_hd__a21oi_1
XANTENNA__6369__A1 _2972_ VGND VGND VPWR VPWR sky130_fd_sc_hd__diode_2
XTAP_TAPCELL_ROW_52_930 VGND VPWR sky130_fd_sc_hd__tapvpwrvgnd_1
XANTENNA__4475__S0 _1125_ VGND VGND VPWR VPWR sky130_fd_sc_hd__diode_2
XFILLER_0_76_670 VGND VGND VPWR VPWR sky130_fd_sc_hd__decap_4
XFILLER_0_67_169 VGND VGND VPWR VPWR sky130_fd_sc_hd__decap_6
XTAP_TAPCELL_ROW_52_941 VGND VPWR sky130_fd_sc_hd__tapvpwrvgnd_1
XFILLER_0_82_139 VGND VGND VPWR VPWR sky130_fd_sc_hd__fill_1
XFILLER_0_82_128 VGND VGND VPWR VPWR sky130_fd_sc_hd__decap_3
XFILLER_0_76_692 VGND VGND VPWR VPWR sky130_fd_sc_hd__fill_1
XFILLER_0_75_191 VGND VGND VPWR VPWR sky130_fd_sc_hd__fill_2
XFILLER_0_91_673 VPWR VGND VPWR VGND sky130_ef_sc_hd__decap_12
XFILLER_0_24_729 VGND VGND VPWR VPWR sky130_fd_sc_hd__fill_1
XFILLER_0_36_589 VGND VGND VPWR VPWR sky130_fd_sc_hd__fill_2
XFILLER_0_106_444 VGND VGND VPWR VPWR sky130_fd_sc_hd__fill_2
XFILLER_0_90_194 VGND VGND VPWR VPWR sky130_fd_sc_hd__fill_2
XANTENNA__7680__S _3757_ VGND VGND VPWR VPWR sky130_fd_sc_hd__diode_2
XFILLER_0_102_672 VGND VGND VPWR VPWR sky130_fd_sc_hd__fill_2
XANTENNA__6296__S _2983_ VGND VGND VPWR VPWR sky130_fd_sc_hd__diode_2
XANTENNA__4304__B1 _1024_ VGND VGND VPWR VPWR sky130_fd_sc_hd__diode_2
XANTENNA__8046__A1 _3479_ VGND VGND VPWR VPWR sky130_fd_sc_hd__diode_2
XANTENNA__5804__B1 _2328_ VGND VGND VPWR VPWR sky130_fd_sc_hd__diode_2
XANTENNA__8016__S _3937_ VGND VGND VPWR VPWR sky130_fd_sc_hd__diode_2
XFILLER_0_86_467 VGND VGND VPWR VPWR sky130_fd_sc_hd__fill_2
XFILLER_0_117_709 VPWR VGND VPWR VGND sky130_ef_sc_hd__decap_12
XANTENNA__4466__S0 _1197_ VGND VGND VPWR VPWR sky130_fd_sc_hd__diode_2
XFILLER_0_73_106 VGND VGND VPWR VPWR sky130_fd_sc_hd__decap_4
XFILLER_0_67_670 VGND VGND VPWR VPWR sky130_fd_sc_hd__fill_2
XFILLER_0_13_10 VGND VGND VPWR VPWR sky130_fd_sc_hd__fill_2
XFILLER_0_39_383 VGND VGND VPWR VPWR sky130_fd_sc_hd__decap_6
XFILLER_0_13_43 VGND VGND VPWR VPWR sky130_fd_sc_hd__fill_1
XANTENNA__4390__A1_N _1073_ VGND VGND VPWR VPWR sky130_fd_sc_hd__diode_2
XTAP_TAPCELL_ROW_80_1295 VGND VPWR sky130_fd_sc_hd__tapvpwrvgnd_1
XFILLER_0_13_87 VGND VGND VPWR VPWR sky130_fd_sc_hd__fill_2
XTAP_TAPCELL_ROW_30_646 VGND VPWR sky130_fd_sc_hd__tapvpwrvgnd_1
X_5440_ registers\[8\]\[30\] registers\[9\]\[30\] registers\[10\]\[30\] registers\[11\]\[30\]
+ _1758_ _1760_ VGND VGND VPWR VPWR _2178_ sky130_fd_sc_hd__mux4_1
XANTENNA__6532__A1 _2964_ VGND VGND VPWR VPWR sky130_fd_sc_hd__diode_2
XFILLER_0_2_645 VGND VGND VPWR VPWR sky130_fd_sc_hd__fill_2
XFILLER_0_1_111 VGND VGND VPWR VPWR sky130_fd_sc_hd__fill_1
XTAP_TAPCELL_ROW_10_392 VGND VPWR sky130_fd_sc_hd__tapvpwrvgnd_1
X_5371_ _2081_ _2112_ _1756_ VGND VGND VPWR VPWR _2113_ sky130_fd_sc_hd__a21o_1
XFILLER_0_112_469 VGND VGND VPWR VPWR sky130_fd_sc_hd__fill_2
X_4322_ _1114_ _1115_ _1117_ VGND VGND VPWR VPWR _1118_ sky130_fd_sc_hd__mux2_1
X_7110_ net47 VGND VGND VPWR VPWR _3453_ sky130_fd_sc_hd__buf_2
X_8090_ _3972_ VGND VGND VPWR VPWR _3984_ sky130_fd_sc_hd__clkbuf_8
XFILLER_0_2_678 VGND VGND VPWR VPWR sky130_fd_sc_hd__fill_1
X_7041_ _3412_ VGND VGND VPWR VPWR _0997_ sky130_fd_sc_hd__clkbuf_1
X_4253_ net8 VGND VGND VPWR VPWR _1052_ sky130_fd_sc_hd__inv_2
XFILLER_0_1_188 VGND VGND VPWR VPWR sky130_fd_sc_hd__fill_1
XFILLER_0_10_467 VGND VGND VPWR VPWR sky130_fd_sc_hd__decap_3
XANTENNA__5194__S1 _1814_ VGND VGND VPWR VPWR sky130_fd_sc_hd__diode_2
XANTENNA__8037__A1 _3470_ VGND VGND VPWR VPWR sky130_fd_sc_hd__diode_2
XANTENNA__4846__A1 _1438_ VGND VGND VPWR VPWR sky130_fd_sc_hd__diode_2
X_8992_ clknet_leaf_5_clk _0089_ VGND VGND VPWR VPWR registers\[1\]\[0\] sky130_fd_sc_hd__dfxtp_1
X_7943_ _3906_ VGND VGND VPWR VPWR _0381_ sky130_fd_sc_hd__clkbuf_1
XFILLER_0_54_72 VGND VGND VPWR VPWR sky130_fd_sc_hd__decap_6
XTAP_TAPCELL_ROW_38_757 VGND VPWR sky130_fd_sc_hd__tapvpwrvgnd_1
XANTENNA__7548__A0 _3092_ VGND VGND VPWR VPWR sky130_fd_sc_hd__diode_2
X_7874_ _3077_ registers\[27\]\[4\] _3865_ VGND VGND VPWR VPWR _3870_ sky130_fd_sc_hd__mux2_1
XANTENNA__6235__A _2182_ VGND VGND VPWR VPWR sky130_fd_sc_hd__diode_2
XANTENNA__7765__S _3804_ VGND VGND VPWR VPWR sky130_fd_sc_hd__diode_2
XANTENNA__4457__S0 _1196_ VGND VGND VPWR VPWR sky130_fd_sc_hd__diode_2
X_6825_ registers\[12\]\[8\] _2978_ _3288_ VGND VGND VPWR VPWR _3297_ sky130_fd_sc_hd__mux2_1
XTAP_TAPCELL_ROW_18_492 VGND VPWR sky130_fd_sc_hd__tapvpwrvgnd_1
X_6756_ _3259_ VGND VGND VPWR VPWR _0865_ sky130_fd_sc_hd__clkbuf_1
X_9544_ clknet_leaf_25_clk _0641_ VGND VGND VPWR VPWR registers\[4\]\[8\] sky130_fd_sc_hd__dfxtp_1
XFILLER_0_64_139 VGND VGND VPWR VPWR sky130_fd_sc_hd__fill_1
XFILLER_0_58_692 VGND VGND VPWR VPWR sky130_fd_sc_hd__decap_8
XFILLER_0_9_266 VGND VGND VPWR VPWR sky130_fd_sc_hd__fill_1
X_5707_ _2439_ VGND VGND VPWR VPWR _2440_ sky130_fd_sc_hd__inv_2
XFILLER_0_18_556 VGND VGND VPWR VPWR sky130_fd_sc_hd__decap_3
XFILLER_0_115_230 VGND VGND VPWR VPWR sky130_fd_sc_hd__decap_3
XTAP_TAPCELL_ROW_98_1534 VGND VPWR sky130_fd_sc_hd__tapvpwrvgnd_1
X_6687_ registers\[10\]\[8\] _2978_ _3214_ VGND VGND VPWR VPWR _3223_ sky130_fd_sc_hd__mux2_1
XFILLER_0_72_161 VGND VGND VPWR VPWR sky130_fd_sc_hd__fill_2
X_9475_ clknet_leaf_21_clk _0572_ VGND VGND VPWR VPWR registers\[5\]\[3\] sky130_fd_sc_hd__dfxtp_1
XFILLER_0_60_301 VGND VGND VPWR VPWR sky130_fd_sc_hd__fill_2
XANTENNA__5285__S _2031_ VGND VGND VPWR VPWR sky130_fd_sc_hd__diode_2
X_5638_ net113 _2235_ VGND VGND VPWR VPWR _2373_ sky130_fd_sc_hd__nand2_1
X_8426_ registers\[8\]\[8\] net46 _4153_ VGND VGND VPWR VPWR _4162_ sky130_fd_sc_hd__mux2_1
XFILLER_0_5_472 VGND VGND VPWR VPWR sky130_fd_sc_hd__decap_3
X_8357_ _4125_ VGND VGND VPWR VPWR _0576_ sky130_fd_sc_hd__clkbuf_1
XANTENNA__5731__C1 _2362_ VGND VGND VPWR VPWR sky130_fd_sc_hd__diode_2
X_5569_ _2253_ _2304_ VGND VGND VPWR VPWR _2305_ sky130_fd_sc_hd__or2_1
XFILLER_0_5_494 VGND VGND VPWR VPWR sky130_fd_sc_hd__fill_2
XFILLER_0_41_581 VGND VGND VPWR VPWR sky130_fd_sc_hd__fill_2
XFILLER_0_13_272 VGND VGND VPWR VPWR sky130_fd_sc_hd__fill_2
X_7308_ registers\[18\]\[27\] _3491_ _3561_ VGND VGND VPWR VPWR _3569_ sky130_fd_sc_hd__mux2_1
X_8288_ _2976_ registers\[31\]\[7\] _4081_ VGND VGND VPWR VPWR _4089_ sky130_fd_sc_hd__mux2_1
XANTENNA__5185__S1 _1743_ VGND VGND VPWR VPWR sky130_fd_sc_hd__diode_2
X_7239_ _3532_ VGND VGND VPWR VPWR _0051_ sky130_fd_sc_hd__clkbuf_1
XANTENNA__6844__S _3299_ VGND VGND VPWR VPWR sky130_fd_sc_hd__diode_2
XTAP_TAPCELL_ROW_107_1652 VGND VPWR sky130_fd_sc_hd__tapvpwrvgnd_1
XFILLER_0_96_721 VGND VGND VPWR VPWR sky130_fd_sc_hd__decap_8
XANTENNA__5262__B2 _1756_ VGND VGND VPWR VPWR sky130_fd_sc_hd__diode_2
XANTENNA__4696__S0 _1323_ VGND VGND VPWR VPWR sky130_fd_sc_hd__diode_2
XANTENNA__7539__A0 _3083_ VGND VGND VPWR VPWR sky130_fd_sc_hd__diode_2
XFILLER_0_68_489 VGND VGND VPWR VPWR sky130_fd_sc_hd__fill_2
XFILLER_0_28_309 VGND VGND VPWR VPWR sky130_fd_sc_hd__fill_2
XANTENNA__6762__A1 _2985_ VGND VGND VPWR VPWR sky130_fd_sc_hd__diode_2
XFILLER_0_50_19 VGND VGND VPWR VPWR sky130_fd_sc_hd__fill_2
XANTENNA__4999__S1 _1760_ VGND VGND VPWR VPWR sky130_fd_sc_hd__diode_2
XFILLER_0_64_662 VGND VGND VPWR VPWR sky130_fd_sc_hd__decap_4
XFILLER_0_64_640 VGND VGND VPWR VPWR sky130_fd_sc_hd__fill_2
XANTENNA__5195__S _1767_ VGND VGND VPWR VPWR sky130_fd_sc_hd__diode_2
XFILLER_0_64_673 VPWR VGND VPWR VGND sky130_ef_sc_hd__decap_12
XFILLER_0_24_515 VGND VGND VPWR VPWR sky130_fd_sc_hd__fill_1
XFILLER_0_24_537 VGND VGND VPWR VPWR sky130_fd_sc_hd__fill_2
XFILLER_0_91_492 VGND VGND VPWR VPWR sky130_fd_sc_hd__fill_2
XFILLER_0_106_285 VGND VGND VPWR VPWR sky130_fd_sc_hd__fill_2
XTAP_TAPCELL_ROW_58_1017 VGND VPWR sky130_fd_sc_hd__tapvpwrvgnd_1
XFILLER_0_51_378 VGND VGND VPWR VPWR sky130_fd_sc_hd__fill_2
XTAP_TAPCELL_ROW_118_1792 VGND VPWR sky130_fd_sc_hd__tapvpwrvgnd_1
XANTENNA__4620__S0 _1338_ VGND VGND VPWR VPWR sky130_fd_sc_hd__diode_2
XFILLER_0_115_11 VPWR VGND VPWR VGND sky130_ef_sc_hd__decap_12
XTAP_TAPCELL_ROW_69_1157 VGND VPWR sky130_fd_sc_hd__tapvpwrvgnd_1
XANTENNA__4687__S0 _1338_ VGND VGND VPWR VPWR sky130_fd_sc_hd__diode_2
XFILLER_0_86_231 VGND VGND VPWR VPWR sky130_fd_sc_hd__fill_2
X_4940_ _1704_ VGND VGND VPWR VPWR net106 sky130_fd_sc_hd__inv_2
XTAP_TAPCELL_ROW_35_716 VGND VPWR sky130_fd_sc_hd__tapvpwrvgnd_1
XTAP_TAPCELL_ROW_82_1324 VGND VPWR sky130_fd_sc_hd__tapvpwrvgnd_1
X_4871_ _1637_ _1638_ _1621_ VGND VGND VPWR VPWR _1639_ sky130_fd_sc_hd__mux2_1
X_6610_ registers\[0\]\[5\] _2972_ _3175_ VGND VGND VPWR VPWR _3181_ sky130_fd_sc_hd__mux2_1
XFILLER_0_74_448 VGND VGND VPWR VPWR sky130_fd_sc_hd__fill_2
XFILLER_0_46_128 VGND VGND VPWR VPWR sky130_fd_sc_hd__decap_3
XANTENNA__7585__S _3706_ VGND VGND VPWR VPWR sky130_fd_sc_hd__diode_2
XTAP_TAPCELL_ROW_15_451 VGND VPWR sky130_fd_sc_hd__tapvpwrvgnd_1
X_7590_ _3718_ VGND VGND VPWR VPWR _0216_ sky130_fd_sc_hd__clkbuf_1
X_6541_ _3143_ VGND VGND VPWR VPWR _0766_ sky130_fd_sc_hd__clkbuf_1
XANTENNA__5100__S1 _1701_ VGND VGND VPWR VPWR sky130_fd_sc_hd__diode_2
XANTENNA__6753__A1 _2976_ VGND VGND VPWR VPWR sky130_fd_sc_hd__diode_2
XANTENNA__7950__A0 _2978_ VGND VGND VPWR VPWR sky130_fd_sc_hd__diode_2
XFILLER_0_7_726 VGND VGND VPWR VPWR sky130_fd_sc_hd__fill_2
XFILLER_0_54_161 VGND VGND VPWR VPWR sky130_fd_sc_hd__fill_2
XFILLER_0_40_52 VGND VGND VPWR VPWR sky130_fd_sc_hd__decap_3
X_6472_ net21 VGND VGND VPWR VPWR _3098_ sky130_fd_sc_hd__clkbuf_2
X_9260_ clknet_leaf_40_clk _0357_ VGND VGND VPWR VPWR registers\[27\]\[12\] sky130_fd_sc_hd__dfxtp_1
XFILLER_0_70_643 VGND VGND VPWR VPWR sky130_fd_sc_hd__fill_1
XFILLER_0_40_85 VGND VGND VPWR VPWR sky130_fd_sc_hd__fill_1
X_9191_ clknet_leaf_25_clk _0288_ VGND VGND VPWR VPWR registers\[25\]\[7\] sky130_fd_sc_hd__dfxtp_1
XFILLER_0_70_687 VGND VGND VPWR VPWR sky130_fd_sc_hd__decap_3
XANTENNA__6929__S _3346_ VGND VGND VPWR VPWR sky130_fd_sc_hd__diode_2
X_5423_ _2160_ _2161_ _2076_ VGND VGND VPWR VPWR _2162_ sky130_fd_sc_hd__mux2_1
X_8211_ _4048_ VGND VGND VPWR VPWR _0507_ sky130_fd_sc_hd__clkbuf_1
XFILLER_0_100_406 VGND VGND VPWR VPWR sky130_fd_sc_hd__fill_1
XANTENNA__4611__S0 _1390_ VGND VGND VPWR VPWR sky130_fd_sc_hd__diode_2
X_8142_ registers\[9\]\[2\] _3439_ _4009_ VGND VGND VPWR VPWR _4012_ sky130_fd_sc_hd__mux2_1
XANTENNA__8258__A1 _3487_ VGND VGND VPWR VPWR sky130_fd_sc_hd__diode_2
X_5354_ _1758_ VGND VGND VPWR VPWR _2097_ sky130_fd_sc_hd__buf_4
XTAP_TAPCELL_ROW_93_1464 VGND VPWR sky130_fd_sc_hd__tapvpwrvgnd_1
X_4305_ registers\[8\]\[3\] registers\[9\]\[3\] registers\[10\]\[3\] registers\[11\]\[3\]
+ _1039_ _1040_ VGND VGND VPWR VPWR _1102_ sky130_fd_sc_hd__mux4_1
XFILLER_0_10_253 VGND VGND VPWR VPWR sky130_fd_sc_hd__fill_2
XFILLER_0_49_83 VGND VGND VPWR VPWR sky130_fd_sc_hd__fill_2
X_8073_ _3975_ VGND VGND VPWR VPWR _0442_ sky130_fd_sc_hd__clkbuf_1
X_5285_ _2029_ _2030_ _2031_ VGND VGND VPWR VPWR _2032_ sky130_fd_sc_hd__mux2_1
X_7024_ _3403_ VGND VGND VPWR VPWR _0989_ sky130_fd_sc_hd__clkbuf_1
X_4236_ registers\[24\]\[0\] registers\[25\]\[0\] registers\[26\]\[0\] registers\[27\]\[0\]
+ _1026_ _1027_ VGND VGND VPWR VPWR _1036_ sky130_fd_sc_hd__mux4_1
XANTENNA__7769__A0 _3108_ VGND VGND VPWR VPWR sky130_fd_sc_hd__diode_2
XANTENNA__6664__S _3174_ VGND VGND VPWR VPWR sky130_fd_sc_hd__diode_2
XFILLER_0_65_71 VGND VGND VPWR VPWR sky130_fd_sc_hd__fill_2
XFILLER_0_78_710 VGND VGND VPWR VPWR sky130_fd_sc_hd__fill_2
X_8975_ clknet_leaf_66_clk _0072_ VGND VGND VPWR VPWR registers\[18\]\[15\] sky130_fd_sc_hd__dfxtp_1
XANTENNA__4678__S0 _1382_ VGND VGND VPWR VPWR sky130_fd_sc_hd__diode_2
X_7926_ _3129_ registers\[27\]\[29\] _3887_ VGND VGND VPWR VPWR _3897_ sky130_fd_sc_hd__mux2_1
XFILLER_0_93_724 VGND VGND VPWR VPWR sky130_fd_sc_hd__decap_4
XFILLER_0_93_713 VGND VGND VPWR VPWR sky130_fd_sc_hd__decap_8
XFILLER_0_65_415 VGND VGND VPWR VPWR sky130_fd_sc_hd__fill_2
X_7857_ _3860_ VGND VGND VPWR VPWR _0341_ sky130_fd_sc_hd__clkbuf_1
X_6808_ _3287_ VGND VGND VPWR VPWR _3288_ sky130_fd_sc_hd__buf_4
XFILLER_0_108_528 VGND VGND VPWR VPWR sky130_fd_sc_hd__fill_2
XTAP_TAPCELL_ROW_102_1582 VGND VPWR sky130_fd_sc_hd__tapvpwrvgnd_1
XANTENNA__5547__A2 _2216_ VGND VGND VPWR VPWR sky130_fd_sc_hd__diode_2
XFILLER_0_46_662 VGND VGND VPWR VPWR sky130_fd_sc_hd__decap_4
X_7788_ _3127_ registers\[25\]\[28\] _3815_ VGND VGND VPWR VPWR _3824_ sky130_fd_sc_hd__mux2_1
XFILLER_0_92_278 VGND VGND VPWR VPWR sky130_fd_sc_hd__fill_2
X_9527_ clknet_leaf_71_clk _0624_ VGND VGND VPWR VPWR registers\[8\]\[23\] sky130_fd_sc_hd__dfxtp_1
X_6739_ registers\[11\]\[0\] _2958_ _3250_ VGND VGND VPWR VPWR _3251_ sky130_fd_sc_hd__mux2_1
XFILLER_0_18_375 VGND VGND VPWR VPWR sky130_fd_sc_hd__fill_2
XFILLER_0_116_583 VGND VGND VPWR VPWR sky130_fd_sc_hd__fill_2
XFILLER_0_116_572 VGND VGND VPWR VPWR sky130_fd_sc_hd__fill_2
XFILLER_0_116_561 VGND VGND VPWR VPWR sky130_fd_sc_hd__fill_2
XFILLER_0_104_723 VGND VGND VPWR VPWR sky130_fd_sc_hd__decap_6
XFILLER_0_104_701 VGND VGND VPWR VPWR sky130_fd_sc_hd__fill_2
XFILLER_0_60_131 VGND VGND VPWR VPWR sky130_fd_sc_hd__fill_2
X_9458_ clknet_leaf_67_clk _0555_ VGND VGND VPWR VPWR registers\[31\]\[18\] sky130_fd_sc_hd__dfxtp_1
X_8409_ _4152_ VGND VGND VPWR VPWR _4153_ sky130_fd_sc_hd__clkbuf_8
XFILLER_0_103_266 VGND VGND VPWR VPWR sky130_fd_sc_hd__fill_2
X_9389_ clknet_leaf_50_clk _0486_ VGND VGND VPWR VPWR registers\[9\]\[13\] sky130_fd_sc_hd__dfxtp_1
XFILLER_0_60_197 VGND VGND VPWR VPWR sky130_fd_sc_hd__fill_2
XANTENNA__4602__S0 _1382_ VGND VGND VPWR VPWR sky130_fd_sc_hd__diode_2
XANTENNA__7524__A _3683_ VGND VGND VPWR VPWR sky130_fd_sc_hd__diode_2
XANTENNA__4359__S _1153_ VGND VGND VPWR VPWR sky130_fd_sc_hd__diode_2
XANTENNA__6574__S _3159_ VGND VGND VPWR VPWR sky130_fd_sc_hd__diode_2
XFILLER_0_69_732 VGND VGND VPWR VPWR sky130_fd_sc_hd__fill_1
XANTENNA__5330__S1 _2073_ VGND VGND VPWR VPWR sky130_fd_sc_hd__diode_2
XANTENNA__8090__A _3972_ VGND VGND VPWR VPWR sky130_fd_sc_hd__diode_2
XANTENNA__4822__S _1379_ VGND VGND VPWR VPWR sky130_fd_sc_hd__diode_2
XFILLER_0_28_139 VGND VGND VPWR VPWR sky130_fd_sc_hd__fill_1
XTAP_TAPCELL_ROW_64_1087 VGND VPWR sky130_fd_sc_hd__tapvpwrvgnd_1
XTAP_TAPCELL_ROW_12_410 VGND VPWR sky130_fd_sc_hd__tapvpwrvgnd_1
XFILLER_0_64_481 VGND VGND VPWR VPWR sky130_fd_sc_hd__fill_2
XFILLER_0_37_695 VGND VGND VPWR VPWR sky130_fd_sc_hd__fill_2
XFILLER_0_37_673 VGND VGND VPWR VPWR sky130_fd_sc_hd__decap_4
XTAP_TAPCELL_ROW_12_421 VGND VPWR sky130_fd_sc_hd__tapvpwrvgnd_1
XFILLER_0_51_131 VGND VGND VPWR VPWR sky130_fd_sc_hd__fill_2
XANTENNA__5219__A _1811_ VGND VGND VPWR VPWR sky130_fd_sc_hd__diode_2
XTAP_TAPCELL_ROW_40_785 VGND VPWR sky130_fd_sc_hd__tapvpwrvgnd_1
XTAP_TAPCELL_ROW_40_774 VGND VPWR sky130_fd_sc_hd__tapvpwrvgnd_1
XFILLER_0_4_729 VGND VGND VPWR VPWR sky130_fd_sc_hd__decap_4
XFILLER_0_3_206 VGND VGND VPWR VPWR sky130_fd_sc_hd__fill_2
XFILLER_0_24_334 VGND VGND VPWR VPWR sky130_fd_sc_hd__fill_2
XANTENNA__6749__S _3250_ VGND VGND VPWR VPWR sky130_fd_sc_hd__diode_2
XFILLER_0_101_57 VGND VGND VPWR VPWR sky130_fd_sc_hd__fill_2
XFILLER_0_51_175 VGND VGND VPWR VPWR sky130_fd_sc_hd__decap_3
XANTENNA__5397__S1 _2109_ VGND VGND VPWR VPWR sky130_fd_sc_hd__diode_2
XFILLER_0_86_15 VGND VGND VPWR VPWR sky130_fd_sc_hd__decap_3
XANTENNA__5171__B1 _1655_ VGND VGND VPWR VPWR sky130_fd_sc_hd__diode_2
XANTENNA__5149__S1 _1749_ VGND VGND VPWR VPWR sky130_fd_sc_hd__diode_2
XANTENNA__4269__S _1030_ VGND VGND VPWR VPWR sky130_fd_sc_hd__diode_2
X_5070_ registers\[0\]\[9\] registers\[1\]\[9\] registers\[2\]\[9\] registers\[3\]\[9\]
+ _1806_ _1759_ VGND VGND VPWR VPWR _1829_ sky130_fd_sc_hd__mux4_1
XANTENNA__8412__A1 net27 VGND VGND VPWR VPWR sky130_fd_sc_hd__diode_2
X_5972_ _2445_ _2467_ VGND VGND VPWR VPWR _2692_ sky130_fd_sc_hd__nor2_2
XFILLER_0_59_231 VGND VGND VPWR VPWR sky130_fd_sc_hd__fill_2
XFILLER_0_59_220 VGND VGND VPWR VPWR sky130_fd_sc_hd__fill_2
XTAP_TAPCELL_ROW_48_885 VGND VPWR sky130_fd_sc_hd__tapvpwrvgnd_1
XANTENNA__5321__S1 _2021_ VGND VGND VPWR VPWR sky130_fd_sc_hd__diode_2
X_8760_ clknet_leaf_89_clk _0881_ VGND VGND VPWR VPWR registers\[11\]\[24\] sky130_fd_sc_hd__dfxtp_1
XFILLER_0_35_85 VGND VGND VPWR VPWR sky130_fd_sc_hd__fill_2
X_4923_ _1683_ _1686_ _1687_ VGND VGND VPWR VPWR _1688_ sky130_fd_sc_hd__mux2_1
X_7711_ _3783_ VGND VGND VPWR VPWR _0272_ sky130_fd_sc_hd__clkbuf_1
X_8691_ clknet_leaf_14_clk _0812_ VGND VGND VPWR VPWR registers\[0\]\[19\] sky130_fd_sc_hd__dfxtp_1
XANTENNA__4732__S _1379_ VGND VGND VPWR VPWR sky130_fd_sc_hd__diode_2
XFILLER_0_19_128 VGND VGND VPWR VPWR sky130_fd_sc_hd__fill_1
XANTENNA__5085__S0 _1773_ VGND VGND VPWR VPWR sky130_fd_sc_hd__diode_2
XFILLER_0_74_267 VGND VGND VPWR VPWR sky130_fd_sc_hd__fill_2
X_4854_ _1619_ _1620_ _1621_ VGND VGND VPWR VPWR _1622_ sky130_fd_sc_hd__mux2_1
XFILLER_0_28_640 VGND VGND VPWR VPWR sky130_fd_sc_hd__fill_2
X_7642_ _3746_ VGND VGND VPWR VPWR _0240_ sky130_fd_sc_hd__clkbuf_1
XFILLER_0_105_509 VGND VGND VPWR VPWR sky130_fd_sc_hd__decap_4
XFILLER_0_51_95 VGND VGND VPWR VPWR sky130_fd_sc_hd__fill_2
XFILLER_0_43_610 VGND VGND VPWR VPWR sky130_fd_sc_hd__decap_4
X_4785_ registers\[28\]\[28\] registers\[29\]\[28\] registers\[30\]\[28\] registers\[31\]\[28\]
+ _1555_ _1556_ VGND VGND VPWR VPWR _1557_ sky130_fd_sc_hd__mux4_1
X_7573_ _3117_ registers\[22\]\[23\] _3706_ VGND VGND VPWR VPWR _3710_ sky130_fd_sc_hd__mux2_1
X_9312_ clknet_leaf_5_clk _0409_ VGND VGND VPWR VPWR registers\[2\]\[0\] sky130_fd_sc_hd__dfxtp_1
XFILLER_0_27_194 VGND VGND VPWR VPWR sky130_fd_sc_hd__decap_4
X_6524_ net40 VGND VGND VPWR VPWR _3133_ sky130_fd_sc_hd__clkbuf_2
XFILLER_0_43_687 VGND VGND VPWR VPWR sky130_fd_sc_hd__decap_8
X_9243_ clknet_leaf_102_clk _0340_ VGND VGND VPWR VPWR registers\[26\]\[27\] sky130_fd_sc_hd__dfxtp_1
XFILLER_0_101_715 VGND VGND VPWR VPWR sky130_fd_sc_hd__fill_2
X_6455_ _3086_ VGND VGND VPWR VPWR _0737_ sky130_fd_sc_hd__clkbuf_1
Xclkload71 clknet_leaf_96_clk VGND VGND VPWR VPWR clkload71/Y sky130_fd_sc_hd__clkinv_4
XANTENNA__4968__A _1617_ VGND VGND VPWR VPWR sky130_fd_sc_hd__diode_2
XFILLER_0_42_197 VGND VGND VPWR VPWR sky130_fd_sc_hd__fill_2
XFILLER_0_42_175 VGND VGND VPWR VPWR sky130_fd_sc_hd__fill_2
XFILLER_0_2_250 VGND VGND VPWR VPWR sky130_fd_sc_hd__fill_2
Xclkload60 clknet_leaf_85_clk VGND VGND VPWR VPWR clkload60/Y sky130_fd_sc_hd__clkinvlp_2
XFILLER_0_30_337 VGND VGND VPWR VPWR sky130_fd_sc_hd__fill_2
X_6386_ registers\[3\]\[13\] _2989_ _3041_ VGND VGND VPWR VPWR _3045_ sky130_fd_sc_hd__mux2_1
Xclkload93 clknet_leaf_51_clk VGND VGND VPWR VPWR clkload93/Y sky130_fd_sc_hd__bufinv_16
Xclkload82 clknet_leaf_69_clk VGND VGND VPWR VPWR clkload82/Y sky130_fd_sc_hd__clkinvlp_2
X_5406_ _2144_ _2145_ _2081_ VGND VGND VPWR VPWR _2146_ sky130_fd_sc_hd__mux2_1
X_9174_ clknet_leaf_93_clk _0271_ VGND VGND VPWR VPWR registers\[24\]\[22\] sky130_fd_sc_hd__dfxtp_1
X_5337_ _1768_ VGND VGND VPWR VPWR _2081_ sky130_fd_sc_hd__buf_4
X_8125_ _4002_ VGND VGND VPWR VPWR _0467_ sky130_fd_sc_hd__clkbuf_1
X_5268_ registers\[28\]\[21\] registers\[29\]\[21\] registers\[30\]\[21\] registers\[31\]\[21\]
+ _1968_ _1969_ VGND VGND VPWR VPWR _2015_ sky130_fd_sc_hd__mux4_1
X_8056_ registers\[2\]\[26\] _3489_ _3959_ VGND VGND VPWR VPWR _3966_ sky130_fd_sc_hd__mux2_1
XANTENNA__6394__S _3041_ VGND VGND VPWR VPWR sky130_fd_sc_hd__diode_2
X_7007_ _3393_ VGND VGND VPWR VPWR _0982_ sky130_fd_sc_hd__clkbuf_1
XANTENNA__4899__S0 _1617_ VGND VGND VPWR VPWR sky130_fd_sc_hd__diode_2
X_5199_ _1946_ _1949_ _1714_ VGND VGND VPWR VPWR _1950_ sky130_fd_sc_hd__mux2_1
XANTENNA__5949__D _2413_ VGND VGND VPWR VPWR sky130_fd_sc_hd__diode_2
XFILLER_0_97_337 VGND VGND VPWR VPWR sky130_fd_sc_hd__fill_2
X_8958_ clknet_leaf_97_clk _0055_ VGND VGND VPWR VPWR registers\[17\]\[30\] sky130_fd_sc_hd__dfxtp_1
XTAP_TAPCELL_ROW_104_1611 VGND VPWR sky130_fd_sc_hd__tapvpwrvgnd_1
X_7909_ _3888_ VGND VGND VPWR VPWR _0365_ sky130_fd_sc_hd__clkbuf_1
X_8889_ clknet_leaf_81_clk _1010_ VGND VGND VPWR VPWR registers\[15\]\[25\] sky130_fd_sc_hd__dfxtp_1
XFILLER_0_65_256 VGND VGND VPWR VPWR sky130_fd_sc_hd__fill_2
XFILLER_0_65_245 VGND VGND VPWR VPWR sky130_fd_sc_hd__fill_2
XANTENNA__8114__S _3995_ VGND VGND VPWR VPWR sky130_fd_sc_hd__diode_2
XFILLER_0_19_640 VGND VGND VPWR VPWR sky130_fd_sc_hd__fill_2
XANTENNA__4642__S _1421_ VGND VGND VPWR VPWR sky130_fd_sc_hd__diode_2
XFILLER_0_93_576 VGND VGND VPWR VPWR sky130_fd_sc_hd__fill_2
XFILLER_0_53_429 VPWR VGND VPWR VGND sky130_ef_sc_hd__decap_12
XFILLER_0_18_161 VGND VGND VPWR VPWR sky130_fd_sc_hd__fill_2
XFILLER_0_108_369 VGND VGND VPWR VPWR sky130_fd_sc_hd__fill_2
XANTENNA__4823__S0 _1382_ VGND VGND VPWR VPWR sky130_fd_sc_hd__diode_2
XANTENNA__5039__A _1691_ VGND VGND VPWR VPWR sky130_fd_sc_hd__diode_2
XFILLER_0_34_665 VGND VGND VPWR VPWR sky130_fd_sc_hd__fill_2
XANTENNA__6569__S _3148_ VGND VGND VPWR VPWR sky130_fd_sc_hd__diode_2
XTAP_TAPCELL_ROW_115_1751 VGND VPWR sky130_fd_sc_hd__tapvpwrvgnd_1
XFILLER_0_56_29 VGND VGND VPWR VPWR sky130_fd_sc_hd__decap_4
XFILLER_0_88_304 VGND VGND VPWR VPWR sky130_fd_sc_hd__decap_4
XFILLER_0_88_359 VGND VGND VPWR VPWR sky130_fd_sc_hd__decap_4
XTAP_TAPCELL_ROW_66_1116 VGND VPWR sky130_fd_sc_hd__tapvpwrvgnd_1
XFILLER_0_57_702 VGND VGND VPWR VPWR sky130_fd_sc_hd__decap_6
XTAP_TAPCELL_ROW_45_844 VGND VPWR sky130_fd_sc_hd__tapvpwrvgnd_1
XFILLER_0_84_521 VGND VGND VPWR VPWR sky130_fd_sc_hd__fill_1
XFILLER_0_84_543 VGND VGND VPWR VPWR sky130_fd_sc_hd__fill_1
XFILLER_0_72_705 VGND VGND VPWR VPWR sky130_fd_sc_hd__fill_1
XANTENNA__7905__A0 _3108_ VGND VGND VPWR VPWR sky130_fd_sc_hd__diode_2
XANTENNA__5916__C1 _2276_ VGND VGND VPWR VPWR sky130_fd_sc_hd__diode_2
XFILLER_0_84_576 VGND VGND VPWR VPWR sky130_fd_sc_hd__fill_2
XANTENNA__5067__S0 _1809_ VGND VGND VPWR VPWR sky130_fd_sc_hd__diode_2
XFILLER_0_16_109 VGND VGND VPWR VPWR sky130_fd_sc_hd__fill_2
XTAP_TAPCELL_ROW_25_590 VGND VPWR sky130_fd_sc_hd__tapvpwrvgnd_1
XFILLER_0_112_45 VGND VGND VPWR VPWR sky130_fd_sc_hd__fill_1
X_4570_ registers\[0\]\[16\] registers\[1\]\[16\] registers\[2\]\[16\] registers\[3\]\[16\]
+ _1126_ _1128_ VGND VGND VPWR VPWR _1354_ sky130_fd_sc_hd__mux4_1
XFILLER_0_21_32 VGND VGND VPWR VPWR sky130_fd_sc_hd__decap_3
XFILLER_0_25_621 VGND VGND VPWR VPWR sky130_fd_sc_hd__fill_2
XFILLER_0_4_537 VGND VGND VPWR VPWR sky130_fd_sc_hd__fill_2
XFILLER_0_24_153 VGND VGND VPWR VPWR sky130_fd_sc_hd__decap_4
XTAP_TAPCELL_ROW_77_1256 VGND VPWR sky130_fd_sc_hd__tapvpwrvgnd_1
XANTENNA__7133__A1 _3468_ VGND VGND VPWR VPWR sky130_fd_sc_hd__diode_2
XANTENNA__6479__S _3090_ VGND VGND VPWR VPWR sky130_fd_sc_hd__diode_2
XFILLER_0_52_495 VGND VGND VPWR VPWR sky130_fd_sc_hd__fill_1
XANTENNA_clkbuf_leaf_3_clk_A clknet_4_1_0_clk VGND VGND VPWR VPWR sky130_fd_sc_hd__diode_2
XFILLER_0_12_304 VGND VGND VPWR VPWR sky130_fd_sc_hd__fill_2
XFILLER_0_12_337 VGND VGND VPWR VPWR sky130_fd_sc_hd__decap_4
XANTENNA__8330__A0 _3018_ VGND VGND VPWR VPWR sky130_fd_sc_hd__diode_2
X_6240_ _2942_ _2945_ VGND VGND VPWR VPWR _2946_ sky130_fd_sc_hd__xor2_1
XANTENNA__5695__B2 _2428_ VGND VGND VPWR VPWR sky130_fd_sc_hd__diode_2
XTAP_TAPCELL_ROW_90_1434 VGND VPWR sky130_fd_sc_hd__tapvpwrvgnd_1
XTAP_TAPCELL_ROW_90_1423 VGND VPWR sky130_fd_sc_hd__tapvpwrvgnd_1
X_6171_ _2202_ _2209_ _2815_ VGND VGND VPWR VPWR _2880_ sky130_fd_sc_hd__nor3_1
XFILLER_0_110_589 VGND VGND VPWR VPWR sky130_fd_sc_hd__fill_2
X_5122_ _1752_ _1877_ VGND VGND VPWR VPWR _1878_ sky130_fd_sc_hd__or2_1
X_5053_ _1809_ _1812_ _1655_ VGND VGND VPWR VPWR _1813_ sky130_fd_sc_hd__o21a_1
XFILLER_0_79_304 VPWR VGND VPWR VGND sky130_ef_sc_hd__decap_12
XFILLER_0_46_73 VGND VGND VPWR VPWR sky130_fd_sc_hd__decap_4
X_8812_ clknet_leaf_45_clk _0933_ VGND VGND VPWR VPWR registers\[13\]\[12\] sky130_fd_sc_hd__dfxtp_1
X_8743_ clknet_leaf_29_clk _0864_ VGND VGND VPWR VPWR registers\[11\]\[7\] sky130_fd_sc_hd__dfxtp_1
X_5955_ _2617_ _2675_ _2295_ VGND VGND VPWR VPWR _2676_ sky130_fd_sc_hd__mux2_1
XFILLER_0_47_223 VGND VGND VPWR VPWR sky130_fd_sc_hd__fill_1
XANTENNA__4462__S _1031_ VGND VGND VPWR VPWR sky130_fd_sc_hd__diode_2
XFILLER_0_75_565 VGND VGND VPWR VPWR sky130_fd_sc_hd__fill_2
X_5886_ _1270_ _2610_ VGND VGND VPWR VPWR _2611_ sky130_fd_sc_hd__xnor2_1
XFILLER_0_62_94 VGND VGND VPWR VPWR sky130_fd_sc_hd__decap_4
X_8674_ clknet_leaf_9_clk _0795_ VGND VGND VPWR VPWR registers\[0\]\[2\] sky130_fd_sc_hd__dfxtp_1
X_4906_ registers\[8\]\[2\] registers\[9\]\[2\] registers\[10\]\[2\] registers\[11\]\[2\]
+ _1642_ _1643_ VGND VGND VPWR VPWR _1672_ sky130_fd_sc_hd__mux4_1
XFILLER_0_118_645 VPWR VGND VPWR VGND sky130_ef_sc_hd__decap_12
XFILLER_0_117_111 VGND VGND VPWR VPWR sky130_fd_sc_hd__fill_1
XFILLER_0_75_598 VGND VGND VPWR VPWR sky130_fd_sc_hd__fill_2
XFILLER_0_75_576 VGND VGND VPWR VPWR sky130_fd_sc_hd__fill_1
X_7625_ _3737_ VGND VGND VPWR VPWR _0232_ sky130_fd_sc_hd__clkbuf_1
X_4837_ _1602_ _1603_ _1604_ _1605_ _1513_ _1379_ VGND VGND VPWR VPWR _1606_ sky130_fd_sc_hd__mux4_1
XFILLER_0_35_418 VGND VGND VPWR VPWR sky130_fd_sc_hd__fill_2
XANTENNA__7372__A1 _3487_ VGND VGND VPWR VPWR sky130_fd_sc_hd__diode_2
X_7556_ _3100_ registers\[22\]\[15\] _3695_ VGND VGND VPWR VPWR _3701_ sky130_fd_sc_hd__mux2_1
XFILLER_0_7_397 VGND VGND VPWR VPWR sky130_fd_sc_hd__fill_1
X_4768_ registers\[4\]\[27\] registers\[5\]\[27\] registers\[6\]\[27\] registers\[7\]\[27\]
+ _1382_ _1383_ VGND VGND VPWR VPWR _1541_ sky130_fd_sc_hd__mux4_1
X_7487_ _3664_ VGND VGND VPWR VPWR _0167_ sky130_fd_sc_hd__clkbuf_1
XANTENNA__7124__A1 _3462_ VGND VGND VPWR VPWR sky130_fd_sc_hd__diode_2
X_4699_ registers\[8\]\[23\] registers\[9\]\[23\] registers\[10\]\[23\] registers\[11\]\[23\]
+ _1347_ _1348_ VGND VGND VPWR VPWR _1476_ sky130_fd_sc_hd__mux4_1
X_6507_ _3121_ registers\[29\]\[25\] _3111_ VGND VGND VPWR VPWR _3122_ sky130_fd_sc_hd__mux2_1
X_9226_ clknet_leaf_37_clk _0323_ VGND VGND VPWR VPWR registers\[26\]\[10\] sky130_fd_sc_hd__dfxtp_1
X_6438_ net41 VGND VGND VPWR VPWR _3075_ sky130_fd_sc_hd__clkbuf_2
X_9157_ clknet_leaf_26_clk _0254_ VGND VGND VPWR VPWR registers\[24\]\[5\] sky130_fd_sc_hd__dfxtp_1
X_6369_ registers\[3\]\[5\] _2972_ _3030_ VGND VGND VPWR VPWR _3036_ sky130_fd_sc_hd__mux2_1
X_8108_ _3993_ VGND VGND VPWR VPWR _0459_ sky130_fd_sc_hd__clkbuf_1
XFILLER_0_11_370 VGND VGND VPWR VPWR sky130_fd_sc_hd__fill_2
X_9088_ clknet_leaf_111_clk _0185_ VGND VGND VPWR VPWR registers\[22\]\[0\] sky130_fd_sc_hd__dfxtp_1
XTAP_TAPCELL_ROW_110_1692 VGND VPWR sky130_fd_sc_hd__tapvpwrvgnd_1
X_8039_ registers\[2\]\[18\] _3472_ _3948_ VGND VGND VPWR VPWR _3957_ sky130_fd_sc_hd__mux2_1
XANTENNA__8109__S _3984_ VGND VGND VPWR VPWR sky130_fd_sc_hd__diode_2
XFILLER_0_97_101 VGND VGND VPWR VPWR sky130_fd_sc_hd__fill_2
XFILLER_0_98_657 VGND VGND VPWR VPWR sky130_fd_sc_hd__fill_2
XANTENNA__7948__S _3901_ VGND VGND VPWR VPWR sky130_fd_sc_hd__diode_2
XTAP_TAPCELL_ROW_3_296 VGND VPWR sky130_fd_sc_hd__tapvpwrvgnd_1
XFILLER_0_85_307 VGND VGND VPWR VPWR sky130_fd_sc_hd__fill_2
XFILLER_0_97_178 VGND VGND VPWR VPWR sky130_fd_sc_hd__fill_2
XTAP_TAPCELL_ROW_42_803 VGND VPWR sky130_fd_sc_hd__tapvpwrvgnd_1
XFILLER_0_109_612 VGND VGND VPWR VPWR sky130_fd_sc_hd__decap_4
XFILLER_0_54_705 VGND VGND VPWR VPWR sky130_fd_sc_hd__fill_2
XFILLER_0_109_656 VGND VGND VPWR VPWR sky130_fd_sc_hd__fill_2
XFILLER_0_66_587 VGND VGND VPWR VPWR sky130_fd_sc_hd__fill_1
XTAP_TAPCELL_ROW_61_1057 VGND VPWR sky130_fd_sc_hd__tapvpwrvgnd_1
XTAP_TAPCELL_ROW_61_1046 VGND VPWR sky130_fd_sc_hd__tapvpwrvgnd_1
XFILLER_0_38_278 VGND VGND VPWR VPWR sky130_fd_sc_hd__decap_3
XANTENNA__7683__S _3768_ VGND VGND VPWR VPWR sky130_fd_sc_hd__diode_2
XANTENNA__7115__A1 _3455_ VGND VGND VPWR VPWR sky130_fd_sc_hd__diode_2
XANTENNA__6299__S _2983_ VGND VGND VPWR VPWR sky130_fd_sc_hd__diode_2
XFILLER_0_61_281 VGND VGND VPWR VPWR sky130_fd_sc_hd__decap_3
XFILLER_0_21_134 VGND VGND VPWR VPWR sky130_fd_sc_hd__decap_3
XFILLER_0_104_394 VGND VGND VPWR VPWR sky130_fd_sc_hd__fill_2
XFILLER_0_67_28 VGND VGND VPWR VPWR sky130_fd_sc_hd__fill_2
XANTENNA__5221__S0 _1968_ VGND VGND VPWR VPWR sky130_fd_sc_hd__diode_2
XTAP_TAPCELL_ROW_72_1197 VGND VPWR sky130_fd_sc_hd__tapvpwrvgnd_1
XFILLER_0_89_613 VGND VGND VPWR VPWR sky130_fd_sc_hd__fill_1
XANTENNA__6762__S _3261_ VGND VGND VPWR VPWR sky130_fd_sc_hd__diode_2
XANTENNA__7858__S _3851_ VGND VGND VPWR VPWR sky130_fd_sc_hd__diode_2
XFILLER_0_89_679 VGND VGND VPWR VPWR sky130_fd_sc_hd__fill_1
XFILLER_0_76_329 VGND VGND VPWR VPWR sky130_fd_sc_hd__decap_3
X_5740_ _2460_ _2470_ _2471_ VGND VGND VPWR VPWR _2472_ sky130_fd_sc_hd__a21o_1
Xclkbuf_leaf_108_clk clknet_4_0_0_clk VGND VGND VPWR VPWR clknet_leaf_108_clk sky130_fd_sc_hd__clkbuf_8
XANTENNA__4282__S _1034_ VGND VGND VPWR VPWR sky130_fd_sc_hd__diode_2
XFILLER_0_45_716 VGND VGND VPWR VPWR sky130_fd_sc_hd__fill_2
XFILLER_0_17_407 VGND VGND VPWR VPWR sky130_fd_sc_hd__fill_2
XFILLER_0_115_615 VGND VGND VPWR VPWR sky130_fd_sc_hd__fill_1
X_7410_ registers\[20\]\[10\] _3455_ _3623_ VGND VGND VPWR VPWR _3624_ sky130_fd_sc_hd__mux2_1
X_5671_ _2308_ _2306_ VGND VGND VPWR VPWR _2405_ sky130_fd_sc_hd__or2_1
XFILLER_0_44_248 VGND VGND VPWR VPWR sky130_fd_sc_hd__fill_2
XANTENNA__7593__S _3720_ VGND VGND VPWR VPWR sky130_fd_sc_hd__diode_2
XTAP_TAPCELL_ROW_20_519 VGND VPWR sky130_fd_sc_hd__tapvpwrvgnd_1
XFILLER_0_32_75 VGND VGND VPWR VPWR sky130_fd_sc_hd__decap_3
XFILLER_0_114_103 VGND VGND VPWR VPWR sky130_fd_sc_hd__fill_2
X_4622_ _1399_ _1402_ _1124_ VGND VGND VPWR VPWR _1403_ sky130_fd_sc_hd__mux2_1
X_8390_ registers\[5\]\[23\] _3483_ _4139_ VGND VGND VPWR VPWR _4143_ sky130_fd_sc_hd__mux2_1
XANTENNA__8303__A0 _2991_ VGND VGND VPWR VPWR sky130_fd_sc_hd__diode_2
XFILLER_0_102_309 VGND VGND VPWR VPWR sky130_fd_sc_hd__fill_2
X_7341_ registers\[1\]\[10\] _3455_ _3586_ VGND VGND VPWR VPWR _3587_ sky130_fd_sc_hd__mux2_1
X_4553_ _1337_ VGND VGND VPWR VPWR net119 sky130_fd_sc_hd__inv_2
XANTENNA__4263__S1 _1061_ VGND VGND VPWR VPWR sky130_fd_sc_hd__diode_2
X_4484_ registers\[16\]\[12\] registers\[17\]\[12\] registers\[18\]\[12\] registers\[19\]\[12\]
+ _1111_ _1113_ VGND VGND VPWR VPWR _1272_ sky130_fd_sc_hd__mux4_1
X_7272_ _3538_ VGND VGND VPWR VPWR _3550_ sky130_fd_sc_hd__buf_6
XFILLER_0_40_454 VGND VGND VPWR VPWR sky130_fd_sc_hd__fill_1
XANTENNA__5407__A _2026_ VGND VGND VPWR VPWR sky130_fd_sc_hd__diode_2
XFILLER_0_4_389 VGND VGND VPWR VPWR sky130_fd_sc_hd__fill_2
XFILLER_0_12_134 VGND VGND VPWR VPWR sky130_fd_sc_hd__decap_3
X_6223_ _2921_ _2922_ _2929_ VGND VGND VPWR VPWR net70 sky130_fd_sc_hd__a21o_1
X_9011_ clknet_leaf_14_clk _0108_ VGND VGND VPWR VPWR registers\[1\]\[19\] sky130_fd_sc_hd__dfxtp_1
XANTENNA__5212__S0 _1820_ VGND VGND VPWR VPWR sky130_fd_sc_hd__diode_2
XANTENNA__6937__S _3346_ VGND VGND VPWR VPWR sky130_fd_sc_hd__diode_2
X_6154_ _2298_ _2861_ _2863_ _2321_ VGND VGND VPWR VPWR _2864_ sky130_fd_sc_hd__a22o_1
X_5105_ registers\[4\]\[11\] registers\[5\]\[11\] registers\[6\]\[11\] registers\[7\]\[11\]
+ _1773_ _1775_ VGND VGND VPWR VPWR _1862_ sky130_fd_sc_hd__mux4_1
X_6085_ _2772_ _2783_ VGND VGND VPWR VPWR _2799_ sky130_fd_sc_hd__nor2_1
X_5036_ _1796_ VGND VGND VPWR VPWR net110 sky130_fd_sc_hd__inv_2
XFILLER_0_79_134 VGND VGND VPWR VPWR sky130_fd_sc_hd__fill_1
XFILLER_0_79_101 VGND VGND VPWR VPWR sky130_fd_sc_hd__fill_2
XTAP_TAPCELL_ROW_28_619 VGND VPWR sky130_fd_sc_hd__tapvpwrvgnd_1
XANTENNA__4981__A _1679_ VGND VGND VPWR VPWR sky130_fd_sc_hd__diode_2
XFILLER_0_79_167 VGND VGND VPWR VPWR sky130_fd_sc_hd__fill_1
XFILLER_0_79_145 VGND VGND VPWR VPWR sky130_fd_sc_hd__decap_4
XTAP_TAPCELL_ROW_0_244 VGND VPWR sky130_fd_sc_hd__tapvpwrvgnd_1
XFILLER_0_48_521 VGND VGND VPWR VPWR sky130_fd_sc_hd__fill_1
X_6987_ _3360_ VGND VGND VPWR VPWR _3383_ sky130_fd_sc_hd__buf_6
XTAP_TAPCELL_ROW_0_255 VGND VPWR sky130_fd_sc_hd__tapvpwrvgnd_1
X_5938_ _2658_ _2659_ _2515_ VGND VGND VPWR VPWR _2660_ sky130_fd_sc_hd__o21a_1
X_8726_ clknet_leaf_95_clk _0847_ VGND VGND VPWR VPWR registers\[10\]\[22\] sky130_fd_sc_hd__dfxtp_1
XFILLER_0_8_640 VGND VGND VPWR VPWR sky130_fd_sc_hd__fill_2
XFILLER_0_36_727 VGND VGND VPWR VPWR sky130_fd_sc_hd__fill_1
XFILLER_0_118_475 VGND VGND VPWR VPWR sky130_fd_sc_hd__fill_1
XFILLER_0_90_321 VGND VGND VPWR VPWR sky130_fd_sc_hd__fill_2
X_8657_ clknet_leaf_49_clk _0778_ VGND VGND VPWR VPWR registers\[7\]\[17\] sky130_fd_sc_hd__dfxtp_1
X_5869_ _2594_ _2208_ _2483_ _2514_ _2484_ VGND VGND VPWR VPWR _2595_ sky130_fd_sc_hd__o41a_1
XFILLER_0_106_648 VGND VGND VPWR VPWR sky130_fd_sc_hd__fill_2
XFILLER_0_90_365 VGND VGND VPWR VPWR sky130_fd_sc_hd__fill_2
X_7608_ _3728_ VGND VGND VPWR VPWR _0224_ sky130_fd_sc_hd__clkbuf_1
X_8588_ clknet_leaf_44_clk _0709_ VGND VGND VPWR VPWR registers\[3\]\[12\] sky130_fd_sc_hd__dfxtp_1
XFILLER_0_51_719 VGND VGND VPWR VPWR sky130_fd_sc_hd__fill_2
XANTENNA__5356__B1 _1756_ VGND VGND VPWR VPWR sky130_fd_sc_hd__diode_2
XFILLER_0_105_147 VGND VGND VPWR VPWR sky130_fd_sc_hd__fill_2
XFILLER_0_90_387 VGND VGND VPWR VPWR sky130_fd_sc_hd__fill_1
X_7539_ _3083_ registers\[22\]\[7\] _3684_ VGND VGND VPWR VPWR _3692_ sky130_fd_sc_hd__mux2_1
XANTENNA__5451__S0 _2126_ VGND VGND VPWR VPWR sky130_fd_sc_hd__diode_2
XFILLER_0_114_681 VPWR VGND VPWR VGND sky130_ef_sc_hd__decap_12
XFILLER_0_105_169 VGND VGND VPWR VPWR sky130_fd_sc_hd__decap_8
XANTENNA__5108__B1 _1778_ VGND VGND VPWR VPWR sky130_fd_sc_hd__diode_2
XTAP_TAPCELL_ROW_112_1710 VGND VPWR sky130_fd_sc_hd__tapvpwrvgnd_1
X_9209_ clknet_leaf_80_clk _0306_ VGND VGND VPWR VPWR registers\[25\]\[25\] sky130_fd_sc_hd__dfxtp_1
XTAP_TAPCELL_ROW_112_1721 VGND VPWR sky130_fd_sc_hd__tapvpwrvgnd_1
Xoutput56 net56 VGND VGND VPWR VPWR alu_result[16] sky130_fd_sc_hd__buf_1
Xoutput67 net67 VGND VGND VPWR VPWR alu_result[26] sky130_fd_sc_hd__buf_1
XFILLER_0_12_690 VGND VGND VPWR VPWR sky130_fd_sc_hd__fill_2
XANTENNA__4867__C1 _1634_ VGND VGND VPWR VPWR sky130_fd_sc_hd__diode_2
Xoutput78 net78 VGND VGND VPWR VPWR alu_result[7] sky130_fd_sc_hd__buf_1
XFILLER_0_101_375 VGND VGND VPWR VPWR sky130_fd_sc_hd__fill_2
XTAP_TAPCELL_ROW_8_366 VGND VPWR sky130_fd_sc_hd__tapvpwrvgnd_1
Xoutput89 net89 VGND VGND VPWR VPWR rd1[17] sky130_fd_sc_hd__buf_1
XANTENNA_input16_A wd3[0] VGND VGND VPWR VPWR sky130_fd_sc_hd__diode_2
XFILLER_0_98_421 VGND VGND VPWR VPWR sky130_fd_sc_hd__fill_2
XANTENNA__7678__S _3757_ VGND VGND VPWR VPWR sky130_fd_sc_hd__diode_2
XANTENNA__5987__A _2394_ VGND VGND VPWR VPWR sky130_fd_sc_hd__diode_2
XANTENNA__7033__A0 _3087_ VGND VGND VPWR VPWR sky130_fd_sc_hd__diode_2
XFILLER_0_53_19 VGND VGND VPWR VPWR sky130_fd_sc_hd__fill_2
XANTENNA__6582__S _3159_ VGND VGND VPWR VPWR sky130_fd_sc_hd__diode_2
XPHY_EDGE_ROW_113_Right_113 VGND VGND VPWR VPWR sky130_fd_sc_hd__decap_3
XFILLER_0_85_126 VGND VGND VPWR VPWR sky130_fd_sc_hd__fill_2
XANTENNA__5198__S _1767_ VGND VGND VPWR VPWR sky130_fd_sc_hd__diode_2
XFILLER_0_85_148 VGND VGND VPWR VPWR sky130_fd_sc_hd__fill_2
XTAP_TAPCELL_ROW_55_972 VGND VPWR sky130_fd_sc_hd__tapvpwrvgnd_1
XFILLER_0_39_543 VGND VGND VPWR VPWR sky130_fd_sc_hd__decap_4
XFILLER_0_39_565 VGND VGND VPWR VPWR sky130_fd_sc_hd__decap_4
XFILLER_0_109_453 VGND VGND VPWR VPWR sky130_fd_sc_hd__decap_3
XFILLER_0_93_181 VGND VGND VPWR VPWR sky130_fd_sc_hd__fill_2
XFILLER_0_81_321 VGND VGND VPWR VPWR sky130_fd_sc_hd__decap_4
XFILLER_0_66_395 VGND VGND VPWR VPWR sky130_fd_sc_hd__decap_8
XANTENNA__7336__A1 _3451_ VGND VGND VPWR VPWR sky130_fd_sc_hd__diode_2
XFILLER_0_109_497 VGND VGND VPWR VPWR sky130_fd_sc_hd__decap_4
XFILLER_0_81_387 VGND VGND VPWR VPWR sky130_fd_sc_hd__fill_2
XFILLER_0_34_270 VGND VGND VPWR VPWR sky130_fd_sc_hd__fill_2
XANTENNA__4245__S1 _1040_ VGND VGND VPWR VPWR sky130_fd_sc_hd__diode_2
XFILLER_0_78_49 VGND VGND VPWR VPWR sky130_fd_sc_hd__fill_2
XANTENNA__5227__A _1778_ VGND VGND VPWR VPWR sky130_fd_sc_hd__diode_2
XTAP_TAPCELL_ROW_74_1226 VGND VPWR sky130_fd_sc_hd__tapvpwrvgnd_1
XTAP_TAPCELL_ROW_74_1215 VGND VPWR sky130_fd_sc_hd__tapvpwrvgnd_1
XFILLER_0_1_337 VGND VGND VPWR VPWR sky130_fd_sc_hd__decap_6
XFILLER_0_22_465 VGND VGND VPWR VPWR sky130_fd_sc_hd__fill_2
XANTENNA__6757__S _3250_ VGND VGND VPWR VPWR sky130_fd_sc_hd__diode_2
XFILLER_0_118_11 VPWR VGND VPWR VGND sky130_ef_sc_hd__decap_12
XFILLER_0_94_59 VGND VGND VPWR VPWR sky130_fd_sc_hd__fill_2
XFILLER_0_118_77 VGND VGND VPWR VPWR sky130_fd_sc_hd__decap_6
XFILLER_0_27_86 VGND VGND VPWR VPWR sky130_fd_sc_hd__fill_2
X_7890_ _3878_ VGND VGND VPWR VPWR _0356_ sky130_fd_sc_hd__clkbuf_1
X_6910_ _3102_ registers\[13\]\[16\] _3335_ VGND VGND VPWR VPWR _3342_ sky130_fd_sc_hd__mux2_1
XANTENNA__6492__S _3111_ VGND VGND VPWR VPWR sky130_fd_sc_hd__diode_2
XANTENNA__8273__A _4080_ VGND VGND VPWR VPWR sky130_fd_sc_hd__diode_2
XTAP_TAPCELL_ROW_85_1366 VGND VPWR sky130_fd_sc_hd__tapvpwrvgnd_1
XFILLER_0_77_649 VGND VGND VPWR VPWR sky130_fd_sc_hd__decap_3
X_6841_ _3305_ VGND VGND VPWR VPWR _0904_ sky130_fd_sc_hd__clkbuf_1
XANTENNA__4389__A1 _1135_ VGND VGND VPWR VPWR sky130_fd_sc_hd__diode_2
XFILLER_0_76_126 VGND VGND VPWR VPWR sky130_fd_sc_hd__decap_8
X_9560_ clknet_leaf_88_clk _0657_ VGND VGND VPWR VPWR registers\[4\]\[24\] sky130_fd_sc_hd__dfxtp_1
XFILLER_0_119_228 VPWR VGND VPWR VGND sky130_ef_sc_hd__decap_12
XANTENNA__4484__S1 _1113_ VGND VGND VPWR VPWR sky130_fd_sc_hd__diode_2
X_8511_ registers\[4\]\[16\] net23 _4200_ VGND VGND VPWR VPWR _4207_ sky130_fd_sc_hd__mux2_1
X_6772_ registers\[11\]\[16\] _2995_ _3261_ VGND VGND VPWR VPWR _3268_ sky130_fd_sc_hd__mux2_1
XANTENNA__5302__A1_N _1677_ VGND VGND VPWR VPWR sky130_fd_sc_hd__diode_2
XFILLER_0_9_459 VGND VGND VPWR VPWR sky130_fd_sc_hd__fill_2
XFILLER_0_18_716 VPWR VGND VPWR VGND sky130_ef_sc_hd__decap_12
X_5723_ net124 _2357_ _2455_ _2270_ VGND VGND VPWR VPWR _2456_ sky130_fd_sc_hd__o211a_1
X_9491_ clknet_leaf_45_clk _0588_ VGND VGND VPWR VPWR registers\[5\]\[19\] sky130_fd_sc_hd__dfxtp_1
XFILLER_0_57_384 VGND VGND VPWR VPWR sky130_fd_sc_hd__fill_2
XTAP_TAPCELL_ROW_33_688 VGND VPWR sky130_fd_sc_hd__tapvpwrvgnd_1
X_8442_ _4170_ VGND VGND VPWR VPWR _0616_ sky130_fd_sc_hd__clkbuf_1
X_5654_ _2386_ _2388_ _1072_ VGND VGND VPWR VPWR _2389_ sky130_fd_sc_hd__mux2_1
XFILLER_0_72_365 VGND VGND VPWR VPWR sky130_fd_sc_hd__fill_2
XFILLER_0_72_354 VGND VGND VPWR VPWR sky130_fd_sc_hd__decap_4
XANTENNA__8212__S _4045_ VGND VGND VPWR VPWR sky130_fd_sc_hd__diode_2
XFILLER_0_45_557 VGND VGND VPWR VPWR sky130_fd_sc_hd__fill_1
XANTENNA__6521__A net39 VGND VGND VPWR VPWR sky130_fd_sc_hd__diode_2
X_8373_ registers\[5\]\[15\] _3466_ _4128_ VGND VGND VPWR VPWR _4134_ sky130_fd_sc_hd__mux2_1
XFILLER_0_72_376 VGND VGND VPWR VPWR sky130_fd_sc_hd__fill_2
X_4605_ _1384_ _1385_ _1386_ VGND VGND VPWR VPWR _1387_ sky130_fd_sc_hd__mux2_1
XANTENNA__5433__S0 _2027_ VGND VGND VPWR VPWR sky130_fd_sc_hd__diode_2
XANTENNA__4236__S1 _1027_ VGND VGND VPWR VPWR sky130_fd_sc_hd__diode_2
X_5585_ _2320_ VGND VGND VPWR VPWR net49 sky130_fd_sc_hd__clkbuf_1
XFILLER_0_103_629 VGND VGND VPWR VPWR sky130_fd_sc_hd__fill_2
X_7324_ registers\[1\]\[2\] _3439_ _3575_ VGND VGND VPWR VPWR _3578_ sky130_fd_sc_hd__mux2_1
XFILLER_0_4_175 VGND VGND VPWR VPWR sky130_fd_sc_hd__decap_6
XFILLER_0_111_640 VGND VGND VPWR VPWR sky130_fd_sc_hd__fill_2
XFILLER_0_102_139 VGND VGND VPWR VPWR sky130_fd_sc_hd__fill_1
X_4536_ _1204_ VGND VGND VPWR VPWR _1321_ sky130_fd_sc_hd__buf_4
XFILLER_0_40_262 VGND VGND VPWR VPWR sky130_fd_sc_hd__decap_4
XFILLER_0_4_197 VGND VGND VPWR VPWR sky130_fd_sc_hd__fill_2
XFILLER_0_13_465 VGND VGND VPWR VPWR sky130_fd_sc_hd__fill_1
X_4467_ registers\[16\]\[11\] registers\[17\]\[11\] registers\[18\]\[11\] registers\[19\]\[11\]
+ _1197_ _1203_ VGND VGND VPWR VPWR _1256_ sky130_fd_sc_hd__mux4_1
XFILLER_0_40_295 VGND VGND VPWR VPWR sky130_fd_sc_hd__fill_2
XFILLER_0_7_85 VGND VGND VPWR VPWR sky130_fd_sc_hd__decap_3
X_7255_ _3541_ VGND VGND VPWR VPWR _0058_ sky130_fd_sc_hd__clkbuf_1
X_4398_ _1187_ _1190_ _1122_ VGND VGND VPWR VPWR _1191_ sky130_fd_sc_hd__mux2_1
X_6206_ _2912_ _2913_ VGND VGND VPWR VPWR _2914_ sky130_fd_sc_hd__nor2_1
X_7186_ registers\[17\]\[1\] _3437_ _3503_ VGND VGND VPWR VPWR _3505_ sky130_fd_sc_hd__mux2_1
X_6137_ _2490_ _2727_ VGND VGND VPWR VPWR _2848_ sky130_fd_sc_hd__nor2_1
XTAP_TAPCELL_ROW_5_325 VGND VPWR sky130_fd_sc_hd__tapvpwrvgnd_1
XANTENNA_input8_A a2[4] VGND VGND VPWR VPWR sky130_fd_sc_hd__diode_2
XFILLER_0_99_218 VGND VGND VPWR VPWR sky130_fd_sc_hd__decap_4
XANTENNA__5813__A1 net139 VGND VGND VPWR VPWR sky130_fd_sc_hd__diode_2
X_6068_ _2034_ _2782_ VGND VGND VPWR VPWR _2783_ sky130_fd_sc_hd__xnor2_1
X_5019_ _1780_ VGND VGND VPWR VPWR net109 sky130_fd_sc_hd__inv_2
XANTENNA_clkbuf_leaf_90_clk_A clknet_4_9_0_clk VGND VGND VPWR VPWR sky130_fd_sc_hd__diode_2
XANTENNA__7015__A0 _3065_ VGND VGND VPWR VPWR sky130_fd_sc_hd__diode_2
XFILLER_0_67_137 VGND VGND VPWR VPWR sky130_fd_sc_hd__decap_3
XANTENNA__4475__S1 _1127_ VGND VGND VPWR VPWR sky130_fd_sc_hd__diode_2
XTAP_TAPCELL_ROW_52_931 VGND VPWR sky130_fd_sc_hd__tapvpwrvgnd_1
XFILLER_0_36_502 VGND VGND VPWR VPWR sky130_fd_sc_hd__decap_8
X_8709_ clknet_leaf_31_clk _0830_ VGND VGND VPWR VPWR registers\[10\]\[5\] sky130_fd_sc_hd__dfxtp_1
XFILLER_0_76_682 VGND VGND VPWR VPWR sky130_fd_sc_hd__fill_2
XFILLER_0_118_261 VGND VGND VPWR VPWR sky130_fd_sc_hd__fill_2
XFILLER_0_63_354 VGND VGND VPWR VPWR sky130_fd_sc_hd__decap_8
XANTENNA__8122__S _3995_ VGND VGND VPWR VPWR sky130_fd_sc_hd__diode_2
XFILLER_0_91_685 VGND VGND VPWR VPWR sky130_fd_sc_hd__decap_6
XFILLER_0_23_218 VGND VGND VPWR VPWR sky130_fd_sc_hd__decap_4
XANTENNA__7961__S _3912_ VGND VGND VPWR VPWR sky130_fd_sc_hd__diode_2
XANTENNA__4552__A1 _1109_ VGND VGND VPWR VPWR sky130_fd_sc_hd__diode_2
XFILLER_0_102_651 VGND VGND VPWR VPWR sky130_fd_sc_hd__fill_1
XFILLER_0_31_273 VGND VGND VPWR VPWR sky130_fd_sc_hd__decap_4
XFILLER_0_101_161 VGND VGND VPWR VPWR sky130_fd_sc_hd__fill_2
XANTENNA_clkbuf_leaf_43_clk_A clknet_4_6_0_clk VGND VGND VPWR VPWR sky130_fd_sc_hd__diode_2
XANTENNA__4304__A1 net6 VGND VGND VPWR VPWR sky130_fd_sc_hd__diode_2
XANTENNA_clkbuf_leaf_58_clk_A clknet_4_15_0_clk VGND VGND VPWR VPWR sky130_fd_sc_hd__diode_2
XFILLER_0_64_29 VGND VGND VPWR VPWR sky130_fd_sc_hd__fill_1
XANTENNA__4825__S _1362_ VGND VGND VPWR VPWR sky130_fd_sc_hd__diode_2
XANTENNA_clkbuf_leaf_101_clk_A clknet_4_2_0_clk VGND VGND VPWR VPWR sky130_fd_sc_hd__diode_2
XFILLER_0_98_295 VGND VGND VPWR VPWR sky130_fd_sc_hd__fill_1
XFILLER_0_27_502 VGND VGND VPWR VPWR sky130_fd_sc_hd__fill_2
XANTENNA__4466__S1 _1203_ VGND VGND VPWR VPWR sky130_fd_sc_hd__diode_2
XFILLER_0_94_490 VGND VGND VPWR VPWR sky130_fd_sc_hd__fill_2
XFILLER_0_82_630 VGND VGND VPWR VPWR sky130_fd_sc_hd__fill_1
XFILLER_0_73_129 VGND VGND VPWR VPWR sky130_fd_sc_hd__fill_2
XFILLER_0_67_682 VGND VGND VPWR VPWR sky130_fd_sc_hd__decap_8
XFILLER_0_66_170 VGND VGND VPWR VPWR sky130_fd_sc_hd__decap_3
XFILLER_0_89_15 VPWR VGND VPWR VGND sky130_ef_sc_hd__decap_12
XFILLER_0_82_641 VGND VGND VPWR VPWR sky130_fd_sc_hd__decap_3
XTAP_TAPCELL_ROW_80_1296 VGND VPWR sky130_fd_sc_hd__tapvpwrvgnd_1
XFILLER_0_66_192 VGND VGND VPWR VPWR sky130_fd_sc_hd__fill_2
XFILLER_0_13_77 VGND VGND VPWR VPWR sky130_fd_sc_hd__fill_1
XANTENNA__6341__A net35 VGND VGND VPWR VPWR sky130_fd_sc_hd__diode_2
XTAP_TAPCELL_ROW_30_647 VGND VPWR sky130_fd_sc_hd__tapvpwrvgnd_1
XFILLER_0_82_674 VGND VGND VPWR VPWR sky130_fd_sc_hd__decap_8
XFILLER_0_54_365 VGND VGND VPWR VPWR sky130_fd_sc_hd__fill_2
XFILLER_0_14_229 VGND VGND VPWR VPWR sky130_fd_sc_hd__fill_1
XANTENNA__5415__S0 _2072_ VGND VGND VPWR VPWR sky130_fd_sc_hd__diode_2
XFILLER_0_2_602 VGND VGND VPWR VPWR sky130_fd_sc_hd__decap_3
XFILLER_0_112_426 VGND VGND VPWR VPWR sky130_fd_sc_hd__fill_2
XTAP_TAPCELL_ROW_10_393 VGND VPWR sky130_fd_sc_hd__tapvpwrvgnd_1
X_5370_ registers\[0\]\[26\] registers\[1\]\[26\] registers\[2\]\[26\] registers\[3\]\[26\]
+ _2097_ _2109_ VGND VGND VPWR VPWR _2112_ sky130_fd_sc_hd__mux4_1
X_4321_ _1116_ VGND VGND VPWR VPWR _1117_ sky130_fd_sc_hd__buf_4
X_4252_ _1051_ VGND VGND VPWR VPWR net113 sky130_fd_sc_hd__clkbuf_4
X_7040_ _3094_ registers\[15\]\[12\] _3409_ VGND VGND VPWR VPWR _3412_ sky130_fd_sc_hd__mux2_1
XANTENNA__7172__A net37 VGND VGND VPWR VPWR sky130_fd_sc_hd__diode_2
XFILLER_0_38_85 VGND VGND VPWR VPWR sky130_fd_sc_hd__decap_3
X_8991_ clknet_leaf_100_clk _0088_ VGND VGND VPWR VPWR registers\[18\]\[31\] sky130_fd_sc_hd__dfxtp_1
X_7942_ _2970_ registers\[28\]\[4\] _3901_ VGND VGND VPWR VPWR _3906_ sky130_fd_sc_hd__mux2_1
XTAP_TAPCELL_ROW_38_747 VGND VPWR sky130_fd_sc_hd__tapvpwrvgnd_1
XANTENNA__4735__S _1421_ VGND VGND VPWR VPWR sky130_fd_sc_hd__diode_2
XFILLER_0_89_273 VGND VGND VPWR VPWR sky130_fd_sc_hd__decap_4
XANTENNA__7111__S _3435_ VGND VGND VPWR VPWR sky130_fd_sc_hd__diode_2
XTAP_TAPCELL_ROW_38_758 VGND VPWR sky130_fd_sc_hd__tapvpwrvgnd_1
X_7873_ _3869_ VGND VGND VPWR VPWR _0348_ sky130_fd_sc_hd__clkbuf_1
X_6824_ _3296_ VGND VGND VPWR VPWR _0896_ sky130_fd_sc_hd__clkbuf_1
XTAP_TAPCELL_ROW_18_493 VGND VPWR sky130_fd_sc_hd__tapvpwrvgnd_1
XANTENNA__6950__S _3361_ VGND VGND VPWR VPWR sky130_fd_sc_hd__diode_2
XFILLER_0_107_209 VGND VGND VPWR VPWR sky130_fd_sc_hd__decap_4
X_9543_ clknet_leaf_32_clk _0640_ VGND VGND VPWR VPWR registers\[4\]\[7\] sky130_fd_sc_hd__dfxtp_1
XANTENNA__4457__S1 _1202_ VGND VGND VPWR VPWR sky130_fd_sc_hd__diode_2
X_6755_ registers\[11\]\[8\] _2978_ _3250_ VGND VGND VPWR VPWR _3259_ sky130_fd_sc_hd__mux2_1
XFILLER_0_57_181 VGND VGND VPWR VPWR sky130_fd_sc_hd__fill_1
X_5706_ _2381_ _2388_ _2293_ VGND VGND VPWR VPWR _2439_ sky130_fd_sc_hd__mux2_1
X_9474_ clknet_leaf_4_clk _0571_ VGND VGND VPWR VPWR registers\[5\]\[2\] sky130_fd_sc_hd__dfxtp_1
Xclkbuf_leaf_30_clk clknet_4_5_0_clk VGND VGND VPWR VPWR clknet_leaf_30_clk sky130_fd_sc_hd__clkbuf_8
X_8425_ _4161_ VGND VGND VPWR VPWR _0608_ sky130_fd_sc_hd__clkbuf_1
X_6686_ _3222_ VGND VGND VPWR VPWR _0832_ sky130_fd_sc_hd__clkbuf_1
XTAP_TAPCELL_ROW_98_1535 VGND VPWR sky130_fd_sc_hd__tapvpwrvgnd_1
XFILLER_0_73_696 VGND VGND VPWR VPWR sky130_fd_sc_hd__fill_1
XFILLER_0_33_538 VGND VGND VPWR VPWR sky130_fd_sc_hd__fill_2
X_5637_ _2371_ VGND VGND VPWR VPWR _2372_ sky130_fd_sc_hd__inv_2
XFILLER_0_72_195 VGND VGND VPWR VPWR sky130_fd_sc_hd__fill_1
XANTENNA__7720__A1 _3493_ VGND VGND VPWR VPWR sky130_fd_sc_hd__diode_2
X_8356_ registers\[5\]\[7\] _3449_ _4117_ VGND VGND VPWR VPWR _4125_ sky130_fd_sc_hd__mux2_1
X_5568_ _1740_ _2214_ VGND VGND VPWR VPWR _2304_ sky130_fd_sc_hd__or2_1
X_4519_ _1303_ _1304_ _1132_ VGND VGND VPWR VPWR _1305_ sky130_fd_sc_hd__mux2_1
X_8287_ _4088_ VGND VGND VPWR VPWR _0543_ sky130_fd_sc_hd__clkbuf_1
X_7307_ _3568_ VGND VGND VPWR VPWR _0083_ sky130_fd_sc_hd__clkbuf_1
XANTENNA__5709__S1 net113 VGND VGND VPWR VPWR sky130_fd_sc_hd__diode_2
X_5499_ _2048_ _2234_ VGND VGND VPWR VPWR _2235_ sky130_fd_sc_hd__or2_1
X_7238_ registers\[17\]\[26\] _3489_ _3525_ VGND VGND VPWR VPWR _3532_ sky130_fd_sc_hd__mux2_1
XANTENNA__4393__S0 _1125_ VGND VGND VPWR VPWR sky130_fd_sc_hd__diode_2
Xclkbuf_leaf_97_clk clknet_4_9_0_clk VGND VGND VPWR VPWR clknet_leaf_97_clk sky130_fd_sc_hd__clkbuf_8
X_7169_ net36 VGND VGND VPWR VPWR _3493_ sky130_fd_sc_hd__buf_2
XANTENNA__6426__A net13 VGND VGND VPWR VPWR sky130_fd_sc_hd__diode_2
XANTENNA__4645__S _1344_ VGND VGND VPWR VPWR sky130_fd_sc_hd__diode_2
XTAP_TAPCELL_ROW_107_1653 VGND VPWR sky130_fd_sc_hd__tapvpwrvgnd_1
XANTENNA__7021__S _3398_ VGND VGND VPWR VPWR sky130_fd_sc_hd__diode_2
XANTENNA__4696__S1 _1324_ VGND VGND VPWR VPWR sky130_fd_sc_hd__diode_2
XFILLER_0_95_221 VGND VGND VPWR VPWR sky130_fd_sc_hd__decap_3
XFILLER_0_83_405 VGND VGND VPWR VPWR sky130_fd_sc_hd__decap_3
XFILLER_0_49_660 VGND VGND VPWR VPWR sky130_fd_sc_hd__fill_1
XANTENNA__4380__S _1117_ VGND VGND VPWR VPWR sky130_fd_sc_hd__diode_2
XFILLER_0_64_685 VPWR VGND VPWR VGND sky130_ef_sc_hd__decap_12
XFILLER_0_63_173 VGND VGND VPWR VPWR sky130_fd_sc_hd__fill_2
Xclkbuf_leaf_21_clk clknet_4_1_0_clk VGND VGND VPWR VPWR clknet_leaf_21_clk sky130_fd_sc_hd__clkbuf_8
XFILLER_0_36_365 VGND VGND VPWR VPWR sky130_fd_sc_hd__decap_3
XANTENNA__7691__S _3768_ VGND VGND VPWR VPWR sky130_fd_sc_hd__diode_2
XTAP_TAPCELL_ROW_58_1007 VGND VPWR sky130_fd_sc_hd__tapvpwrvgnd_1
XTAP_TAPCELL_ROW_58_1018 VGND VPWR sky130_fd_sc_hd__tapvpwrvgnd_1
XTAP_TAPCELL_ROW_118_1793 VGND VPWR sky130_fd_sc_hd__tapvpwrvgnd_1
XANTENNA__4620__S1 _1339_ VGND VGND VPWR VPWR sky130_fd_sc_hd__diode_2
XFILLER_0_32_571 VGND VGND VPWR VPWR sky130_fd_sc_hd__fill_2
XANTENNA__7475__A0 _3087_ VGND VGND VPWR VPWR sky130_fd_sc_hd__diode_2
XFILLER_0_75_28 VGND VGND VPWR VPWR sky130_fd_sc_hd__decap_8
Xclkbuf_leaf_88_clk clknet_4_8_0_clk VGND VGND VPWR VPWR clknet_leaf_88_clk sky130_fd_sc_hd__clkbuf_8
XANTENNA__8027__S _3948_ VGND VGND VPWR VPWR sky130_fd_sc_hd__diode_2
XTAP_TAPCELL_ROW_69_1158 VGND VPWR sky130_fd_sc_hd__tapvpwrvgnd_1
XFILLER_0_59_402 VGND VGND VPWR VPWR sky130_fd_sc_hd__decap_3
XANTENNA__4687__S1 _1339_ VGND VGND VPWR VPWR sky130_fd_sc_hd__diode_2
XFILLER_0_115_23 VPWR VGND VPWR VGND sky130_ef_sc_hd__decap_12
XFILLER_0_86_221 VGND VGND VPWR VPWR sky130_fd_sc_hd__fill_2
XANTENNA__7866__S _3865_ VGND VGND VPWR VPWR sky130_fd_sc_hd__diode_2
XFILLER_0_24_10 VGND VGND VPWR VPWR sky130_fd_sc_hd__fill_2
XTAP_TAPCELL_ROW_35_717 VGND VPWR sky130_fd_sc_hd__tapvpwrvgnd_1
XTAP_TAPCELL_ROW_82_1325 VGND VPWR sky130_fd_sc_hd__tapvpwrvgnd_1
XANTENNA__6770__S _3261_ VGND VGND VPWR VPWR sky130_fd_sc_hd__diode_2
X_4870_ registers\[0\]\[0\] registers\[1\]\[0\] registers\[2\]\[0\] registers\[3\]\[0\]
+ _1617_ _1618_ VGND VGND VPWR VPWR _1638_ sky130_fd_sc_hd__mux4_1
XTAP_TAPCELL_ROW_15_452 VGND VPWR sky130_fd_sc_hd__tapvpwrvgnd_1
X_6540_ registers\[7\]\[5\] _2972_ _3137_ VGND VGND VPWR VPWR _3143_ sky130_fd_sc_hd__mux2_1
XFILLER_0_55_641 VGND VGND VPWR VPWR sky130_fd_sc_hd__fill_1
Xclkbuf_leaf_12_clk clknet_4_3_0_clk VGND VGND VPWR VPWR clknet_leaf_12_clk sky130_fd_sc_hd__clkbuf_8
XFILLER_0_6_259 VGND VGND VPWR VPWR sky130_fd_sc_hd__fill_2
X_6471_ _3097_ VGND VGND VPWR VPWR _0742_ sky130_fd_sc_hd__clkbuf_1
XFILLER_0_70_633 VGND VGND VPWR VPWR sky130_fd_sc_hd__fill_2
X_9190_ clknet_leaf_42_clk _0287_ VGND VGND VPWR VPWR registers\[25\]\[6\] sky130_fd_sc_hd__dfxtp_1
XFILLER_0_71_7 VGND VGND VPWR VPWR sky130_fd_sc_hd__fill_2
XFILLER_0_2_421 VGND VGND VPWR VPWR sky130_fd_sc_hd__fill_1
X_5422_ registers\[12\]\[29\] registers\[13\]\[29\] registers\[14\]\[29\] registers\[15\]\[29\]
+ _2119_ _2120_ VGND VGND VPWR VPWR _2161_ sky130_fd_sc_hd__mux4_1
X_8210_ registers\[6\]\[2\] _3439_ _4045_ VGND VGND VPWR VPWR _4048_ sky130_fd_sc_hd__mux2_1
XANTENNA__4611__S1 _1391_ VGND VGND VPWR VPWR sky130_fd_sc_hd__diode_2
X_8141_ _4011_ VGND VGND VPWR VPWR _0474_ sky130_fd_sc_hd__clkbuf_1
X_5353_ _2076_ _2095_ VGND VGND VPWR VPWR _2096_ sky130_fd_sc_hd__and2_1
XFILLER_0_112_289 VGND VGND VPWR VPWR sky130_fd_sc_hd__fill_2
XTAP_TAPCELL_ROW_93_1465 VGND VPWR sky130_fd_sc_hd__tapvpwrvgnd_1
X_4304_ net6 _1100_ _1024_ VGND VGND VPWR VPWR _1101_ sky130_fd_sc_hd__o21a_1
XFILLER_0_2_498 VGND VGND VPWR VPWR sky130_fd_sc_hd__decap_8
X_5284_ _1746_ VGND VGND VPWR VPWR _2031_ sky130_fd_sc_hd__clkbuf_8
XFILLER_0_49_95 VGND VGND VPWR VPWR sky130_fd_sc_hd__fill_2
X_8072_ _2964_ registers\[30\]\[1\] _3973_ VGND VGND VPWR VPWR _3975_ sky130_fd_sc_hd__mux2_1
X_7023_ _3077_ registers\[15\]\[4\] _3398_ VGND VGND VPWR VPWR _3403_ sky130_fd_sc_hd__mux2_1
XANTENNA__4375__S0 _1167_ VGND VGND VPWR VPWR sky130_fd_sc_hd__diode_2
X_4235_ registers\[28\]\[0\] registers\[29\]\[0\] registers\[30\]\[0\] registers\[31\]\[0\]
+ _1026_ _1027_ VGND VGND VPWR VPWR _1035_ sky130_fd_sc_hd__mux4_1
XFILLER_0_4_42 VGND VGND VPWR VPWR sky130_fd_sc_hd__fill_1
XFILLER_0_4_20 VGND VGND VPWR VPWR sky130_fd_sc_hd__fill_2
Xclkbuf_leaf_79_clk clknet_4_10_0_clk VGND VGND VPWR VPWR clknet_leaf_79_clk sky130_fd_sc_hd__clkbuf_8
XFILLER_0_65_61 VGND VGND VPWR VPWR sky130_fd_sc_hd__fill_1
X_8974_ clknet_leaf_39_clk _0071_ VGND VGND VPWR VPWR registers\[18\]\[14\] sky130_fd_sc_hd__dfxtp_1
XANTENNA__4678__S1 _1383_ VGND VGND VPWR VPWR sky130_fd_sc_hd__diode_2
X_7925_ _3896_ VGND VGND VPWR VPWR _0373_ sky130_fd_sc_hd__clkbuf_1
XANTENNA__7776__S _3815_ VGND VGND VPWR VPWR sky130_fd_sc_hd__diode_2
X_7856_ _3127_ registers\[26\]\[28\] _3851_ VGND VGND VPWR VPWR _3860_ sky130_fd_sc_hd__mux2_1
XANTENNA__8194__A1 _3491_ VGND VGND VPWR VPWR sky130_fd_sc_hd__diode_2
XFILLER_0_65_449 VGND VGND VPWR VPWR sky130_fd_sc_hd__fill_1
X_6807_ _3285_ _3286_ VGND VGND VPWR VPWR _3287_ sky130_fd_sc_hd__and2_2
X_4999_ registers\[12\]\[6\] registers\[13\]\[6\] registers\[14\]\[6\] registers\[15\]\[6\]
+ _1758_ _1760_ VGND VGND VPWR VPWR _1761_ sky130_fd_sc_hd__mux4_1
XTAP_TAPCELL_ROW_102_1583 VGND VPWR sky130_fd_sc_hd__tapvpwrvgnd_1
XANTENNA__5296__S _1689_ VGND VGND VPWR VPWR sky130_fd_sc_hd__diode_2
X_9526_ clknet_leaf_95_clk _0623_ VGND VGND VPWR VPWR registers\[8\]\[22\] sky130_fd_sc_hd__dfxtp_1
X_7787_ _3823_ VGND VGND VPWR VPWR _0308_ sky130_fd_sc_hd__clkbuf_1
XFILLER_0_73_471 VGND VGND VPWR VPWR sky130_fd_sc_hd__fill_2
XFILLER_0_61_611 VGND VGND VPWR VPWR sky130_fd_sc_hd__decap_3
X_6738_ _3249_ VGND VGND VPWR VPWR _3250_ sky130_fd_sc_hd__clkbuf_8
XFILLER_0_46_696 VGND VGND VPWR VPWR sky130_fd_sc_hd__fill_2
XFILLER_0_46_685 VGND VGND VPWR VPWR sky130_fd_sc_hd__fill_1
XFILLER_0_18_365 VGND VGND VPWR VPWR sky130_fd_sc_hd__fill_1
XFILLER_0_18_387 VGND VGND VPWR VPWR sky130_fd_sc_hd__fill_2
X_9457_ clknet_leaf_53_clk _0554_ VGND VGND VPWR VPWR registers\[31\]\[17\] sky130_fd_sc_hd__dfxtp_1
XFILLER_0_60_110 VGND VGND VPWR VPWR sky130_fd_sc_hd__fill_2
X_6669_ _3210_ _3212_ VGND VGND VPWR VPWR _3213_ sky130_fd_sc_hd__nor2_2
X_9388_ clknet_leaf_17_clk _0485_ VGND VGND VPWR VPWR registers\[9\]\[12\] sky130_fd_sc_hd__dfxtp_1
XFILLER_0_60_165 VGND VGND VPWR VPWR sky130_fd_sc_hd__fill_2
X_8408_ _3173_ _3210_ VGND VGND VPWR VPWR _4152_ sky130_fd_sc_hd__nor2_2
XANTENNA__8400__S _4139_ VGND VGND VPWR VPWR sky130_fd_sc_hd__diode_2
XANTENNA__4602__S1 _1383_ VGND VGND VPWR VPWR sky130_fd_sc_hd__diode_2
X_8339_ _4115_ VGND VGND VPWR VPWR _0568_ sky130_fd_sc_hd__clkbuf_1
XANTENNA__7457__A0 _3065_ VGND VGND VPWR VPWR sky130_fd_sc_hd__diode_2
XANTENNA__6855__S _3310_ VGND VGND VPWR VPWR sky130_fd_sc_hd__diode_2
XANTENNA__6156__A _2353_ VGND VGND VPWR VPWR sky130_fd_sc_hd__diode_2
XFILLER_0_69_700 VGND VGND VPWR VPWR sky130_fd_sc_hd__fill_2
XANTENNA__5060__A _1819_ VGND VGND VPWR VPWR sky130_fd_sc_hd__diode_2
XFILLER_0_96_541 VGND VGND VPWR VPWR sky130_fd_sc_hd__fill_2
XFILLER_0_68_210 VGND VGND VPWR VPWR sky130_fd_sc_hd__decap_6
XFILLER_0_96_574 VGND VGND VPWR VPWR sky130_fd_sc_hd__fill_1
XANTENNA__5995__A _1943_ VGND VGND VPWR VPWR sky130_fd_sc_hd__diode_2
XANTENNA__6590__S _3159_ VGND VGND VPWR VPWR sky130_fd_sc_hd__diode_2
XTAP_TAPCELL_ROW_64_1088 VGND VPWR sky130_fd_sc_hd__tapvpwrvgnd_1
XFILLER_0_49_490 VGND VGND VPWR VPWR sky130_fd_sc_hd__fill_2
XTAP_TAPCELL_ROW_12_411 VGND VPWR sky130_fd_sc_hd__tapvpwrvgnd_1
XANTENNA__4404__A _1196_ VGND VGND VPWR VPWR sky130_fd_sc_hd__diode_2
XFILLER_0_83_279 VGND VGND VPWR VPWR sky130_fd_sc_hd__fill_1
XFILLER_0_64_471 VGND VGND VPWR VPWR sky130_fd_sc_hd__fill_1
XFILLER_0_64_493 VGND VGND VPWR VPWR sky130_fd_sc_hd__decap_3
XFILLER_0_52_622 VGND VGND VPWR VPWR sky130_fd_sc_hd__fill_2
XFILLER_0_51_121 VGND VGND VPWR VPWR sky130_fd_sc_hd__fill_1
XTAP_TAPCELL_ROW_40_775 VGND VPWR sky130_fd_sc_hd__tapvpwrvgnd_1
XFILLER_0_107_595 VPWR VGND VPWR VGND sky130_ef_sc_hd__decap_12
XFILLER_0_52_688 VGND VGND VPWR VPWR sky130_fd_sc_hd__fill_1
XFILLER_0_51_165 VGND VGND VPWR VPWR sky130_fd_sc_hd__decap_3
XFILLER_0_3_229 VGND VGND VPWR VPWR sky130_fd_sc_hd__fill_1
XFILLER_0_10_23 VGND VGND VPWR VPWR sky130_fd_sc_hd__decap_3
XFILLER_0_10_34 VGND VGND VPWR VPWR sky130_fd_sc_hd__decap_4
XFILLER_0_12_519 VGND VGND VPWR VPWR sky130_fd_sc_hd__fill_2
XANTENNA__5171__A1 _1809_ VGND VGND VPWR VPWR sky130_fd_sc_hd__diode_2
XFILLER_0_110_716 VGND VGND VPWR VPWR sky130_fd_sc_hd__fill_2
XFILLER_0_86_38 VGND VGND VPWR VPWR sky130_fd_sc_hd__fill_2
XFILLER_0_20_552 VGND VGND VPWR VPWR sky130_fd_sc_hd__fill_2
Xclkbuf_leaf_1_clk clknet_4_0_0_clk VGND VGND VPWR VPWR clknet_leaf_1_clk sky130_fd_sc_hd__clkbuf_8
XANTENNA__6671__A1 _2958_ VGND VGND VPWR VPWR sky130_fd_sc_hd__diode_2
X_5971_ _2636_ _2690_ _2403_ VGND VGND VPWR VPWR _2691_ sky130_fd_sc_hd__mux2_1
XTAP_TAPCELL_ROW_48_886 VGND VPWR sky130_fd_sc_hd__tapvpwrvgnd_1
X_8690_ clknet_leaf_67_clk _0811_ VGND VGND VPWR VPWR registers\[0\]\[18\] sky130_fd_sc_hd__dfxtp_1
X_4922_ _1634_ VGND VGND VPWR VPWR _1687_ sky130_fd_sc_hd__buf_6
X_7710_ registers\[24\]\[23\] _3483_ _3779_ VGND VGND VPWR VPWR _3783_ sky130_fd_sc_hd__mux2_1
XFILLER_0_59_276 VGND VGND VPWR VPWR sky130_fd_sc_hd__fill_2
XFILLER_0_19_107 VGND VGND VPWR VPWR sky130_fd_sc_hd__fill_2
XFILLER_0_19_118 VGND VGND VPWR VPWR sky130_fd_sc_hd__fill_2
X_7641_ _3117_ registers\[23\]\[23\] _3742_ VGND VGND VPWR VPWR _3746_ sky130_fd_sc_hd__mux2_1
XFILLER_0_117_326 VGND VGND VPWR VPWR sky130_fd_sc_hd__fill_1
XFILLER_0_74_246 VGND VGND VPWR VPWR sky130_fd_sc_hd__decap_4
XFILLER_0_47_449 VGND VGND VPWR VPWR sky130_fd_sc_hd__fill_2
X_4853_ net3 VGND VGND VPWR VPWR _1621_ sky130_fd_sc_hd__inv_2
XFILLER_0_117_337 VGND VGND VPWR VPWR sky130_fd_sc_hd__fill_1
XANTENNA__5085__S1 _1775_ VGND VGND VPWR VPWR sky130_fd_sc_hd__diode_2
XANTENNA__4314__A _1060_ VGND VGND VPWR VPWR sky130_fd_sc_hd__diode_2
XFILLER_0_62_419 VGND VGND VPWR VPWR sky130_fd_sc_hd__fill_1
XFILLER_0_55_460 VGND VGND VPWR VPWR sky130_fd_sc_hd__fill_2
XFILLER_0_51_85 VGND VGND VPWR VPWR sky130_fd_sc_hd__decap_4
X_4784_ _1348_ VGND VGND VPWR VPWR _1556_ sky130_fd_sc_hd__clkbuf_4
X_7572_ _3709_ VGND VGND VPWR VPWR _0207_ sky130_fd_sc_hd__clkbuf_1
X_9311_ clknet_leaf_10_clk _0408_ VGND VGND VPWR VPWR registers\[28\]\[31\] sky130_fd_sc_hd__dfxtp_1
X_6523_ _3132_ VGND VGND VPWR VPWR _0759_ sky130_fd_sc_hd__clkbuf_1
XANTENNA__8220__S _4045_ VGND VGND VPWR VPWR sky130_fd_sc_hd__diode_2
X_6454_ _3085_ registers\[29\]\[8\] _3069_ VGND VGND VPWR VPWR _3086_ sky130_fd_sc_hd__mux2_1
XFILLER_0_43_677 VGND VGND VPWR VPWR sky130_fd_sc_hd__fill_2
X_9242_ clknet_leaf_77_clk _0339_ VGND VGND VPWR VPWR registers\[26\]\[26\] sky130_fd_sc_hd__dfxtp_1
Xclkload50 clknet_leaf_15_clk VGND VGND VPWR VPWR clkload50/Y sky130_fd_sc_hd__bufinv_16
Xclkload61 clknet_leaf_86_clk VGND VGND VPWR VPWR clkload61/Y sky130_fd_sc_hd__clkinvlp_2
X_5405_ registers\[8\]\[28\] registers\[9\]\[28\] registers\[10\]\[28\] registers\[11\]\[28\]
+ _2072_ _2073_ VGND VGND VPWR VPWR _2145_ sky130_fd_sc_hd__mux4_1
XFILLER_0_113_598 VGND VGND VPWR VPWR sky130_fd_sc_hd__fill_2
XFILLER_0_101_727 VGND VGND VPWR VPWR sky130_fd_sc_hd__fill_1
Xclkload94 clknet_leaf_52_clk VGND VGND VPWR VPWR clkload94/Y sky130_fd_sc_hd__bufinv_16
X_6385_ _3044_ VGND VGND VPWR VPWR _0709_ sky130_fd_sc_hd__clkbuf_1
XANTENNA__5145__A _1899_ VGND VGND VPWR VPWR sky130_fd_sc_hd__diode_2
Xclkload72 clknet_leaf_97_clk VGND VGND VPWR VPWR clkload72/Y sky130_fd_sc_hd__clkinvlp_4
Xclkload83 clknet_leaf_70_clk VGND VGND VPWR VPWR clkload83/X sky130_fd_sc_hd__clkbuf_4
XFILLER_0_2_273 VGND VGND VPWR VPWR sky130_fd_sc_hd__fill_1
X_9173_ clknet_leaf_79_clk _0270_ VGND VGND VPWR VPWR registers\[24\]\[21\] sky130_fd_sc_hd__dfxtp_1
X_5336_ registers\[0\]\[24\] registers\[1\]\[24\] registers\[2\]\[24\] registers\[3\]\[24\]
+ _2072_ _2073_ VGND VGND VPWR VPWR _2080_ sky130_fd_sc_hd__mux4_1
XPHY_EDGE_ROW_10_Left_130 VGND VGND VPWR VPWR sky130_fd_sc_hd__decap_3
X_8124_ _3016_ registers\[30\]\[26\] _3995_ VGND VGND VPWR VPWR _4002_ sky130_fd_sc_hd__mux2_1
XANTENNA__4984__A _1682_ VGND VGND VPWR VPWR sky130_fd_sc_hd__diode_2
X_8055_ _3965_ VGND VGND VPWR VPWR _0434_ sky130_fd_sc_hd__clkbuf_1
X_5267_ _2012_ _2013_ _1768_ VGND VGND VPWR VPWR _2014_ sky130_fd_sc_hd__mux2_1
XANTENNA__6675__S _3214_ VGND VGND VPWR VPWR sky130_fd_sc_hd__diode_2
X_7006_ _3129_ registers\[14\]\[29\] _3383_ VGND VGND VPWR VPWR _3393_ sky130_fd_sc_hd__mux2_1
XANTENNA__4899__S1 _1618_ VGND VGND VPWR VPWR sky130_fd_sc_hd__diode_2
X_5198_ _1947_ _1948_ _1767_ VGND VGND VPWR VPWR _1949_ sky130_fd_sc_hd__mux2_1
XANTENNA__7611__A0 _3087_ VGND VGND VPWR VPWR sky130_fd_sc_hd__diode_2
XFILLER_0_97_327 VGND VGND VPWR VPWR sky130_fd_sc_hd__fill_2
X_8957_ clknet_leaf_102_clk _0054_ VGND VGND VPWR VPWR registers\[17\]\[29\] sky130_fd_sc_hd__dfxtp_1
XTAP_TAPCELL_ROW_104_1612 VGND VPWR sky130_fd_sc_hd__tapvpwrvgnd_1
XFILLER_0_78_563 VGND VGND VPWR VPWR sky130_fd_sc_hd__fill_2
XFILLER_0_78_552 VGND VGND VPWR VPWR sky130_fd_sc_hd__decap_6
XANTENNA__4923__S _1687_ VGND VGND VPWR VPWR sky130_fd_sc_hd__diode_2
X_7908_ _3110_ registers\[27\]\[20\] _3887_ VGND VGND VPWR VPWR _3888_ sky130_fd_sc_hd__mux2_1
XANTENNA__4976__B2 _1655_ VGND VGND VPWR VPWR sky130_fd_sc_hd__diode_2
XFILLER_0_93_500 VGND VGND VPWR VPWR sky130_fd_sc_hd__fill_2
XFILLER_0_78_585 VGND VGND VPWR VPWR sky130_fd_sc_hd__decap_3
X_8888_ clknet_leaf_87_clk _1009_ VGND VGND VPWR VPWR registers\[15\]\[24\] sky130_fd_sc_hd__dfxtp_1
X_7839_ _3828_ VGND VGND VPWR VPWR _3851_ sky130_fd_sc_hd__clkbuf_8
XFILLER_0_93_599 VGND VGND VPWR VPWR sky130_fd_sc_hd__fill_2
XFILLER_0_46_471 VGND VGND VPWR VPWR sky130_fd_sc_hd__fill_2
XANTENNA__4224__A net7 VGND VGND VPWR VPWR sky130_fd_sc_hd__diode_2
XFILLER_0_19_663 VGND VGND VPWR VPWR sky130_fd_sc_hd__decap_8
X_9509_ clknet_leaf_31_clk _0606_ VGND VGND VPWR VPWR registers\[8\]\[5\] sky130_fd_sc_hd__dfxtp_1
XANTENNA__4823__S1 _1383_ VGND VGND VPWR VPWR sky130_fd_sc_hd__diode_2
Xclkload0 clknet_4_1_0_clk VGND VGND VPWR VPWR clkload0/X sky130_fd_sc_hd__clkbuf_8
XFILLER_0_18_195 VGND VGND VPWR VPWR sky130_fd_sc_hd__fill_1
XANTENNA__8130__S _3995_ VGND VGND VPWR VPWR sky130_fd_sc_hd__diode_2
XFILLER_0_33_143 VGND VGND VPWR VPWR sky130_fd_sc_hd__fill_2
XFILLER_0_33_187 VGND VGND VPWR VPWR sky130_fd_sc_hd__decap_3
XFILLER_0_34_699 VGND VGND VPWR VPWR sky130_fd_sc_hd__fill_1
XTAP_TAPCELL_ROW_115_1752 VGND VPWR sky130_fd_sc_hd__tapvpwrvgnd_1
XFILLER_0_104_576 VGND VGND VPWR VPWR sky130_fd_sc_hd__fill_2
XANTENNA_input46_A wd3[8] VGND VGND VPWR VPWR sky130_fd_sc_hd__diode_2
XANTENNA__4894__A _1660_ VGND VGND VPWR VPWR sky130_fd_sc_hd__diode_2
XFILLER_0_72_18 VGND VGND VPWR VPWR sky130_fd_sc_hd__fill_2
XTAP_TAPCELL_ROW_66_1117 VGND VPWR sky130_fd_sc_hd__tapvpwrvgnd_1
XANTENNA__4511__S0 _1198_ VGND VGND VPWR VPWR sky130_fd_sc_hd__diode_2
XANTENNA__8305__S _4092_ VGND VGND VPWR VPWR sky130_fd_sc_hd__diode_2
XFILLER_0_69_552 VGND VGND VPWR VPWR sky130_fd_sc_hd__decap_4
XTAP_TAPCELL_ROW_45_845 VGND VPWR sky130_fd_sc_hd__tapvpwrvgnd_1
XFILLER_0_96_360 VGND VGND VPWR VPWR sky130_fd_sc_hd__fill_2
XFILLER_0_84_555 VGND VGND VPWR VPWR sky130_fd_sc_hd__fill_2
XFILLER_0_84_533 VGND VGND VPWR VPWR sky130_fd_sc_hd__fill_2
XANTENNA__6169__B1 _2878_ VGND VGND VPWR VPWR sky130_fd_sc_hd__diode_2
XANTENNA__5067__S1 _1701_ VGND VGND VPWR VPWR sky130_fd_sc_hd__diode_2
XTAP_TAPCELL_ROW_25_580 VGND VPWR sky130_fd_sc_hd__tapvpwrvgnd_1
XFILLER_0_21_44 VGND VGND VPWR VPWR sky130_fd_sc_hd__fill_2
XFILLER_0_21_55 VGND VGND VPWR VPWR sky130_fd_sc_hd__fill_1
XFILLER_0_21_66 VGND VGND VPWR VPWR sky130_fd_sc_hd__fill_2
XFILLER_0_21_77 VGND VGND VPWR VPWR sky130_fd_sc_hd__fill_2
XFILLER_0_25_677 VGND VGND VPWR VPWR sky130_fd_sc_hd__fill_2
XFILLER_0_97_15 VGND VGND VPWR VPWR sky130_fd_sc_hd__fill_2
XFILLER_0_12_327 VGND VGND VPWR VPWR sky130_fd_sc_hd__fill_1
XFILLER_0_110_502 VGND VGND VPWR VPWR sky130_fd_sc_hd__fill_1
XANTENNA__4578__S0 _1132_ VGND VGND VPWR VPWR sky130_fd_sc_hd__diode_2
XTAP_TAPCELL_ROW_77_1257 VGND VPWR sky130_fd_sc_hd__tapvpwrvgnd_1
XTAP_TAPCELL_ROW_90_1424 VGND VPWR sky130_fd_sc_hd__tapvpwrvgnd_1
X_6170_ net131 _2871_ net132 VGND VGND VPWR VPWR _2879_ sky130_fd_sc_hd__o21a_1
XTAP_TAPCELL_ROW_90_1435 VGND VPWR sky130_fd_sc_hd__tapvpwrvgnd_1
X_5121_ registers\[4\]\[12\] registers\[5\]\[12\] registers\[6\]\[12\] registers\[7\]\[12\]
+ _1806_ _1759_ VGND VGND VPWR VPWR _1877_ sky130_fd_sc_hd__mux4_1
XANTENNA__6495__S _3111_ VGND VGND VPWR VPWR sky130_fd_sc_hd__diode_2
X_5052_ registers\[0\]\[8\] registers\[1\]\[8\] registers\[2\]\[8\] registers\[3\]\[8\]
+ _1810_ _1811_ VGND VGND VPWR VPWR _1812_ sky130_fd_sc_hd__mux4_1
XFILLER_0_79_316 VGND VGND VPWR VPWR sky130_fd_sc_hd__fill_1
X_8811_ clknet_leaf_55_clk _0932_ VGND VGND VPWR VPWR registers\[13\]\[11\] sky130_fd_sc_hd__dfxtp_1
X_8742_ clknet_leaf_36_clk _0863_ VGND VGND VPWR VPWR registers\[11\]\[6\] sky130_fd_sc_hd__dfxtp_1
XTAP_TAPCELL_ROW_88_1397 VGND VPWR sky130_fd_sc_hd__tapvpwrvgnd_1
X_5954_ _2651_ _2674_ _2293_ VGND VGND VPWR VPWR _2675_ sky130_fd_sc_hd__mux2_1
XFILLER_0_75_500 VGND VGND VPWR VPWR sky130_fd_sc_hd__fill_1
XFILLER_0_48_714 VGND VGND VPWR VPWR sky130_fd_sc_hd__fill_1
XANTENNA__6524__A net40 VGND VGND VPWR VPWR sky130_fd_sc_hd__diode_2
X_5885_ net114 _2515_ _2595_ VGND VGND VPWR VPWR _2610_ sky130_fd_sc_hd__a21oi_1
X_8673_ clknet_leaf_7_clk _0794_ VGND VGND VPWR VPWR registers\[0\]\[1\] sky130_fd_sc_hd__dfxtp_1
X_4905_ _1631_ _1670_ _1636_ VGND VGND VPWR VPWR _1671_ sky130_fd_sc_hd__o21a_1
XFILLER_0_118_657 VPWR VGND VPWR VGND sky130_ef_sc_hd__decap_12
XFILLER_0_117_134 VGND VGND VPWR VPWR sky130_fd_sc_hd__decap_8
X_7624_ _3100_ registers\[23\]\[15\] _3731_ VGND VGND VPWR VPWR _3737_ sky130_fd_sc_hd__mux2_1
XFILLER_0_62_205 VGND VGND VPWR VPWR sky130_fd_sc_hd__decap_4
XFILLER_0_47_279 VGND VGND VPWR VPWR sky130_fd_sc_hd__fill_1
X_4836_ registers\[24\]\[31\] registers\[25\]\[31\] registers\[26\]\[31\] registers\[27\]\[31\]
+ _1555_ _1556_ VGND VGND VPWR VPWR _1605_ sky130_fd_sc_hd__mux4_1
X_7555_ _3700_ VGND VGND VPWR VPWR _0199_ sky130_fd_sc_hd__clkbuf_1
XFILLER_0_90_547 VGND VGND VPWR VPWR sky130_fd_sc_hd__fill_2
XFILLER_0_62_216 VGND VGND VPWR VPWR sky130_fd_sc_hd__decap_3
XFILLER_0_28_493 VGND VGND VPWR VPWR sky130_fd_sc_hd__fill_2
XFILLER_0_117_189 VPWR VGND VPWR VGND sky130_ef_sc_hd__decap_12
XANTENNA__4979__A _1677_ VGND VGND VPWR VPWR sky130_fd_sc_hd__diode_2
XFILLER_0_7_387 VGND VGND VPWR VPWR sky130_fd_sc_hd__decap_4
X_6506_ net33 VGND VGND VPWR VPWR _3121_ sky130_fd_sc_hd__clkbuf_2
X_4767_ _1536_ _1539_ _1379_ VGND VGND VPWR VPWR _1540_ sky130_fd_sc_hd__mux2_1
X_7486_ _3098_ registers\[21\]\[14\] _3659_ VGND VGND VPWR VPWR _3664_ sky130_fd_sc_hd__mux2_1
XFILLER_0_43_485 VGND VGND VPWR VPWR sky130_fd_sc_hd__fill_2
X_4698_ _1471_ _1474_ _1124_ VGND VGND VPWR VPWR _1475_ sky130_fd_sc_hd__mux2_1
XFILLER_0_16_699 VGND VGND VPWR VPWR sky130_fd_sc_hd__fill_1
XANTENNA__4569__S0 _1323_ VGND VGND VPWR VPWR sky130_fd_sc_hd__diode_2
X_9225_ clknet_leaf_8_clk _0322_ VGND VGND VPWR VPWR registers\[26\]\[9\] sky130_fd_sc_hd__dfxtp_1
X_6437_ _3074_ VGND VGND VPWR VPWR _0731_ sky130_fd_sc_hd__clkbuf_1
XFILLER_0_30_135 VGND VGND VPWR VPWR sky130_fd_sc_hd__fill_2
XFILLER_0_31_669 VGND VGND VPWR VPWR sky130_fd_sc_hd__decap_3
X_6368_ _3035_ VGND VGND VPWR VPWR _0701_ sky130_fd_sc_hd__clkbuf_1
X_9156_ clknet_leaf_27_clk _0253_ VGND VGND VPWR VPWR registers\[24\]\[4\] sky130_fd_sc_hd__dfxtp_1
XFILLER_0_30_157 VGND VGND VPWR VPWR sky130_fd_sc_hd__fill_1
XFILLER_0_87_81 VGND VGND VPWR VPWR sky130_fd_sc_hd__fill_2
XANTENNA__4918__S _1682_ VGND VGND VPWR VPWR sky130_fd_sc_hd__diode_2
X_8107_ _2999_ registers\[30\]\[18\] _3984_ VGND VGND VPWR VPWR _3993_ sky130_fd_sc_hd__mux2_1
X_5319_ _1677_ _2055_ _2063_ VGND VGND VPWR VPWR _2064_ sky130_fd_sc_hd__o21a_1
XFILLER_0_11_382 VGND VGND VPWR VPWR sky130_fd_sc_hd__decap_8
XFILLER_0_11_393 VGND VGND VPWR VPWR sky130_fd_sc_hd__decap_3
X_6299_ registers\[19\]\[13\] _2989_ _2983_ VGND VGND VPWR VPWR _2990_ sky130_fd_sc_hd__mux2_1
XANTENNA__6635__A1 _2997_ VGND VGND VPWR VPWR sky130_fd_sc_hd__diode_2
X_9087_ clknet_leaf_2_clk _0184_ VGND VGND VPWR VPWR registers\[21\]\[31\] sky130_fd_sc_hd__dfxtp_1
XTAP_TAPCELL_ROW_110_1693 VGND VPWR sky130_fd_sc_hd__tapvpwrvgnd_1
X_8038_ _3956_ VGND VGND VPWR VPWR _0426_ sky130_fd_sc_hd__clkbuf_1
XFILLER_0_98_636 VGND VGND VPWR VPWR sky130_fd_sc_hd__decap_8
XTAP_TAPCELL_ROW_3_297 VGND VPWR sky130_fd_sc_hd__tapvpwrvgnd_1
XANTENNA__5071__B1 _1655_ VGND VGND VPWR VPWR sky130_fd_sc_hd__diode_2
XTAP_TAPCELL_ROW_42_804 VGND VPWR sky130_fd_sc_hd__tapvpwrvgnd_1
XFILLER_0_66_533 VGND VGND VPWR VPWR sky130_fd_sc_hd__fill_2
XTAP_TAPCELL_ROW_61_1047 VGND VPWR sky130_fd_sc_hd__tapvpwrvgnd_1
XFILLER_0_54_717 VGND VGND VPWR VPWR sky130_fd_sc_hd__fill_2
XFILLER_0_53_205 VGND VGND VPWR VPWR sky130_fd_sc_hd__fill_1
XFILLER_0_81_525 VGND VGND VPWR VPWR sky130_fd_sc_hd__fill_1
XTAP_TAPCELL_ROW_61_1058 VGND VPWR sky130_fd_sc_hd__tapvpwrvgnd_1
XTAP_TAPCELL_ROW_22_550 VGND VPWR sky130_fd_sc_hd__tapvpwrvgnd_1
XFILLER_0_108_178 VGND VGND VPWR VPWR sky130_fd_sc_hd__decap_3
XFILLER_0_61_271 VGND VGND VPWR VPWR sky130_fd_sc_hd__decap_4
XANTENNA__5126__A1 _1741_ VGND VGND VPWR VPWR sky130_fd_sc_hd__diode_2
XFILLER_0_21_113 VGND VGND VPWR VPWR sky130_fd_sc_hd__fill_2
XANTENNA__5221__S1 _1969_ VGND VGND VPWR VPWR sky130_fd_sc_hd__diode_2
XTAP_TAPCELL_ROW_72_1198 VGND VPWR sky130_fd_sc_hd__tapvpwrvgnd_1
XFILLER_0_107_57 VGND VGND VPWR VPWR sky130_fd_sc_hd__fill_2
XFILLER_0_89_625 VGND VGND VPWR VPWR sky130_fd_sc_hd__decap_4
XANTENNA__8379__A1 _3472_ VGND VGND VPWR VPWR sky130_fd_sc_hd__diode_2
XFILLER_0_16_22 VGND VGND VPWR VPWR sky130_fd_sc_hd__decap_4
XFILLER_0_107_68 VGND VGND VPWR VPWR sky130_fd_sc_hd__fill_2
XFILLER_0_76_319 VGND VGND VPWR VPWR sky130_fd_sc_hd__fill_1
XANTENNA__8035__S _3948_ VGND VGND VPWR VPWR sky130_fd_sc_hd__diode_2
XANTENNA__6344__A net36 VGND VGND VPWR VPWR sky130_fd_sc_hd__diode_2
XFILLER_0_29_202 VGND VGND VPWR VPWR sky130_fd_sc_hd__fill_1
XFILLER_0_96_190 VGND VGND VPWR VPWR sky130_fd_sc_hd__decap_4
XFILLER_0_69_393 VGND VGND VPWR VPWR sky130_fd_sc_hd__fill_1
XFILLER_0_57_555 VGND VGND VPWR VPWR sky130_fd_sc_hd__decap_3
X_5670_ _2401_ _2402_ _2403_ VGND VGND VPWR VPWR _2404_ sky130_fd_sc_hd__mux2_1
XANTENNA__7874__S _3865_ VGND VGND VPWR VPWR sky130_fd_sc_hd__diode_2
XFILLER_0_84_363 VGND VGND VPWR VPWR sky130_fd_sc_hd__fill_1
XFILLER_0_57_577 VGND VGND VPWR VPWR sky130_fd_sc_hd__fill_2
XFILLER_0_32_65 VGND VGND VPWR VPWR sky130_fd_sc_hd__fill_1
X_4621_ _1400_ _1401_ _1344_ VGND VGND VPWR VPWR _1402_ sky130_fd_sc_hd__mux2_1
XANTENNA_clkbuf_0_clk_A clk VGND VGND VPWR VPWR sky130_fd_sc_hd__diode_2
XANTENNA__7175__A net39 VGND VGND VPWR VPWR sky130_fd_sc_hd__diode_2
XANTENNA__4799__S0 _1555_ VGND VGND VPWR VPWR sky130_fd_sc_hd__diode_2
XFILLER_0_4_313 VGND VGND VPWR VPWR sky130_fd_sc_hd__fill_2
X_4552_ _1109_ _1328_ _1336_ VGND VGND VPWR VPWR _1337_ sky130_fd_sc_hd__o21ai_2
X_7340_ _3574_ VGND VGND VPWR VPWR _3586_ sky130_fd_sc_hd__buf_4
XFILLER_0_25_474 VGND VGND VPWR VPWR sky130_fd_sc_hd__fill_2
X_4483_ registers\[20\]\[12\] registers\[21\]\[12\] registers\[22\]\[12\] registers\[23\]\[12\]
+ _1111_ _1113_ VGND VGND VPWR VPWR _1271_ sky130_fd_sc_hd__mux4_1
X_7271_ _3549_ VGND VGND VPWR VPWR _0066_ sky130_fd_sc_hd__clkbuf_1
X_6222_ _2654_ _2695_ _2923_ _2927_ _2928_ VGND VGND VPWR VPWR _2929_ sky130_fd_sc_hd__a221o_1
X_9010_ clknet_leaf_65_clk _0107_ VGND VGND VPWR VPWR registers\[1\]\[18\] sky130_fd_sc_hd__dfxtp_1
XANTENNA__5212__S1 _1821_ VGND VGND VPWR VPWR sky130_fd_sc_hd__diode_2
XFILLER_0_40_477 VGND VGND VPWR VPWR sky130_fd_sc_hd__decap_3
XFILLER_0_12_157 VGND VGND VPWR VPWR sky130_fd_sc_hd__decap_6
XANTENNA__6865__A1 _3018_ VGND VGND VPWR VPWR sky130_fd_sc_hd__diode_2
XFILLER_0_40_499 VGND VGND VPWR VPWR sky130_fd_sc_hd__fill_2
XFILLER_0_0_574 VGND VGND VPWR VPWR sky130_fd_sc_hd__decap_4
XANTENNA_clkbuf_4_9_0_clk_A clknet_0_clk VGND VGND VPWR VPWR sky130_fd_sc_hd__diode_2
XANTENNA__4971__S0 _1731_ VGND VGND VPWR VPWR sky130_fd_sc_hd__diode_2
X_6153_ _2842_ _2862_ _2308_ VGND VGND VPWR VPWR _2863_ sky130_fd_sc_hd__mux2_1
XANTENNA__7814__A0 _3085_ VGND VGND VPWR VPWR sky130_fd_sc_hd__diode_2
XFILLER_0_57_62 VGND VGND VPWR VPWR sky130_fd_sc_hd__fill_2
X_6084_ _2362_ _2504_ VGND VGND VPWR VPWR _2798_ sky130_fd_sc_hd__or2_1
X_5104_ _1756_ _1860_ VGND VGND VPWR VPWR _1861_ sky130_fd_sc_hd__nand2_1
XFILLER_0_57_73 VGND VGND VPWR VPWR sky130_fd_sc_hd__decap_6
X_5035_ _1616_ _1787_ _1791_ _1795_ VGND VGND VPWR VPWR _1796_ sky130_fd_sc_hd__a2bb2o_2
XFILLER_0_79_113 VGND VGND VPWR VPWR sky130_fd_sc_hd__decap_6
XFILLER_0_95_606 VGND VGND VPWR VPWR sky130_fd_sc_hd__decap_8
XTAP_TAPCELL_ROW_0_245 VGND VPWR sky130_fd_sc_hd__tapvpwrvgnd_1
XFILLER_0_95_617 VGND VGND VPWR VPWR sky130_fd_sc_hd__fill_2
XFILLER_0_94_105 VGND VGND VPWR VPWR sky130_fd_sc_hd__fill_1
XANTENNA__5053__B1 _1655_ VGND VGND VPWR VPWR sky130_fd_sc_hd__diode_2
X_6986_ _3382_ VGND VGND VPWR VPWR _0972_ sky130_fd_sc_hd__clkbuf_1
XTAP_TAPCELL_ROW_0_256 VGND VPWR sky130_fd_sc_hd__tapvpwrvgnd_1
XANTENNA__6254__A net16 VGND VGND VPWR VPWR sky130_fd_sc_hd__diode_2
X_5937_ _2203_ _2208_ _2483_ _2514_ VGND VGND VPWR VPWR _2659_ sky130_fd_sc_hd__or4_1
X_8725_ clknet_leaf_84_clk _0846_ VGND VGND VPWR VPWR registers\[10\]\[21\] sky130_fd_sc_hd__dfxtp_1
XFILLER_0_118_421 VGND VGND VPWR VPWR sky130_fd_sc_hd__decap_6
XFILLER_0_75_374 VGND VGND VPWR VPWR sky130_fd_sc_hd__fill_2
X_8656_ clknet_leaf_65_clk _0777_ VGND VGND VPWR VPWR registers\[7\]\[16\] sky130_fd_sc_hd__dfxtp_1
XANTENNA__7784__S _3815_ VGND VGND VPWR VPWR sky130_fd_sc_hd__diode_2
XFILLER_0_90_333 VGND VGND VPWR VPWR sky130_fd_sc_hd__fill_1
X_7607_ _3083_ registers\[23\]\[7\] _3720_ VGND VGND VPWR VPWR _3728_ sky130_fd_sc_hd__mux2_1
X_5868_ net143 net144 VGND VGND VPWR VPWR _2594_ sky130_fd_sc_hd__or2_1
XFILLER_0_35_238 VGND VGND VPWR VPWR sky130_fd_sc_hd__decap_4
XANTENNA__8542__A1 net40 VGND VGND VPWR VPWR sky130_fd_sc_hd__diode_2
X_8587_ clknet_leaf_51_clk _0708_ VGND VGND VPWR VPWR registers\[3\]\[11\] sky130_fd_sc_hd__dfxtp_1
X_5799_ net142 _2527_ VGND VGND VPWR VPWR _2528_ sky130_fd_sc_hd__xnor2_1
XFILLER_0_63_558 VGND VGND VPWR VPWR sky130_fd_sc_hd__fill_2
X_4819_ registers\[28\]\[30\] registers\[29\]\[30\] registers\[30\]\[30\] registers\[31\]\[30\]
+ _1390_ _1391_ VGND VGND VPWR VPWR _1589_ sky130_fd_sc_hd__mux4_1
XANTENNA__5356__A1 _2031_ VGND VGND VPWR VPWR sky130_fd_sc_hd__diode_2
X_7538_ _3691_ VGND VGND VPWR VPWR _0191_ sky130_fd_sc_hd__clkbuf_1
XANTENNA__5451__S1 _2127_ VGND VGND VPWR VPWR sky130_fd_sc_hd__diode_2
XANTENNA__5108__A1 _1771_ VGND VGND VPWR VPWR sky130_fd_sc_hd__diode_2
X_7469_ _3081_ registers\[21\]\[6\] _3648_ VGND VGND VPWR VPWR _3655_ sky130_fd_sc_hd__mux2_1
XFILLER_0_71_591 VGND VGND VPWR VPWR sky130_fd_sc_hd__fill_2
XFILLER_0_114_693 VGND VGND VPWR VPWR sky130_fd_sc_hd__decap_6
XTAP_TAPCELL_ROW_112_1711 VGND VPWR sky130_fd_sc_hd__tapvpwrvgnd_1
X_9208_ clknet_leaf_86_clk _0305_ VGND VGND VPWR VPWR registers\[25\]\[24\] sky130_fd_sc_hd__dfxtp_1
Xoutput57 net57 VGND VGND VPWR VPWR alu_result[17] sky130_fd_sc_hd__buf_1
Xoutput79 net79 VGND VGND VPWR VPWR alu_result[8] sky130_fd_sc_hd__buf_1
Xoutput68 net68 VGND VGND VPWR VPWR alu_result[27] sky130_fd_sc_hd__buf_1
X_9139_ clknet_leaf_45_clk _0236_ VGND VGND VPWR VPWR registers\[23\]\[19\] sky130_fd_sc_hd__dfxtp_1
XTAP_TAPCELL_ROW_8_367 VGND VPWR sky130_fd_sc_hd__tapvpwrvgnd_1
XFILLER_0_11_190 VGND VGND VPWR VPWR sky130_fd_sc_hd__fill_1
XANTENNA__6429__A _3068_ VGND VGND VPWR VPWR sky130_fd_sc_hd__diode_2
XANTENNA__5816__C1 _2317_ VGND VGND VPWR VPWR sky130_fd_sc_hd__diode_2
XANTENNA__7959__S _3912_ VGND VGND VPWR VPWR sky130_fd_sc_hd__diode_2
XANTENNA__6863__S _3310_ VGND VGND VPWR VPWR sky130_fd_sc_hd__diode_2
XFILLER_0_98_466 VGND VGND VPWR VPWR sky130_fd_sc_hd__fill_2
XANTENNA_clkbuf_leaf_2_clk_A clknet_4_0_0_clk VGND VGND VPWR VPWR sky130_fd_sc_hd__diode_2
XFILLER_0_86_639 VGND VGND VPWR VPWR sky130_fd_sc_hd__fill_2
XFILLER_0_58_319 VGND VGND VPWR VPWR sky130_fd_sc_hd__fill_2
XFILLER_0_39_500 VGND VGND VPWR VPWR sky130_fd_sc_hd__fill_2
XPHY_EDGE_ROW_19_Right_19 VGND VGND VPWR VPWR sky130_fd_sc_hd__decap_3
XANTENNA__5595__A1 _1913_ VGND VGND VPWR VPWR sky130_fd_sc_hd__diode_2
XTAP_TAPCELL_ROW_55_973 VGND VPWR sky130_fd_sc_hd__tapvpwrvgnd_1
XFILLER_0_109_465 VGND VGND VPWR VPWR sky130_fd_sc_hd__decap_8
XFILLER_0_93_160 VGND VGND VPWR VPWR sky130_fd_sc_hd__fill_2
XFILLER_0_19_290 VGND VGND VPWR VPWR sky130_fd_sc_hd__fill_1
XFILLER_0_41_208 VGND VGND VPWR VPWR sky130_fd_sc_hd__fill_2
XANTENNA__8297__A0 _2985_ VGND VGND VPWR VPWR sky130_fd_sc_hd__diode_2
XFILLER_0_105_671 VGND VGND VPWR VPWR sky130_fd_sc_hd__fill_1
XFILLER_0_50_731 VGND VGND VPWR VPWR sky130_fd_sc_hd__fill_2
XFILLER_0_111_129 VGND VGND VPWR VPWR sky130_fd_sc_hd__fill_2
XFILLER_0_104_170 VGND VGND VPWR VPWR sky130_fd_sc_hd__fill_2
XTAP_TAPCELL_ROW_74_1227 VGND VPWR sky130_fd_sc_hd__tapvpwrvgnd_1
XTAP_TAPCELL_ROW_74_1216 VGND VPWR sky130_fd_sc_hd__tapvpwrvgnd_1
XPHY_EDGE_ROW_28_Right_28 VGND VGND VPWR VPWR sky130_fd_sc_hd__decap_3
XFILLER_0_22_488 VGND VGND VPWR VPWR sky130_fd_sc_hd__fill_2
XFILLER_0_118_23 VGND VGND VPWR VPWR sky130_fd_sc_hd__decap_4
XPHY_EDGE_ROW_37_Right_37 VGND VGND VPWR VPWR sky130_fd_sc_hd__decap_3
XFILLER_0_89_499 VGND VGND VPWR VPWR sky130_fd_sc_hd__fill_2
XFILLER_0_89_477 VGND VGND VPWR VPWR sky130_fd_sc_hd__decap_3
X_6840_ registers\[12\]\[15\] _2993_ _3299_ VGND VGND VPWR VPWR _3305_ sky130_fd_sc_hd__mux2_1
XANTENNA__5130__S0 _1883_ VGND VGND VPWR VPWR sky130_fd_sc_hd__diode_2
XTAP_TAPCELL_ROW_85_1367 VGND VPWR sky130_fd_sc_hd__tapvpwrvgnd_1
X_6771_ _3267_ VGND VGND VPWR VPWR _0872_ sky130_fd_sc_hd__clkbuf_1
X_5722_ _2352_ _2351_ VGND VGND VPWR VPWR _2455_ sky130_fd_sc_hd__or2_1
X_8510_ _4206_ VGND VGND VPWR VPWR _0648_ sky130_fd_sc_hd__clkbuf_1
XFILLER_0_9_449 VGND VGND VPWR VPWR sky130_fd_sc_hd__fill_2
XFILLER_0_18_728 VGND VGND VPWR VPWR sky130_fd_sc_hd__fill_2
XFILLER_0_85_683 VGND VGND VPWR VPWR sky130_fd_sc_hd__fill_2
XFILLER_0_72_300 VGND VGND VPWR VPWR sky130_fd_sc_hd__fill_2
X_9490_ clknet_leaf_66_clk _0587_ VGND VGND VPWR VPWR registers\[5\]\[18\] sky130_fd_sc_hd__dfxtp_1
XFILLER_0_45_514 VGND VGND VPWR VPWR sky130_fd_sc_hd__fill_2
XANTENNA__8524__A1 net30 VGND VGND VPWR VPWR sky130_fd_sc_hd__diode_2
XFILLER_0_115_413 VGND VGND VPWR VPWR sky130_fd_sc_hd__decap_8
X_8441_ registers\[8\]\[15\] net22 _4164_ VGND VGND VPWR VPWR _4170_ sky130_fd_sc_hd__mux2_1
X_5653_ _2217_ _2245_ _2387_ VGND VGND VPWR VPWR _2388_ sky130_fd_sc_hd__o21bai_1
XFILLER_0_5_611 VGND VGND VPWR VPWR sky130_fd_sc_hd__fill_1
XTAP_TAPCELL_ROW_33_689 VGND VPWR sky130_fd_sc_hd__tapvpwrvgnd_1
XFILLER_0_33_709 VGND VGND VPWR VPWR sky130_fd_sc_hd__fill_2
X_5584_ _2265_ _2278_ _2319_ VGND VGND VPWR VPWR _2320_ sky130_fd_sc_hd__or3b_1
X_8372_ _4133_ VGND VGND VPWR VPWR _0583_ sky130_fd_sc_hd__clkbuf_1
XFILLER_0_72_399 VGND VGND VPWR VPWR sky130_fd_sc_hd__decap_3
XPHY_EDGE_ROW_46_Right_46 VGND VGND VPWR VPWR sky130_fd_sc_hd__decap_3
XANTENNA__5433__S1 _2028_ VGND VGND VPWR VPWR sky130_fd_sc_hd__diode_2
XFILLER_0_4_132 VGND VGND VPWR VPWR sky130_fd_sc_hd__fill_2
X_4604_ _1362_ VGND VGND VPWR VPWR _1386_ sky130_fd_sc_hd__buf_4
XFILLER_0_32_208 VGND VGND VPWR VPWR sky130_fd_sc_hd__decap_8
XFILLER_0_103_608 VGND VGND VPWR VPWR sky130_fd_sc_hd__decap_3
XANTENNA__8288__A0 _2976_ VGND VGND VPWR VPWR sky130_fd_sc_hd__diode_2
X_4535_ _1201_ VGND VGND VPWR VPWR _1320_ sky130_fd_sc_hd__buf_4
X_7323_ _3577_ VGND VGND VPWR VPWR _0090_ sky130_fd_sc_hd__clkbuf_1
XANTENNA__6948__S _3361_ VGND VGND VPWR VPWR sky130_fd_sc_hd__diode_2
XFILLER_0_13_433 VGND VGND VPWR VPWR sky130_fd_sc_hd__decap_4
XFILLER_0_111_630 VGND VGND VPWR VPWR sky130_fd_sc_hd__fill_2
XANTENNA__6838__A1 _2991_ VGND VGND VPWR VPWR sky130_fd_sc_hd__diode_2
XFILLER_0_7_53 VGND VGND VPWR VPWR sky130_fd_sc_hd__decap_3
XANTENNA__5197__S0 _1757_ VGND VGND VPWR VPWR sky130_fd_sc_hd__diode_2
X_4466_ registers\[20\]\[11\] registers\[21\]\[11\] registers\[22\]\[11\] registers\[23\]\[11\]
+ _1197_ _1203_ VGND VGND VPWR VPWR _1255_ sky130_fd_sc_hd__mux4_1
XFILLER_0_111_652 VGND VGND VPWR VPWR sky130_fd_sc_hd__decap_3
X_7254_ registers\[18\]\[1\] _3437_ _3539_ VGND VGND VPWR VPWR _3541_ sky130_fd_sc_hd__mux2_1
XANTENNA__4468__S _1116_ VGND VGND VPWR VPWR sky130_fd_sc_hd__diode_2
XANTENNA__4944__S0 _1705_ VGND VGND VPWR VPWR sky130_fd_sc_hd__diode_2
X_4397_ _1188_ _1189_ _1117_ VGND VGND VPWR VPWR _1190_ sky130_fd_sc_hd__mux2_1
XFILLER_0_68_83 VGND VGND VPWR VPWR sky130_fd_sc_hd__fill_1
X_6205_ _2911_ _2907_ VGND VGND VPWR VPWR _2913_ sky130_fd_sc_hd__and2b_1
X_7185_ _3504_ VGND VGND VPWR VPWR _0025_ sky130_fd_sc_hd__clkbuf_1
X_6136_ _2422_ _2840_ _2847_ VGND VGND VPWR VPWR net65 sky130_fd_sc_hd__o21a_1
XTAP_TAPCELL_ROW_5_326 VGND VPWR sky130_fd_sc_hd__tapvpwrvgnd_1
XFILLER_0_0_393 VGND VGND VPWR VPWR sky130_fd_sc_hd__decap_4
XANTENNA__6683__S _3214_ VGND VGND VPWR VPWR sky130_fd_sc_hd__diode_2
XANTENNA__4992__A _1687_ VGND VGND VPWR VPWR sky130_fd_sc_hd__diode_2
XPHY_EDGE_ROW_55_Right_55 VGND VGND VPWR VPWR sky130_fd_sc_hd__decap_3
X_6067_ net126 _2781_ VGND VGND VPWR VPWR _2782_ sky130_fd_sc_hd__xnor2_1
X_5018_ _1741_ _1755_ _1770_ _1779_ VGND VGND VPWR VPWR _1780_ sky130_fd_sc_hd__a2bb2o_2
XFILLER_0_68_606 VGND VGND VPWR VPWR sky130_fd_sc_hd__decap_4
XANTENNA__5577__A1 _2267_ VGND VGND VPWR VPWR sky130_fd_sc_hd__diode_2
XANTENNA__5121__S0 _1806_ VGND VGND VPWR VPWR sky130_fd_sc_hd__diode_2
X_6969_ _3092_ registers\[14\]\[11\] _3372_ VGND VGND VPWR VPWR _3374_ sky130_fd_sc_hd__mux2_1
XTAP_TAPCELL_ROW_52_932 VGND VPWR sky130_fd_sc_hd__tapvpwrvgnd_1
X_8708_ clknet_leaf_29_clk _0829_ VGND VGND VPWR VPWR registers\[10\]\[4\] sky130_fd_sc_hd__dfxtp_1
XANTENNA__8515__A1 net25 VGND VGND VPWR VPWR sky130_fd_sc_hd__diode_2
XFILLER_0_106_413 VGND VGND VPWR VPWR sky130_fd_sc_hd__decap_4
XFILLER_0_91_664 VGND VGND VPWR VPWR sky130_fd_sc_hd__fill_2
XPHY_EDGE_ROW_64_Right_64 VGND VGND VPWR VPWR sky130_fd_sc_hd__decap_3
X_8639_ clknet_leaf_2_clk _0760_ VGND VGND VPWR VPWR registers\[29\]\[31\] sky130_fd_sc_hd__dfxtp_1
XFILLER_0_106_435 VGND VGND VPWR VPWR sky130_fd_sc_hd__fill_2
XFILLER_0_63_388 VGND VGND VPWR VPWR sky130_fd_sc_hd__fill_2
XFILLER_0_51_528 VGND VGND VPWR VPWR sky130_fd_sc_hd__decap_4
XANTENNA__5328__A _1968_ VGND VGND VPWR VPWR sky130_fd_sc_hd__diode_2
XFILLER_0_16_260 VGND VGND VPWR VPWR sky130_fd_sc_hd__fill_2
XANTENNA__7019__S _3398_ VGND VGND VPWR VPWR sky130_fd_sc_hd__diode_2
XFILLER_0_16_282 VGND VGND VPWR VPWR sky130_fd_sc_hd__fill_2
XPHY_EDGE_ROW_39_Left_159 VGND VGND VPWR VPWR sky130_fd_sc_hd__decap_3
XPHY_EDGE_ROW_2_Left_122 VGND VGND VPWR VPWR sky130_fd_sc_hd__decap_3
XANTENNA__5188__S0 _1748_ VGND VGND VPWR VPWR sky130_fd_sc_hd__diode_2
XFILLER_0_101_151 VGND VGND VPWR VPWR sky130_fd_sc_hd__decap_3
XANTENNA__7689__S _3768_ VGND VGND VPWR VPWR sky130_fd_sc_hd__diode_2
XPHY_EDGE_ROW_73_Right_73 VGND VGND VPWR VPWR sky130_fd_sc_hd__decap_3
XANTENNA__5998__A net89 VGND VGND VPWR VPWR sky130_fd_sc_hd__diode_2
XANTENNA__7254__A1 _3437_ VGND VGND VPWR VPWR sky130_fd_sc_hd__diode_2
XANTENNA__5360__S0 _1996_ VGND VGND VPWR VPWR sky130_fd_sc_hd__diode_2
XFILLER_0_59_617 VGND VGND VPWR VPWR sky130_fd_sc_hd__fill_2
XPHY_EDGE_ROW_48_Left_168 VGND VGND VPWR VPWR sky130_fd_sc_hd__decap_3
XANTENNA__5017__B1 _1778_ VGND VGND VPWR VPWR sky130_fd_sc_hd__diode_2
XFILLER_0_80_29 VGND VGND VPWR VPWR sky130_fd_sc_hd__decap_6
XFILLER_0_58_138 VGND VGND VPWR VPWR sky130_fd_sc_hd__fill_2
XANTENNA__5112__S0 _1798_ VGND VGND VPWR VPWR sky130_fd_sc_hd__diode_2
XFILLER_0_74_609 VGND VGND VPWR VPWR sky130_fd_sc_hd__decap_4
XFILLER_0_67_661 VGND VGND VPWR VPWR sky130_fd_sc_hd__decap_6
XFILLER_0_39_363 VGND VGND VPWR VPWR sky130_fd_sc_hd__decap_3
XFILLER_0_39_341 VGND VGND VPWR VPWR sky130_fd_sc_hd__fill_1
XPHY_EDGE_ROW_82_Right_82 VGND VGND VPWR VPWR sky130_fd_sc_hd__decap_3
XANTENNA__8313__S _4092_ VGND VGND VPWR VPWR sky130_fd_sc_hd__diode_2
XANTENNA__4633__A1_N _1372_ VGND VGND VPWR VPWR sky130_fd_sc_hd__diode_2
XFILLER_0_81_130 VGND VGND VPWR VPWR sky130_fd_sc_hd__fill_2
XFILLER_0_89_49 VGND VGND VPWR VPWR sky130_fd_sc_hd__decap_4
XFILLER_0_89_27 VGND VGND VPWR VPWR sky130_fd_sc_hd__decap_8
XTAP_TAPCELL_ROW_80_1297 VGND VPWR sky130_fd_sc_hd__tapvpwrvgnd_1
XANTENNA__5415__S1 _2073_ VGND VGND VPWR VPWR sky130_fd_sc_hd__diode_2
XTAP_TAPCELL_ROW_30_648 VGND VPWR sky130_fd_sc_hd__tapvpwrvgnd_1
XFILLER_0_81_185 VGND VGND VPWR VPWR sky130_fd_sc_hd__fill_2
XPHY_EDGE_ROW_57_Left_177 VGND VGND VPWR VPWR sky130_fd_sc_hd__decap_3
XFILLER_0_54_399 VGND VGND VPWR VPWR sky130_fd_sc_hd__fill_1
XFILLER_0_2_614 VGND VGND VPWR VPWR sky130_fd_sc_hd__fill_2
XANTENNA__5740__A1 _2460_ VGND VGND VPWR VPWR sky130_fd_sc_hd__diode_2
XANTENNA__6768__S _3261_ VGND VGND VPWR VPWR sky130_fd_sc_hd__diode_2
XFILLER_0_1_113 VPWR VGND VPWR VGND sky130_ef_sc_hd__decap_12
XTAP_TAPCELL_ROW_10_383 VGND VPWR sky130_fd_sc_hd__tapvpwrvgnd_1
XTAP_TAPCELL_ROW_10_394 VGND VPWR sky130_fd_sc_hd__tapvpwrvgnd_1
X_4320_ _1030_ VGND VGND VPWR VPWR _1116_ sky130_fd_sc_hd__buf_4
XANTENNA__5179__S0 _1763_ VGND VGND VPWR VPWR sky130_fd_sc_hd__diode_2
XFILLER_0_50_583 VGND VGND VPWR VPWR sky130_fd_sc_hd__fill_2
XFILLER_0_10_425 VGND VGND VPWR VPWR sky130_fd_sc_hd__decap_3
X_4251_ _1050_ VGND VGND VPWR VPWR _1051_ sky130_fd_sc_hd__buf_2
XFILLER_0_10_447 VGND VGND VPWR VPWR sky130_fd_sc_hd__fill_2
XPHY_EDGE_ROW_91_Right_91 VGND VGND VPWR VPWR sky130_fd_sc_hd__decap_3
XANTENNA__7599__S _3720_ VGND VGND VPWR VPWR sky130_fd_sc_hd__diode_2
XFILLER_0_38_97 VGND VGND VPWR VPWR sky130_fd_sc_hd__fill_2
XFILLER_0_38_75 VGND VGND VPWR VPWR sky130_fd_sc_hd__fill_2
X_8990_ clknet_leaf_97_clk _0087_ VGND VGND VPWR VPWR registers\[18\]\[30\] sky130_fd_sc_hd__dfxtp_1
XPHY_EDGE_ROW_66_Left_186 VGND VGND VPWR VPWR sky130_fd_sc_hd__decap_3
X_7941_ _3905_ VGND VGND VPWR VPWR _0380_ sky130_fd_sc_hd__clkbuf_1
XANTENNA__4317__A _1112_ VGND VGND VPWR VPWR sky130_fd_sc_hd__diode_2
X_7872_ _3075_ registers\[27\]\[3\] _3865_ VGND VGND VPWR VPWR _3869_ sky130_fd_sc_hd__mux2_1
XTAP_TAPCELL_ROW_38_759 VGND VPWR sky130_fd_sc_hd__tapvpwrvgnd_1
XTAP_TAPCELL_ROW_38_748 VGND VPWR sky130_fd_sc_hd__tapvpwrvgnd_1
XFILLER_0_77_447 VGND VGND VPWR VPWR sky130_fd_sc_hd__fill_1
XFILLER_0_54_85 VGND VGND VPWR VPWR sky130_fd_sc_hd__decap_4
XFILLER_0_49_116 VGND VGND VPWR VPWR sky130_fd_sc_hd__decap_3
XFILLER_0_92_417 VGND VGND VPWR VPWR sky130_fd_sc_hd__decap_3
X_6823_ registers\[12\]\[7\] _2976_ _3288_ VGND VGND VPWR VPWR _3296_ sky130_fd_sc_hd__mux2_1
XFILLER_0_77_458 VGND VGND VPWR VPWR sky130_fd_sc_hd__fill_2
XFILLER_0_9_202 VPWR VGND VPWR VGND sky130_ef_sc_hd__decap_12
XTAP_TAPCELL_ROW_18_494 VGND VPWR sky130_fd_sc_hd__tapvpwrvgnd_1
X_9542_ clknet_leaf_36_clk _0639_ VGND VGND VPWR VPWR registers\[4\]\[6\] sky130_fd_sc_hd__dfxtp_1
X_6754_ _3258_ VGND VGND VPWR VPWR _0864_ sky130_fd_sc_hd__clkbuf_1
XFILLER_0_58_672 VGND VGND VPWR VPWR sky130_fd_sc_hd__decap_6
XFILLER_0_9_246 VGND VGND VPWR VPWR sky130_fd_sc_hd__fill_2
XFILLER_0_18_514 VGND VGND VPWR VPWR sky130_fd_sc_hd__fill_2
X_6685_ registers\[10\]\[7\] _2976_ _3214_ VGND VGND VPWR VPWR _3222_ sky130_fd_sc_hd__mux2_1
X_5705_ net124 _2383_ VGND VGND VPWR VPWR _2438_ sky130_fd_sc_hd__or2_1
XFILLER_0_73_642 VGND VGND VPWR VPWR sky130_fd_sc_hd__fill_2
X_9473_ clknet_leaf_6_clk _0570_ VGND VGND VPWR VPWR registers\[5\]\[1\] sky130_fd_sc_hd__dfxtp_1
XFILLER_0_45_344 VGND VGND VPWR VPWR sky130_fd_sc_hd__fill_1
X_8424_ registers\[8\]\[7\] net45 _4153_ VGND VGND VPWR VPWR _4161_ sky130_fd_sc_hd__mux2_1
XTAP_TAPCELL_ROW_98_1536 VGND VPWR sky130_fd_sc_hd__tapvpwrvgnd_1
X_5636_ _2367_ _2370_ _1071_ VGND VGND VPWR VPWR _2371_ sky130_fd_sc_hd__mux2_1
XPHY_EDGE_ROW_75_Left_195 VGND VGND VPWR VPWR sky130_fd_sc_hd__decap_3
XFILLER_0_45_366 VGND VGND VPWR VPWR sky130_fd_sc_hd__fill_2
XFILLER_0_103_416 VGND VGND VPWR VPWR sky130_fd_sc_hd__fill_1
XFILLER_0_72_185 VGND VGND VPWR VPWR sky130_fd_sc_hd__decap_4
XFILLER_0_60_325 VGND VGND VPWR VPWR sky130_fd_sc_hd__decap_3
X_8355_ _4124_ VGND VGND VPWR VPWR _0575_ sky130_fd_sc_hd__clkbuf_1
XFILLER_0_103_449 VGND VGND VPWR VPWR sky130_fd_sc_hd__fill_2
XANTENNA__5731__A1 net138 VGND VGND VPWR VPWR sky130_fd_sc_hd__diode_2
X_5567_ _1051_ _2302_ VGND VGND VPWR VPWR _2303_ sky130_fd_sc_hd__nor2_1
XANTENNA__4987__A _1706_ VGND VGND VPWR VPWR sky130_fd_sc_hd__diode_2
XFILLER_0_41_561 VGND VGND VPWR VPWR sky130_fd_sc_hd__fill_2
XFILLER_0_13_252 VGND VGND VPWR VPWR sky130_fd_sc_hd__decap_4
X_4518_ registers\[28\]\[14\] registers\[29\]\[14\] registers\[30\]\[14\] registers\[31\]\[14\]
+ _1198_ _1199_ VGND VGND VPWR VPWR _1304_ sky130_fd_sc_hd__mux4_1
X_8286_ _2974_ registers\[31\]\[6\] _4081_ VGND VGND VPWR VPWR _4088_ sky130_fd_sc_hd__mux2_1
X_5498_ _2213_ VGND VGND VPWR VPWR _2234_ sky130_fd_sc_hd__buf_2
X_7306_ registers\[18\]\[26\] _3489_ _3561_ VGND VGND VPWR VPWR _3568_ sky130_fd_sc_hd__mux2_1
X_4449_ _1073_ _1231_ _1235_ _1239_ VGND VGND VPWR VPWR _1240_ sky130_fd_sc_hd__o22a_2
XFILLER_0_0_9 VGND VGND VPWR VPWR sky130_fd_sc_hd__fill_2
X_7237_ _3531_ VGND VGND VPWR VPWR _0050_ sky130_fd_sc_hd__clkbuf_1
XANTENNA__4393__S1 _1127_ VGND VGND VPWR VPWR sky130_fd_sc_hd__diode_2
XANTENNA__7236__A1 _3487_ VGND VGND VPWR VPWR sky130_fd_sc_hd__diode_2
X_7168_ _3492_ VGND VGND VPWR VPWR _0020_ sky130_fd_sc_hd__clkbuf_1
X_7099_ registers\[16\]\[5\] _3445_ _3435_ VGND VGND VPWR VPWR _3446_ sky130_fd_sc_hd__mux2_1
X_6119_ _2820_ _2805_ _2830_ VGND VGND VPWR VPWR _2831_ sky130_fd_sc_hd__and3b_1
XANTENNA__7302__S _3561_ VGND VGND VPWR VPWR sky130_fd_sc_hd__diode_2
XANTENNA__5342__S0 _2027_ VGND VGND VPWR VPWR sky130_fd_sc_hd__diode_2
XFILLER_0_68_414 VGND VGND VPWR VPWR sky130_fd_sc_hd__fill_2
XANTENNA__4227__A a2[1] VGND VGND VPWR VPWR sky130_fd_sc_hd__diode_2
XANTENNA__6426__B net12 VGND VGND VPWR VPWR sky130_fd_sc_hd__diode_2
XTAP_TAPCELL_ROW_107_1654 VGND VPWR sky130_fd_sc_hd__tapvpwrvgnd_1
XFILLER_0_68_425 VGND VGND VPWR VPWR sky130_fd_sc_hd__fill_1
XFILLER_0_83_439 VGND VGND VPWR VPWR sky130_fd_sc_hd__fill_2
XANTENNA__4758__C1 _1109_ VGND VGND VPWR VPWR sky130_fd_sc_hd__diode_2
XANTENNA__5970__A1 net124 VGND VGND VPWR VPWR sky130_fd_sc_hd__diode_2
XFILLER_0_64_631 VGND VGND VPWR VPWR sky130_fd_sc_hd__decap_3
XFILLER_0_48_182 VGND VGND VPWR VPWR sky130_fd_sc_hd__fill_1
XFILLER_0_119_593 VGND VGND VPWR VPWR sky130_fd_sc_hd__fill_2
XFILLER_0_64_697 VGND VGND VPWR VPWR sky130_fd_sc_hd__decap_3
XFILLER_0_63_163 VGND VGND VPWR VPWR sky130_fd_sc_hd__fill_2
XFILLER_0_63_152 VGND VGND VPWR VPWR sky130_fd_sc_hd__fill_1
XFILLER_0_51_314 VGND VGND VPWR VPWR sky130_fd_sc_hd__fill_2
XFILLER_0_91_483 VGND VGND VPWR VPWR sky130_fd_sc_hd__fill_2
XFILLER_0_63_196 VGND VGND VPWR VPWR sky130_fd_sc_hd__fill_1
XTAP_TAPCELL_ROW_58_1019 VGND VPWR sky130_fd_sc_hd__tapvpwrvgnd_1
XTAP_TAPCELL_ROW_58_1008 VGND VPWR sky130_fd_sc_hd__tapvpwrvgnd_1
XFILLER_0_51_358 VGND VGND VPWR VPWR sky130_fd_sc_hd__fill_2
XANTENNA__6588__S _3159_ VGND VGND VPWR VPWR sky130_fd_sc_hd__diode_2
XFILLER_0_32_561 VGND VGND VPWR VPWR sky130_fd_sc_hd__fill_2
XTAP_TAPCELL_ROW_118_1794 VGND VPWR sky130_fd_sc_hd__tapvpwrvgnd_1
XFILLER_0_32_594 VGND VGND VPWR VPWR sky130_fd_sc_hd__fill_2
XFILLER_0_102_482 VGND VGND VPWR VPWR sky130_fd_sc_hd__fill_2
XANTENNA__5521__A _2196_ VGND VGND VPWR VPWR sky130_fd_sc_hd__diode_2
XFILLER_0_99_561 VGND VGND VPWR VPWR sky130_fd_sc_hd__fill_2
XFILLER_0_99_550 VGND VGND VPWR VPWR sky130_fd_sc_hd__fill_1
XTAP_TAPCELL_ROW_69_1159 VGND VPWR sky130_fd_sc_hd__tapvpwrvgnd_1
XFILLER_0_115_35 VPWR VGND VPWR VGND sky130_ef_sc_hd__decap_12
XFILLER_0_99_594 VGND VGND VPWR VPWR sky130_fd_sc_hd__fill_2
XFILLER_0_24_33 VGND VGND VPWR VPWR sky130_fd_sc_hd__decap_3
XTAP_TAPCELL_ROW_35_718 VGND VPWR sky130_fd_sc_hd__tapvpwrvgnd_1
XFILLER_0_86_266 VGND VGND VPWR VPWR sky130_fd_sc_hd__fill_1
XFILLER_0_86_244 VGND VGND VPWR VPWR sky130_fd_sc_hd__fill_2
XTAP_TAPCELL_ROW_82_1326 VGND VPWR sky130_fd_sc_hd__tapvpwrvgnd_1
XFILLER_0_86_277 VGND VGND VPWR VPWR sky130_fd_sc_hd__fill_2
XANTENNA__4571__S _1140_ VGND VGND VPWR VPWR sky130_fd_sc_hd__diode_2
XTAP_TAPCELL_ROW_15_453 VGND VPWR sky130_fd_sc_hd__tapvpwrvgnd_1
XANTENNA__7882__S _3865_ VGND VGND VPWR VPWR sky130_fd_sc_hd__diode_2
XFILLER_0_55_686 VGND VGND VPWR VPWR sky130_fd_sc_hd__decap_4
XFILLER_0_40_21 VGND VGND VPWR VPWR sky130_fd_sc_hd__decap_4
X_6470_ _3096_ registers\[29\]\[13\] _3090_ VGND VGND VPWR VPWR _3097_ sky130_fd_sc_hd__mux2_1
XFILLER_0_70_645 VGND VGND VPWR VPWR sky130_fd_sc_hd__fill_2
XFILLER_0_54_185 VGND VGND VPWR VPWR sky130_fd_sc_hd__fill_2
XFILLER_0_42_336 VGND VGND VPWR VPWR sky130_fd_sc_hd__decap_4
XFILLER_0_15_539 VGND VGND VPWR VPWR sky130_fd_sc_hd__fill_2
XFILLER_0_112_213 VGND VGND VPWR VPWR sky130_fd_sc_hd__fill_2
XFILLER_0_70_678 VGND VGND VPWR VPWR sky130_fd_sc_hd__decap_6
X_5421_ registers\[8\]\[29\] registers\[9\]\[29\] registers\[10\]\[29\] registers\[11\]\[29\]
+ _2119_ _2120_ VGND VGND VPWR VPWR _2160_ sky130_fd_sc_hd__mux4_1
XANTENNA__6498__S _3111_ VGND VGND VPWR VPWR sky130_fd_sc_hd__diode_2
XFILLER_0_112_246 VGND VGND VPWR VPWR sky130_fd_sc_hd__decap_6
XANTENNA__7183__A _3502_ VGND VGND VPWR VPWR sky130_fd_sc_hd__diode_2
X_8140_ registers\[9\]\[1\] _3437_ _4009_ VGND VGND VPWR VPWR _4011_ sky130_fd_sc_hd__mux2_1
X_5352_ registers\[4\]\[25\] registers\[5\]\[25\] registers\[6\]\[25\] registers\[7\]\[25\]
+ _2020_ _2021_ VGND VGND VPWR VPWR _2095_ sky130_fd_sc_hd__mux4_1
XFILLER_0_23_561 VGND VGND VPWR VPWR sky130_fd_sc_hd__fill_1
XFILLER_0_23_572 VGND VGND VPWR VPWR sky130_fd_sc_hd__fill_2
XANTENNA__4600__A _1323_ VGND VGND VPWR VPWR sky130_fd_sc_hd__diode_2
XTAP_TAPCELL_ROW_93_1466 VGND VPWR sky130_fd_sc_hd__tapvpwrvgnd_1
X_4303_ registers\[0\]\[3\] registers\[1\]\[3\] registers\[2\]\[3\] registers\[3\]\[3\]
+ _1026_ _1027_ VGND VGND VPWR VPWR _1100_ sky130_fd_sc_hd__mux4_1
XFILLER_0_2_488 VGND VGND VPWR VPWR sky130_fd_sc_hd__fill_1
XFILLER_0_2_477 VGND VGND VPWR VPWR sky130_fd_sc_hd__fill_2
XFILLER_0_10_222 VGND VGND VPWR VPWR sky130_fd_sc_hd__fill_2
X_8071_ _3974_ VGND VGND VPWR VPWR _0441_ sky130_fd_sc_hd__clkbuf_1
X_7022_ _3402_ VGND VGND VPWR VPWR _0988_ sky130_fd_sc_hd__clkbuf_1
X_5283_ registers\[0\]\[21\] registers\[1\]\[21\] registers\[2\]\[21\] registers\[3\]\[21\]
+ _2027_ _2028_ VGND VGND VPWR VPWR _2030_ sky130_fd_sc_hd__mux4_1
XANTENNA__4375__S1 _1168_ VGND VGND VPWR VPWR sky130_fd_sc_hd__diode_2
X_4234_ net7 VGND VGND VPWR VPWR _1034_ sky130_fd_sc_hd__buf_4
XANTENNA__8218__S _4045_ VGND VGND VPWR VPWR sky130_fd_sc_hd__diode_2
XFILLER_0_4_65 VGND VGND VPWR VPWR sky130_fd_sc_hd__fill_1
XFILLER_0_4_54 VGND VGND VPWR VPWR sky130_fd_sc_hd__fill_1
XANTENNA__4746__S _1421_ VGND VGND VPWR VPWR sky130_fd_sc_hd__diode_2
XANTENNA__6527__A net13 VGND VGND VPWR VPWR sky130_fd_sc_hd__diode_2
XANTENNA__5324__S0 _2020_ VGND VGND VPWR VPWR sky130_fd_sc_hd__diode_2
X_8973_ clknet_leaf_57_clk _0070_ VGND VGND VPWR VPWR registers\[18\]\[13\] sky130_fd_sc_hd__dfxtp_1
XFILLER_0_78_701 VGND VGND VPWR VPWR sky130_fd_sc_hd__fill_2
X_7924_ _3127_ registers\[27\]\[28\] _3887_ VGND VGND VPWR VPWR _3896_ sky130_fd_sc_hd__mux2_1
XFILLER_0_77_233 VGND VGND VPWR VPWR sky130_fd_sc_hd__fill_1
X_7855_ _3859_ VGND VGND VPWR VPWR _0340_ sky130_fd_sc_hd__clkbuf_1
XANTENNA_clkbuf_leaf_42_clk_A clknet_4_6_0_clk VGND VGND VPWR VPWR sky130_fd_sc_hd__diode_2
XFILLER_0_81_94 VGND VGND VPWR VPWR sky130_fd_sc_hd__fill_2
X_6806_ net13 net12 net11 VGND VGND VPWR VPWR _3286_ sky130_fd_sc_hd__and3b_1
XPHY_EDGE_ROW_83_Left_203 VGND VGND VPWR VPWR sky130_fd_sc_hd__decap_3
X_4998_ _1759_ VGND VGND VPWR VPWR _1760_ sky130_fd_sc_hd__buf_6
X_7786_ _3125_ registers\[25\]\[27\] _3815_ VGND VGND VPWR VPWR _3823_ sky130_fd_sc_hd__mux2_1
X_9525_ clknet_leaf_83_clk _0622_ VGND VGND VPWR VPWR registers\[8\]\[21\] sky130_fd_sc_hd__dfxtp_1
XTAP_TAPCELL_ROW_102_1584 VGND VPWR sky130_fd_sc_hd__tapvpwrvgnd_1
XANTENNA__5952__A1 _2399_ VGND VGND VPWR VPWR sky130_fd_sc_hd__diode_2
XANTENNA__5952__B2 _2560_ VGND VGND VPWR VPWR sky130_fd_sc_hd__diode_2
X_6737_ _2960_ _3210_ VGND VGND VPWR VPWR _3249_ sky130_fd_sc_hd__nor2_2
XANTENNA__7792__S _3792_ VGND VGND VPWR VPWR sky130_fd_sc_hd__diode_2
X_9456_ clknet_leaf_64_clk _0553_ VGND VGND VPWR VPWR registers\[31\]\[16\] sky130_fd_sc_hd__dfxtp_1
X_6668_ net9 _3211_ VGND VGND VPWR VPWR _3212_ sky130_fd_sc_hd__or2_2
X_9387_ clknet_leaf_53_clk _0484_ VGND VGND VPWR VPWR registers\[9\]\[11\] sky130_fd_sc_hd__dfxtp_1
XANTENNA_clkbuf_leaf_57_clk_A clknet_4_15_0_clk VGND VGND VPWR VPWR sky130_fd_sc_hd__diode_2
X_5619_ _2348_ _2351_ _2353_ VGND VGND VPWR VPWR _2354_ sky130_fd_sc_hd__mux2_1
XFILLER_0_61_689 VGND VGND VPWR VPWR sky130_fd_sc_hd__fill_1
XFILLER_0_61_667 VGND VGND VPWR VPWR sky130_fd_sc_hd__fill_2
X_6599_ _3174_ VGND VGND VPWR VPWR _3175_ sky130_fd_sc_hd__clkbuf_8
X_8407_ _4151_ VGND VGND VPWR VPWR _0600_ sky130_fd_sc_hd__clkbuf_1
XFILLER_0_14_550 VGND VGND VPWR VPWR sky130_fd_sc_hd__fill_1
XANTENNA__4510__A _1124_ VGND VGND VPWR VPWR sky130_fd_sc_hd__diode_2
XANTENNA_clkbuf_leaf_100_clk_A clknet_4_2_0_clk VGND VGND VPWR VPWR sky130_fd_sc_hd__diode_2
X_8338_ _3026_ registers\[31\]\[31\] _4080_ VGND VGND VPWR VPWR _4115_ sky130_fd_sc_hd__mux2_1
XFILLER_0_103_279 VGND VGND VPWR VPWR sky130_fd_sc_hd__fill_1
XPHY_EDGE_ROW_92_Left_212 VGND VGND VPWR VPWR sky130_fd_sc_hd__decap_3
X_8269_ _4078_ VGND VGND VPWR VPWR _0535_ sky130_fd_sc_hd__clkbuf_1
XANTENNA__8128__S _3995_ VGND VGND VPWR VPWR sky130_fd_sc_hd__diode_2
XANTENNA__5341__A _2084_ VGND VGND VPWR VPWR sky130_fd_sc_hd__diode_2
XANTENNA__7967__S _3912_ VGND VGND VPWR VPWR sky130_fd_sc_hd__diode_2
XANTENNA__5315__S0 _1798_ VGND VGND VPWR VPWR sky130_fd_sc_hd__diode_2
XFILLER_0_68_222 VGND VGND VPWR VPWR sky130_fd_sc_hd__decap_4
XANTENNA__6871__S _3287_ VGND VGND VPWR VPWR sky130_fd_sc_hd__diode_2
XFILLER_0_96_553 VGND VGND VPWR VPWR sky130_fd_sc_hd__decap_8
XFILLER_0_96_597 VGND VGND VPWR VPWR sky130_fd_sc_hd__fill_2
XFILLER_0_96_586 VGND VGND VPWR VPWR sky130_fd_sc_hd__fill_2
XFILLER_0_83_225 VGND VGND VPWR VPWR sky130_fd_sc_hd__decap_4
XFILLER_0_83_203 VGND VGND VPWR VPWR sky130_fd_sc_hd__fill_2
XFILLER_0_83_236 VGND VGND VPWR VPWR sky130_fd_sc_hd__decap_6
XTAP_TAPCELL_ROW_64_1089 VGND VPWR sky130_fd_sc_hd__tapvpwrvgnd_1
XFILLER_0_83_269 VGND VGND VPWR VPWR sky130_fd_sc_hd__decap_4
XFILLER_0_64_450 VGND VGND VPWR VPWR sky130_fd_sc_hd__fill_1
XTAP_TAPCELL_ROW_12_412 VGND VPWR sky130_fd_sc_hd__tapvpwrvgnd_1
XFILLER_0_36_141 VGND VGND VPWR VPWR sky130_fd_sc_hd__decap_3
XFILLER_0_51_111 VGND VGND VPWR VPWR sky130_fd_sc_hd__fill_1
XTAP_TAPCELL_ROW_40_776 VGND VPWR sky130_fd_sc_hd__tapvpwrvgnd_1
XFILLER_0_24_325 VGND VGND VPWR VPWR sky130_fd_sc_hd__fill_2
XFILLER_0_101_26 VGND VGND VPWR VPWR sky130_fd_sc_hd__decap_6
XANTENNA__7207__S _3514_ VGND VGND VPWR VPWR sky130_fd_sc_hd__diode_2
XPHY_EDGE_ROW_108_Right_108 VGND VGND VPWR VPWR sky130_fd_sc_hd__decap_3
XANTENNA__5950__S _2490_ VGND VGND VPWR VPWR sky130_fd_sc_hd__diode_2
XANTENNA__6347__A net37 VGND VGND VPWR VPWR sky130_fd_sc_hd__diode_2
XFILLER_0_19_99 VGND VGND VPWR VPWR sky130_fd_sc_hd__fill_2
XFILLER_0_79_509 VGND VGND VPWR VPWR sky130_fd_sc_hd__decap_3
XFILLER_0_35_21 VGND VGND VPWR VPWR sky130_fd_sc_hd__decap_3
X_5970_ net124 _2688_ _2689_ VGND VGND VPWR VPWR _2690_ sky130_fd_sc_hd__o21ai_1
XFILLER_0_99_391 VGND VGND VPWR VPWR sky130_fd_sc_hd__fill_1
XFILLER_0_59_200 VGND VGND VPWR VPWR sky130_fd_sc_hd__fill_2
XTAP_TAPCELL_ROW_48_887 VGND VPWR sky130_fd_sc_hd__tapvpwrvgnd_1
XANTENNA__6781__S _3272_ VGND VGND VPWR VPWR sky130_fd_sc_hd__diode_2
XFILLER_0_35_65 VGND VGND VPWR VPWR sky130_fd_sc_hd__fill_2
X_4921_ _1684_ _1685_ _1682_ VGND VGND VPWR VPWR _1686_ sky130_fd_sc_hd__mux2_1
XFILLER_0_59_255 VGND VGND VPWR VPWR sky130_fd_sc_hd__fill_2
XFILLER_0_59_244 VGND VGND VPWR VPWR sky130_fd_sc_hd__decap_4
XFILLER_0_87_575 VGND VGND VPWR VPWR sky130_fd_sc_hd__fill_2
XFILLER_0_75_726 VGND VGND VPWR VPWR sky130_fd_sc_hd__fill_2
XFILLER_0_47_406 VGND VGND VPWR VPWR sky130_fd_sc_hd__fill_1
X_4852_ registers\[16\]\[0\] registers\[17\]\[0\] registers\[18\]\[0\] registers\[19\]\[0\]
+ _1617_ _1618_ VGND VGND VPWR VPWR _1620_ sky130_fd_sc_hd__mux4_1
X_7640_ _3745_ VGND VGND VPWR VPWR _0239_ sky130_fd_sc_hd__clkbuf_1
XANTENNA__7178__A net40 VGND VGND VPWR VPWR sky130_fd_sc_hd__diode_2
XFILLER_0_51_53 VGND VGND VPWR VPWR sky130_fd_sc_hd__decap_3
XFILLER_0_7_514 VGND VGND VPWR VPWR sky130_fd_sc_hd__decap_3
XFILLER_0_7_536 VGND VGND VPWR VPWR sky130_fd_sc_hd__fill_2
X_4783_ _1347_ VGND VGND VPWR VPWR _1555_ sky130_fd_sc_hd__buf_4
X_7571_ _3115_ registers\[22\]\[22\] _3706_ VGND VGND VPWR VPWR _3709_ sky130_fd_sc_hd__mux2_1
XANTENNA__8501__S _4200_ VGND VGND VPWR VPWR sky130_fd_sc_hd__diode_2
X_9310_ clknet_leaf_97_clk _0407_ VGND VGND VPWR VPWR registers\[28\]\[30\] sky130_fd_sc_hd__dfxtp_1
X_6522_ _3131_ registers\[29\]\[30\] _3068_ VGND VGND VPWR VPWR _3132_ sky130_fd_sc_hd__mux2_1
X_6453_ net46 VGND VGND VPWR VPWR _3085_ sky130_fd_sc_hd__clkbuf_2
XFILLER_0_70_464 VGND VGND VPWR VPWR sky130_fd_sc_hd__fill_2
X_9241_ clknet_leaf_80_clk _0338_ VGND VGND VPWR VPWR registers\[26\]\[25\] sky130_fd_sc_hd__dfxtp_1
XFILLER_0_113_555 VGND VGND VPWR VPWR sky130_fd_sc_hd__fill_2
XANTENNA__4330__A _1125_ VGND VGND VPWR VPWR sky130_fd_sc_hd__diode_2
Xclkload40 clknet_leaf_19_clk VGND VGND VPWR VPWR clkload40/Y sky130_fd_sc_hd__clkinv_1
Xclkload51 clknet_leaf_16_clk VGND VGND VPWR VPWR clkload51/Y sky130_fd_sc_hd__bufinv_16
XFILLER_0_42_166 VGND VGND VPWR VPWR sky130_fd_sc_hd__decap_3
Xclkload62 clknet_leaf_87_clk VGND VGND VPWR VPWR clkload62/Y sky130_fd_sc_hd__clkinv_1
X_5404_ registers\[12\]\[28\] registers\[13\]\[28\] registers\[14\]\[28\] registers\[15\]\[28\]
+ _2072_ _2073_ VGND VGND VPWR VPWR _2144_ sky130_fd_sc_hd__mux4_1
X_9172_ clknet_leaf_74_clk _0269_ VGND VGND VPWR VPWR registers\[24\]\[20\] sky130_fd_sc_hd__dfxtp_1
Xclkload95 clknet_leaf_53_clk VGND VGND VPWR VPWR clkload95/Y sky130_fd_sc_hd__clkinv_1
XANTENNA__5208__A1_N _1741_ VGND VGND VPWR VPWR sky130_fd_sc_hd__diode_2
X_6384_ registers\[3\]\[12\] _2987_ _3041_ VGND VGND VPWR VPWR _3044_ sky130_fd_sc_hd__mux2_1
Xclkload84 clknet_leaf_71_clk VGND VGND VPWR VPWR clkload84/Y sky130_fd_sc_hd__bufinv_16
X_8123_ _4001_ VGND VGND VPWR VPWR _0466_ sky130_fd_sc_hd__clkbuf_1
XANTENNA__7439__A1 _3485_ VGND VGND VPWR VPWR sky130_fd_sc_hd__diode_2
Xclkload73 clknet_leaf_98_clk VGND VGND VPWR VPWR clkload73/Y sky130_fd_sc_hd__bufinv_16
XFILLER_0_100_238 VGND VGND VPWR VPWR sky130_fd_sc_hd__fill_2
XANTENNA__4370__B1 _1143_ VGND VGND VPWR VPWR sky130_fd_sc_hd__diode_2
XANTENNA__6956__S _3361_ VGND VGND VPWR VPWR sky130_fd_sc_hd__diode_2
X_5335_ registers\[4\]\[24\] registers\[5\]\[24\] registers\[6\]\[24\] registers\[7\]\[24\]
+ _2072_ _2073_ VGND VGND VPWR VPWR _2079_ sky130_fd_sc_hd__mux4_1
XFILLER_0_11_575 VGND VGND VPWR VPWR sky130_fd_sc_hd__decap_4
X_8054_ registers\[2\]\[25\] _3487_ _3959_ VGND VGND VPWR VPWR _3965_ sky130_fd_sc_hd__mux2_1
X_5266_ registers\[16\]\[21\] registers\[17\]\[21\] registers\[18\]\[21\] registers\[19\]\[21\]
+ _1968_ _1969_ VGND VGND VPWR VPWR _2013_ sky130_fd_sc_hd__mux4_1
X_7005_ _3392_ VGND VGND VPWR VPWR _0981_ sky130_fd_sc_hd__clkbuf_1
X_5197_ registers\[24\]\[17\] registers\[25\]\[17\] registers\[26\]\[17\] registers\[27\]\[17\]
+ _1757_ _1814_ VGND VGND VPWR VPWR _1948_ sky130_fd_sc_hd__mux4_1
X_8956_ clknet_leaf_104_clk _0053_ VGND VGND VPWR VPWR registers\[17\]\[28\] sky130_fd_sc_hd__dfxtp_1
XTAP_TAPCELL_ROW_104_1613 VGND VPWR sky130_fd_sc_hd__tapvpwrvgnd_1
XFILLER_0_92_82 VGND VGND VPWR VPWR sky130_fd_sc_hd__fill_2
X_7907_ _3864_ VGND VGND VPWR VPWR _3887_ sky130_fd_sc_hd__clkbuf_8
X_8887_ clknet_leaf_71_clk _1008_ VGND VGND VPWR VPWR registers\[15\]\[23\] sky130_fd_sc_hd__dfxtp_1
XFILLER_0_108_305 VGND VGND VPWR VPWR sky130_fd_sc_hd__decap_3
X_7838_ _3850_ VGND VGND VPWR VPWR _0332_ sky130_fd_sc_hd__clkbuf_1
XFILLER_0_81_729 VGND VGND VPWR VPWR sky130_fd_sc_hd__fill_1
XFILLER_0_80_206 VGND VGND VPWR VPWR sky130_fd_sc_hd__decap_4
X_7769_ _3108_ registers\[25\]\[19\] _3804_ VGND VGND VPWR VPWR _3814_ sky130_fd_sc_hd__mux2_1
XFILLER_0_18_141 VGND VGND VPWR VPWR sky130_fd_sc_hd__decap_4
X_9508_ clknet_leaf_30_clk _0605_ VGND VGND VPWR VPWR registers\[8\]\[4\] sky130_fd_sc_hd__dfxtp_1
XFILLER_0_80_228 VGND VGND VPWR VPWR sky130_fd_sc_hd__fill_2
XFILLER_0_46_494 VGND VGND VPWR VPWR sky130_fd_sc_hd__fill_1
XFILLER_0_46_483 VGND VGND VPWR VPWR sky130_fd_sc_hd__fill_2
XFILLER_0_18_185 VGND VGND VPWR VPWR sky130_fd_sc_hd__fill_2
Xclkload1 clknet_4_2_0_clk VGND VGND VPWR VPWR clkload1/Y sky130_fd_sc_hd__inv_6
XFILLER_0_34_645 VGND VGND VPWR VPWR sky130_fd_sc_hd__fill_2
XFILLER_0_34_634 VGND VGND VPWR VPWR sky130_fd_sc_hd__fill_2
XANTENNA__7678__A1 _3451_ VGND VGND VPWR VPWR sky130_fd_sc_hd__diode_2
XFILLER_0_61_453 VGND VGND VPWR VPWR sky130_fd_sc_hd__decap_3
XFILLER_0_61_431 VPWR VGND VPWR VGND sky130_ef_sc_hd__decap_12
X_9439_ clknet_leaf_99_clk _0536_ VGND VGND VPWR VPWR registers\[6\]\[31\] sky130_fd_sc_hd__dfxtp_1
XFILLER_0_116_393 VGND VGND VPWR VPWR sky130_fd_sc_hd__decap_8
XANTENNA__7027__S _3398_ VGND VGND VPWR VPWR sky130_fd_sc_hd__diode_2
XFILLER_0_104_555 VGND VGND VPWR VPWR sky130_fd_sc_hd__fill_2
XANTENNA__5689__B1 _2394_ VGND VGND VPWR VPWR sky130_fd_sc_hd__diode_2
XANTENNA__4240__A a2[1] VGND VGND VPWR VPWR sky130_fd_sc_hd__diode_2
XTAP_TAPCELL_ROW_115_1753 VGND VPWR sky130_fd_sc_hd__tapvpwrvgnd_1
XANTENNA_input39_A wd3[30] VGND VGND VPWR VPWR sky130_fd_sc_hd__diode_2
XANTENNA__7697__S _3768_ VGND VGND VPWR VPWR sky130_fd_sc_hd__diode_2
XTAP_TAPCELL_ROW_66_1118 VGND VPWR sky130_fd_sc_hd__tapvpwrvgnd_1
XFILLER_0_69_531 VGND VGND VPWR VPWR sky130_fd_sc_hd__fill_1
XTAP_TAPCELL_ROW_45_846 VGND VPWR sky130_fd_sc_hd__tapvpwrvgnd_1
XFILLER_0_96_372 VGND VGND VPWR VPWR sky130_fd_sc_hd__fill_2
XANTENNA__4511__S1 _1199_ VGND VGND VPWR VPWR sky130_fd_sc_hd__diode_2
XANTENNA__6169__B2 _2429_ VGND VGND VPWR VPWR sky130_fd_sc_hd__diode_2
XFILLER_0_56_247 VGND VGND VPWR VPWR sky130_fd_sc_hd__decap_3
XFILLER_0_112_14 VGND VGND VPWR VPWR sky130_fd_sc_hd__fill_2
XFILLER_0_56_269 VGND VGND VPWR VPWR sky130_fd_sc_hd__fill_2
XTAP_TAPCELL_ROW_25_581 VGND VPWR sky130_fd_sc_hd__tapvpwrvgnd_1
XFILLER_0_71_217 VGND VGND VPWR VPWR sky130_fd_sc_hd__fill_1
XFILLER_0_21_23 VGND VGND VPWR VPWR sky130_fd_sc_hd__decap_3
XFILLER_0_4_528 VGND VGND VPWR VPWR sky130_fd_sc_hd__fill_2
XFILLER_0_21_89 VGND VGND VPWR VPWR sky130_fd_sc_hd__decap_4
XFILLER_0_40_626 VGND VGND VPWR VPWR sky130_fd_sc_hd__fill_2
XFILLER_0_12_317 VGND VGND VPWR VPWR sky130_fd_sc_hd__decap_4
XANTENNA__4578__S1 _1135_ VGND VGND VPWR VPWR sky130_fd_sc_hd__diode_2
XTAP_TAPCELL_ROW_77_1258 VGND VPWR sky130_fd_sc_hd__tapvpwrvgnd_1
XFILLER_0_0_701 VPWR VGND VPWR VGND sky130_ef_sc_hd__decap_12
XANTENNA__5680__S net135 VGND VGND VPWR VPWR sky130_fd_sc_hd__diode_2
XTAP_TAPCELL_ROW_90_1425 VGND VPWR sky130_fd_sc_hd__tapvpwrvgnd_1
XANTENNA__6776__S _3261_ VGND VGND VPWR VPWR sky130_fd_sc_hd__diode_2
X_5120_ _1874_ _1875_ _1767_ VGND VGND VPWR VPWR _1876_ sky130_fd_sc_hd__mux2_1
XFILLER_0_20_372 VGND VGND VPWR VPWR sky130_fd_sc_hd__decap_3
X_5051_ _1706_ VGND VGND VPWR VPWR _1811_ sky130_fd_sc_hd__buf_4
XANTENNA__4296__S _1030_ VGND VGND VPWR VPWR sky130_fd_sc_hd__diode_2
XFILLER_0_46_20 VGND VGND VPWR VPWR sky130_fd_sc_hd__fill_2
X_8810_ clknet_leaf_37_clk _0931_ VGND VGND VPWR VPWR registers\[13\]\[10\] sky130_fd_sc_hd__dfxtp_1
X_8741_ clknet_leaf_31_clk _0862_ VGND VGND VPWR VPWR registers\[11\]\[5\] sky130_fd_sc_hd__dfxtp_1
XFILLER_0_94_309 VGND VGND VPWR VPWR sky130_fd_sc_hd__fill_2
XTAP_TAPCELL_ROW_88_1398 VGND VPWR sky130_fd_sc_hd__tapvpwrvgnd_1
XFILLER_0_1_55 VGND VGND VPWR VPWR sky130_fd_sc_hd__fill_1
XFILLER_0_87_361 VGND VGND VPWR VPWR sky130_fd_sc_hd__fill_2
X_5953_ _2330_ _2334_ VGND VGND VPWR VPWR _2674_ sky130_fd_sc_hd__and2_1
XANTENNA__6016__S _2460_ VGND VGND VPWR VPWR sky130_fd_sc_hd__diode_2
XANTENNA_clkbuf_4_5_0_clk_A clknet_0_clk VGND VGND VPWR VPWR sky130_fd_sc_hd__diode_2
X_5884_ _2399_ _2602_ _2605_ _2609_ VGND VGND VPWR VPWR net50 sky130_fd_sc_hd__o22a_1
XFILLER_0_87_383 VGND VGND VPWR VPWR sky130_fd_sc_hd__fill_2
XFILLER_0_75_556 VGND VGND VPWR VPWR sky130_fd_sc_hd__fill_2
XFILLER_0_75_534 VGND VGND VPWR VPWR sky130_fd_sc_hd__fill_1
X_8672_ clknet_leaf_9_clk _0793_ VGND VGND VPWR VPWR registers\[0\]\[0\] sky130_fd_sc_hd__dfxtp_1
X_4904_ registers\[0\]\[2\] registers\[1\]\[2\] registers\[2\]\[2\] registers\[3\]\[2\]
+ _1642_ _1643_ VGND VGND VPWR VPWR _1670_ sky130_fd_sc_hd__mux4_1
X_7623_ _3736_ VGND VGND VPWR VPWR _0231_ sky130_fd_sc_hd__clkbuf_1
XFILLER_0_117_113 VGND VGND VPWR VPWR sky130_fd_sc_hd__fill_1
X_4835_ registers\[28\]\[31\] registers\[29\]\[31\] registers\[30\]\[31\] registers\[31\]\[31\]
+ _1555_ _1556_ VGND VGND VPWR VPWR _1604_ sky130_fd_sc_hd__mux4_1
XFILLER_0_118_669 VPWR VGND VPWR VGND sky130_ef_sc_hd__decap_12
X_7554_ _3098_ registers\[22\]\[14\] _3695_ VGND VGND VPWR VPWR _3700_ sky130_fd_sc_hd__mux2_1
XANTENNA__5855__S _2344_ VGND VGND VPWR VPWR sky130_fd_sc_hd__diode_2
XFILLER_0_90_537 VGND VGND VPWR VPWR sky130_fd_sc_hd__fill_2
XANTENNA__8231__S _4056_ VGND VGND VPWR VPWR sky130_fd_sc_hd__diode_2
XFILLER_0_16_612 VGND VGND VPWR VPWR sky130_fd_sc_hd__fill_2
X_4766_ _1537_ _1538_ _1346_ VGND VGND VPWR VPWR _1539_ sky130_fd_sc_hd__mux2_1
XFILLER_0_43_453 VGND VGND VPWR VPWR sky130_fd_sc_hd__decap_4
X_6505_ _3120_ VGND VGND VPWR VPWR _0753_ sky130_fd_sc_hd__clkbuf_1
XFILLER_0_16_645 VGND VGND VPWR VPWR sky130_fd_sc_hd__fill_2
X_7485_ _3663_ VGND VGND VPWR VPWR _0166_ sky130_fd_sc_hd__clkbuf_1
XFILLER_0_70_250 VGND VGND VPWR VPWR sky130_fd_sc_hd__fill_2
X_4697_ _1472_ _1473_ _1344_ VGND VGND VPWR VPWR _1474_ sky130_fd_sc_hd__mux2_1
XFILLER_0_15_166 VGND VGND VPWR VPWR sky130_fd_sc_hd__fill_2
XFILLER_0_101_503 VGND VGND VPWR VPWR sky130_fd_sc_hd__fill_1
XANTENNA__4569__S1 _1128_ VGND VGND VPWR VPWR sky130_fd_sc_hd__diode_2
X_9224_ clknet_leaf_20_clk _0321_ VGND VGND VPWR VPWR registers\[26\]\[8\] sky130_fd_sc_hd__dfxtp_1
X_6436_ _3073_ registers\[29\]\[2\] _3069_ VGND VGND VPWR VPWR _3074_ sky130_fd_sc_hd__mux2_1
X_6367_ registers\[3\]\[4\] _2970_ _3030_ VGND VGND VPWR VPWR _3035_ sky130_fd_sc_hd__mux2_1
XFILLER_0_101_525 VGND VGND VPWR VPWR sky130_fd_sc_hd__fill_2
XANTENNA__4995__A _1731_ VGND VGND VPWR VPWR sky130_fd_sc_hd__diode_2
X_9155_ clknet_leaf_19_clk _0252_ VGND VGND VPWR VPWR registers\[24\]\[3\] sky130_fd_sc_hd__dfxtp_1
XFILLER_0_11_350 VGND VGND VPWR VPWR sky130_fd_sc_hd__decap_4
X_8106_ _3992_ VGND VGND VPWR VPWR _0458_ sky130_fd_sc_hd__clkbuf_1
X_5318_ _2057_ _2059_ _2062_ _1701_ _1702_ VGND VGND VPWR VPWR _2063_ sky130_fd_sc_hd__a221o_1
X_6298_ net20 VGND VGND VPWR VPWR _2989_ sky130_fd_sc_hd__buf_2
X_9086_ clknet_leaf_96_clk _0183_ VGND VGND VPWR VPWR registers\[21\]\[30\] sky130_fd_sc_hd__dfxtp_1
XTAP_TAPCELL_ROW_110_1683 VGND VPWR sky130_fd_sc_hd__tapvpwrvgnd_1
X_8037_ registers\[2\]\[17\] _3470_ _3948_ VGND VGND VPWR VPWR _3956_ sky130_fd_sc_hd__mux2_1
X_5249_ _1775_ VGND VGND VPWR VPWR _1997_ sky130_fd_sc_hd__buf_4
XTAP_TAPCELL_ROW_110_1694 VGND VPWR sky130_fd_sc_hd__tapvpwrvgnd_1
XANTENNA__7310__S _3561_ VGND VGND VPWR VPWR sky130_fd_sc_hd__diode_2
XTAP_TAPCELL_ROW_3_298 VGND VPWR sky130_fd_sc_hd__tapvpwrvgnd_1
X_8939_ clknet_4_15_0_clk _0036_ VGND VGND VPWR VPWR registers\[17\]\[11\] sky130_fd_sc_hd__dfxtp_1
XANTENNA__5071__A1 _1809_ VGND VGND VPWR VPWR sky130_fd_sc_hd__diode_2
XFILLER_0_39_726 VGND VGND VPWR VPWR sky130_fd_sc_hd__fill_2
XTAP_TAPCELL_ROW_42_805 VGND VPWR sky130_fd_sc_hd__tapvpwrvgnd_1
XFILLER_0_109_647 VGND VGND VPWR VPWR sky130_fd_sc_hd__decap_6
XTAP_TAPCELL_ROW_61_1048 VGND VPWR sky130_fd_sc_hd__tapvpwrvgnd_1
XFILLER_0_81_537 VGND VGND VPWR VPWR sky130_fd_sc_hd__decap_8
XANTENNA__4257__S0 _1053_ VGND VGND VPWR VPWR sky130_fd_sc_hd__diode_2
XFILLER_0_19_494 VGND VGND VPWR VPWR sky130_fd_sc_hd__fill_2
XTAP_TAPCELL_ROW_22_540 VGND VPWR sky130_fd_sc_hd__tapvpwrvgnd_1
XTAP_TAPCELL_ROW_22_551 VGND VPWR sky130_fd_sc_hd__tapvpwrvgnd_1
XFILLER_0_81_559 VGND VGND VPWR VPWR sky130_fd_sc_hd__fill_1
XFILLER_0_104_330 VGND VGND VPWR VPWR sky130_fd_sc_hd__fill_2
XANTENNA__7980__S _3923_ VGND VGND VPWR VPWR sky130_fd_sc_hd__diode_2
XTAP_TAPCELL_ROW_72_1199 VGND VPWR sky130_fd_sc_hd__tapvpwrvgnd_1
XFILLER_0_107_25 VGND VGND VPWR VPWR sky130_fd_sc_hd__fill_1
XANTENNA__7587__A0 _3131_ VGND VGND VPWR VPWR sky130_fd_sc_hd__diode_2
XANTENNA__8316__S _4103_ VGND VGND VPWR VPWR sky130_fd_sc_hd__diode_2
XANTENNA__4844__S _1513_ VGND VGND VPWR VPWR sky130_fd_sc_hd__diode_2
XANTENNA_clkload4_A clknet_4_5_0_clk VGND VGND VPWR VPWR sky130_fd_sc_hd__diode_2
XFILLER_0_97_681 VGND VGND VPWR VPWR sky130_fd_sc_hd__fill_1
XFILLER_0_16_89 VGND VGND VPWR VPWR sky130_fd_sc_hd__fill_2
XFILLER_0_69_383 VGND VGND VPWR VPWR sky130_fd_sc_hd__fill_1
XANTENNA__4270__C1 net8 VGND VGND VPWR VPWR sky130_fd_sc_hd__diode_2
XFILLER_0_57_567 VGND VGND VPWR VPWR sky130_fd_sc_hd__fill_2
XFILLER_0_45_729 VGND VGND VPWR VPWR sky130_fd_sc_hd__fill_1
XFILLER_0_29_247 VGND VGND VPWR VPWR sky130_fd_sc_hd__fill_2
XFILLER_0_72_537 VGND VGND VPWR VPWR sky130_fd_sc_hd__fill_2
X_4620_ registers\[24\]\[19\] registers\[25\]\[19\] registers\[26\]\[19\] registers\[27\]\[19\]
+ _1338_ _1339_ VGND VGND VPWR VPWR _1401_ sky130_fd_sc_hd__mux4_1
XANTENNA__7456__A _3647_ VGND VGND VPWR VPWR sky130_fd_sc_hd__diode_2
XANTENNA__4799__S1 _1556_ VGND VGND VPWR VPWR sky130_fd_sc_hd__diode_2
XFILLER_0_25_442 VGND VGND VPWR VPWR sky130_fd_sc_hd__fill_2
XFILLER_0_114_138 VGND VGND VPWR VPWR sky130_fd_sc_hd__fill_2
XANTENNA__5770__C1 _2317_ VGND VGND VPWR VPWR sky130_fd_sc_hd__diode_2
X_4551_ _1330_ _1332_ _1335_ _1153_ _1142_ VGND VGND VPWR VPWR _1336_ sky130_fd_sc_hd__a221o_1
XFILLER_0_25_464 VGND VGND VPWR VPWR sky130_fd_sc_hd__decap_3
XFILLER_0_25_486 VGND VGND VPWR VPWR sky130_fd_sc_hd__decap_3
X_4482_ _1270_ VGND VGND VPWR VPWR net115 sky130_fd_sc_hd__inv_2
X_7270_ registers\[18\]\[9\] _3453_ _3539_ VGND VGND VPWR VPWR _3549_ sky130_fd_sc_hd__mux2_1
XFILLER_0_13_648 VGND VGND VPWR VPWR sky130_fd_sc_hd__decap_3
XANTENNA__7511__A0 _3123_ VGND VGND VPWR VPWR sky130_fd_sc_hd__diode_2
X_6221_ _2384_ _2894_ VGND VGND VPWR VPWR _2928_ sky130_fd_sc_hd__nor2_1
X_6152_ _2241_ _2248_ VGND VGND VPWR VPWR _2862_ sky130_fd_sc_hd__nand2_1
XANTENNA__4420__S0 _1053_ VGND VGND VPWR VPWR sky130_fd_sc_hd__diode_2
XFILLER_0_21_692 VGND VGND VPWR VPWR sky130_fd_sc_hd__fill_2
XANTENNA__6078__B1 _2420_ VGND VGND VPWR VPWR sky130_fd_sc_hd__diode_2
XANTENNA__4971__S1 _1691_ VGND VGND VPWR VPWR sky130_fd_sc_hd__diode_2
X_5103_ _1858_ _1859_ _1856_ VGND VGND VPWR VPWR _1860_ sky130_fd_sc_hd__mux2_1
X_6083_ _2490_ _2560_ _2669_ _2796_ VGND VGND VPWR VPWR _2797_ sky130_fd_sc_hd__o31a_1
X_5034_ _1701_ _1794_ _1702_ VGND VGND VPWR VPWR _1795_ sky130_fd_sc_hd__a21oi_1
XANTENNA__7130__S _3456_ VGND VGND VPWR VPWR sky130_fd_sc_hd__diode_2
XANTENNA__4487__S0 _1167_ VGND VGND VPWR VPWR sky130_fd_sc_hd__diode_2
XFILLER_0_79_169 VGND VGND VPWR VPWR sky130_fd_sc_hd__fill_2
XANTENNA__5053__A1 _1809_ VGND VGND VPWR VPWR sky130_fd_sc_hd__diode_2
XFILLER_0_67_309 VGND VGND VPWR VPWR sky130_fd_sc_hd__decap_8
X_6985_ _3108_ registers\[14\]\[19\] _3372_ VGND VGND VPWR VPWR _3382_ sky130_fd_sc_hd__mux2_1
XTAP_TAPCELL_ROW_0_246 VGND VPWR sky130_fd_sc_hd__tapvpwrvgnd_1
XTAP_TAPCELL_ROW_0_257 VGND VPWR sky130_fd_sc_hd__tapvpwrvgnd_1
XFILLER_0_94_139 VGND VGND VPWR VPWR sky130_fd_sc_hd__fill_1
X_5936_ _1286_ _1302_ VGND VGND VPWR VPWR _2658_ sky130_fd_sc_hd__nand2_1
X_8724_ clknet_leaf_92_clk _0845_ VGND VGND VPWR VPWR registers\[10\]\[20\] sky130_fd_sc_hd__dfxtp_1
XFILLER_0_118_400 VGND VGND VPWR VPWR sky130_fd_sc_hd__decap_4
X_8655_ clknet_leaf_44_clk _0776_ VGND VGND VPWR VPWR registers\[7\]\[15\] sky130_fd_sc_hd__dfxtp_1
XFILLER_0_8_631 VGND VGND VPWR VPWR sky130_fd_sc_hd__decap_6
X_7606_ _3727_ VGND VGND VPWR VPWR _0223_ sky130_fd_sc_hd__clkbuf_1
X_5867_ _2557_ _2576_ VGND VGND VPWR VPWR _2593_ sky130_fd_sc_hd__and2_1
XFILLER_0_8_653 VGND VGND VPWR VPWR sky130_fd_sc_hd__decap_3
XFILLER_0_105_105 VGND VGND VPWR VPWR sky130_fd_sc_hd__fill_2
XANTENNA__6553__A1 _2985_ VGND VGND VPWR VPWR sky130_fd_sc_hd__diode_2
X_8586_ clknet_leaf_39_clk _0707_ VGND VGND VPWR VPWR registers\[3\]\[10\] sky130_fd_sc_hd__dfxtp_1
X_5798_ net141 _2483_ _2514_ _2484_ VGND VGND VPWR VPWR _2527_ sky130_fd_sc_hd__o31a_1
X_4818_ _1586_ _1587_ _1421_ VGND VGND VPWR VPWR _1588_ sky130_fd_sc_hd__mux2_1
XFILLER_0_8_675 VGND VGND VPWR VPWR sky130_fd_sc_hd__fill_2
XFILLER_0_16_442 VGND VGND VPWR VPWR sky130_fd_sc_hd__fill_1
X_7537_ _3081_ registers\[22\]\[6\] _3684_ VGND VGND VPWR VPWR _3691_ sky130_fd_sc_hd__mux2_1
X_4749_ _1521_ _1522_ _1421_ VGND VGND VPWR VPWR _1523_ sky130_fd_sc_hd__mux2_1
X_7468_ _3654_ VGND VGND VPWR VPWR _0158_ sky130_fd_sc_hd__clkbuf_1
XFILLER_0_113_160 VGND VGND VPWR VPWR sky130_fd_sc_hd__fill_2
XFILLER_0_101_311 VGND VGND VPWR VPWR sky130_fd_sc_hd__decap_3
X_6419_ registers\[3\]\[29\] _3022_ _3052_ VGND VGND VPWR VPWR _3062_ sky130_fd_sc_hd__mux2_1
X_9207_ clknet_leaf_76_clk _0304_ VGND VGND VPWR VPWR registers\[25\]\[23\] sky130_fd_sc_hd__dfxtp_1
XTAP_TAPCELL_ROW_112_1712 VGND VPWR sky130_fd_sc_hd__tapvpwrvgnd_1
X_7399_ registers\[20\]\[5\] _3445_ _3612_ VGND VGND VPWR VPWR _3618_ sky130_fd_sc_hd__mux2_1
Xoutput58 net58 VGND VGND VPWR VPWR alu_result[18] sky130_fd_sc_hd__buf_1
XANTENNA__8058__A1 _3491_ VGND VGND VPWR VPWR sky130_fd_sc_hd__diode_2
XANTENNA__4867__A1 _1627_ VGND VGND VPWR VPWR sky130_fd_sc_hd__diode_2
Xoutput69 net69 VGND VGND VPWR VPWR alu_result[28] sky130_fd_sc_hd__buf_1
X_9138_ clknet_leaf_72_clk _0235_ VGND VGND VPWR VPWR registers\[23\]\[18\] sky130_fd_sc_hd__dfxtp_1
XFILLER_0_9_6 VGND VGND VPWR VPWR sky130_fd_sc_hd__fill_1
XTAP_TAPCELL_ROW_8_368 VGND VPWR sky130_fd_sc_hd__tapvpwrvgnd_1
XTAP_TAPCELL_ROW_8_357 VGND VPWR sky130_fd_sc_hd__tapvpwrvgnd_1
X_9069_ clknet_leaf_56_clk _0166_ VGND VGND VPWR VPWR registers\[21\]\[13\] sky130_fd_sc_hd__dfxtp_1
XANTENNA__7040__S _3409_ VGND VGND VPWR VPWR sky130_fd_sc_hd__diode_2
XTAP_TAPCELL_ROW_27_610 VGND VPWR sky130_fd_sc_hd__tapvpwrvgnd_1
XANTENNA__4478__S0 _1197_ VGND VGND VPWR VPWR sky130_fd_sc_hd__diode_2
XFILLER_0_79_692 VPWR VGND VPWR VGND sky130_ef_sc_hd__decap_12
XFILLER_0_79_681 VGND VGND VPWR VPWR sky130_fd_sc_hd__decap_4
XTAP_TAPCELL_ROW_55_974 VGND VPWR sky130_fd_sc_hd__tapvpwrvgnd_1
XFILLER_0_109_400 VGND VGND VPWR VPWR sky130_fd_sc_hd__fill_1
XFILLER_0_27_718 VGND VGND VPWR VPWR sky130_fd_sc_hd__decap_4
XFILLER_0_27_729 VGND VGND VPWR VPWR sky130_fd_sc_hd__fill_1
XFILLER_0_109_477 VGND VGND VPWR VPWR sky130_fd_sc_hd__decap_4
XANTENNA__6544__A1 _2976_ VGND VGND VPWR VPWR sky130_fd_sc_hd__diode_2
XFILLER_0_105_661 VGND VGND VPWR VPWR sky130_fd_sc_hd__fill_2
XFILLER_0_78_29 VGND VGND VPWR VPWR sky130_fd_sc_hd__decap_8
XANTENNA__4650__S0 _1427_ VGND VGND VPWR VPWR sky130_fd_sc_hd__diode_2
XTAP_TAPCELL_ROW_74_1217 VGND VPWR sky130_fd_sc_hd__tapvpwrvgnd_1
XANTENNA__7215__S _3514_ VGND VGND VPWR VPWR sky130_fd_sc_hd__diode_2
XFILLER_0_89_445 VGND VGND VPWR VPWR sky130_fd_sc_hd__decap_3
XANTENNA__8046__S _3959_ VGND VGND VPWR VPWR sky130_fd_sc_hd__diode_2
XANTENNA__4469__S0 _1197_ VGND VGND VPWR VPWR sky130_fd_sc_hd__diode_2
XTAP_TAPCELL_ROW_85_1368 VGND VPWR sky130_fd_sc_hd__tapvpwrvgnd_1
X_6770_ registers\[11\]\[15\] _2993_ _3261_ VGND VGND VPWR VPWR _3267_ sky130_fd_sc_hd__mux2_1
XANTENNA__6232__B1 _2515_ VGND VGND VPWR VPWR sky130_fd_sc_hd__diode_2
XANTENNA__5130__S1 _1774_ VGND VGND VPWR VPWR sky130_fd_sc_hd__diode_2
X_5721_ _2297_ _2453_ _2317_ VGND VGND VPWR VPWR _2454_ sky130_fd_sc_hd__a21o_1
X_8440_ _4169_ VGND VGND VPWR VPWR _0615_ sky130_fd_sc_hd__clkbuf_1
XFILLER_0_94_7 VGND VGND VPWR VPWR sky130_fd_sc_hd__decap_6
X_5652_ _1050_ _2251_ VGND VGND VPWR VPWR _2387_ sky130_fd_sc_hd__and2_1
XANTENNA__7732__A0 _3071_ VGND VGND VPWR VPWR sky130_fd_sc_hd__diode_2
XFILLER_0_115_447 VGND VGND VPWR VPWR sky130_fd_sc_hd__fill_1
X_5583_ _2279_ _2296_ _2298_ _2309_ _2318_ VGND VGND VPWR VPWR _2319_ sky130_fd_sc_hd__a221o_1
X_8371_ registers\[5\]\[14\] _3464_ _4128_ VGND VGND VPWR VPWR _4133_ sky130_fd_sc_hd__mux2_1
X_4603_ registers\[12\]\[18\] registers\[13\]\[18\] registers\[14\]\[18\] registers\[15\]\[18\]
+ _1382_ _1383_ VGND VGND VPWR VPWR _1385_ sky130_fd_sc_hd__mux4_1
XFILLER_0_4_122 VGND VGND VPWR VPWR sky130_fd_sc_hd__decap_4
X_4534_ _1319_ VGND VGND VPWR VPWR net118 sky130_fd_sc_hd__inv_2
X_7322_ registers\[1\]\[1\] _3437_ _3575_ VGND VGND VPWR VPWR _3577_ sky130_fd_sc_hd__mux2_1
XFILLER_0_41_732 VGND VGND VPWR VPWR sky130_fd_sc_hd__fill_1
XFILLER_0_25_272 VGND VGND VPWR VPWR sky130_fd_sc_hd__fill_2
XFILLER_0_102_119 VGND VGND VPWR VPWR sky130_fd_sc_hd__fill_1
XFILLER_0_4_188 VGND VGND VPWR VPWR sky130_fd_sc_hd__fill_2
XANTENNA__5197__S1 _1814_ VGND VGND VPWR VPWR sky130_fd_sc_hd__diode_2
X_4465_ _1254_ VGND VGND VPWR VPWR net114 sky130_fd_sc_hd__dlymetal6s2s_1
X_7253_ _3540_ VGND VGND VPWR VPWR _0057_ sky130_fd_sc_hd__clkbuf_1
XANTENNA__4749__S _1421_ VGND VGND VPWR VPWR sky130_fd_sc_hd__diode_2
XANTENNA__4944__S1 _1706_ VGND VGND VPWR VPWR sky130_fd_sc_hd__diode_2
X_4396_ registers\[24\]\[7\] registers\[25\]\[7\] registers\[26\]\[7\] registers\[27\]\[7\]
+ _1125_ _1127_ VGND VGND VPWR VPWR _1189_ sky130_fd_sc_hd__mux4_1
X_6204_ _2907_ _2911_ VGND VGND VPWR VPWR _2912_ sky130_fd_sc_hd__and2b_1
X_7184_ registers\[17\]\[0\] _3433_ _3503_ VGND VGND VPWR VPWR _3504_ sky130_fd_sc_hd__mux2_1
X_6135_ _2566_ _2766_ _2846_ VGND VGND VPWR VPWR _2847_ sky130_fd_sc_hd__o21ai_1
XANTENNA__6964__S _3361_ VGND VGND VPWR VPWR sky130_fd_sc_hd__diode_2
XTAP_TAPCELL_ROW_5_327 VGND VPWR sky130_fd_sc_hd__tapvpwrvgnd_1
X_6066_ _1440_ _2207_ _2706_ _2707_ VGND VGND VPWR VPWR _2781_ sky130_fd_sc_hd__a31o_1
XANTENNA__8460__A1 net32 VGND VGND VPWR VPWR sky130_fd_sc_hd__diode_2
X_5017_ _1771_ _1777_ _1778_ VGND VGND VPWR VPWR _1779_ sky130_fd_sc_hd__a21oi_1
XANTENNA__5577__A2 _2310_ VGND VGND VPWR VPWR sky130_fd_sc_hd__diode_2
X_6968_ _3373_ VGND VGND VPWR VPWR _0963_ sky130_fd_sc_hd__clkbuf_1
XANTENNA__6774__A1 _2997_ VGND VGND VPWR VPWR sky130_fd_sc_hd__diode_2
XANTENNA__5121__S1 _1759_ VGND VGND VPWR VPWR sky130_fd_sc_hd__diode_2
XFILLER_0_76_662 VGND VGND VPWR VPWR sky130_fd_sc_hd__fill_2
X_8707_ clknet_leaf_6_clk _0828_ VGND VGND VPWR VPWR registers\[10\]\[3\] sky130_fd_sc_hd__dfxtp_1
XTAP_TAPCELL_ROW_52_933 VGND VPWR sky130_fd_sc_hd__tapvpwrvgnd_1
X_6899_ _3336_ VGND VGND VPWR VPWR _0931_ sky130_fd_sc_hd__clkbuf_1
XANTENNA__5609__A _2295_ VGND VGND VPWR VPWR sky130_fd_sc_hd__diode_2
X_5919_ _2429_ _2632_ _2642_ VGND VGND VPWR VPWR net52 sky130_fd_sc_hd__a21oi_1
XFILLER_0_75_161 VGND VGND VPWR VPWR sky130_fd_sc_hd__fill_1
XANTENNA__4880__S0 _1642_ VGND VGND VPWR VPWR sky130_fd_sc_hd__diode_2
XFILLER_0_91_643 VGND VGND VPWR VPWR sky130_fd_sc_hd__fill_2
XFILLER_0_8_472 VGND VGND VPWR VPWR sky130_fd_sc_hd__fill_2
X_8638_ clknet_leaf_98_clk _0759_ VGND VGND VPWR VPWR registers\[29\]\[30\] sky130_fd_sc_hd__dfxtp_1
XFILLER_0_8_494 VGND VGND VPWR VPWR sky130_fd_sc_hd__fill_2
X_8569_ clknet_leaf_80_clk _0690_ VGND VGND VPWR VPWR registers\[19\]\[25\] sky130_fd_sc_hd__dfxtp_1
XFILLER_0_106_458 VGND VGND VPWR VPWR sky130_fd_sc_hd__fill_2
XFILLER_0_31_220 VGND VGND VPWR VPWR sky130_fd_sc_hd__fill_2
XFILLER_0_102_664 VGND VGND VPWR VPWR sky130_fd_sc_hd__fill_2
XANTENNA__5188__S1 _1749_ VGND VGND VPWR VPWR sky130_fd_sc_hd__diode_2
XFILLER_0_101_185 VGND VGND VPWR VPWR sky130_fd_sc_hd__fill_2
XANTENNA_input21_A wd3[14] VGND VGND VPWR VPWR sky130_fd_sc_hd__diode_2
XANTENNA__4699__S0 _1347_ VGND VGND VPWR VPWR sky130_fd_sc_hd__diode_2
XFILLER_0_99_732 VGND VGND VPWR VPWR sky130_fd_sc_hd__fill_1
XANTENNA_clkbuf_4_13_0_clk_A clknet_0_clk VGND VGND VPWR VPWR sky130_fd_sc_hd__diode_2
XANTENNA__4394__S _1117_ VGND VGND VPWR VPWR sky130_fd_sc_hd__diode_2
XANTENNA__5360__S1 _1997_ VGND VGND VPWR VPWR sky130_fd_sc_hd__diode_2
XPHY_EDGE_ROW_103_Left_223 VGND VGND VPWR VPWR sky130_fd_sc_hd__decap_3
XFILLER_0_98_253 VGND VGND VPWR VPWR sky130_fd_sc_hd__decap_3
XANTENNA__5017__A1 _1771_ VGND VGND VPWR VPWR sky130_fd_sc_hd__diode_2
XFILLER_0_86_437 VGND VGND VPWR VPWR sky130_fd_sc_hd__decap_4
XFILLER_0_39_320 VGND VGND VPWR VPWR sky130_fd_sc_hd__fill_2
XFILLER_0_104_26 VGND VGND VPWR VPWR sky130_fd_sc_hd__fill_2
XANTENNA__5112__S1 _1799_ VGND VGND VPWR VPWR sky130_fd_sc_hd__diode_2
XANTENNA_output108_A net108 VGND VGND VPWR VPWR sky130_fd_sc_hd__diode_2
XFILLER_0_104_59 VGND VGND VPWR VPWR sky130_fd_sc_hd__decap_4
XFILLER_0_67_695 VPWR VGND VPWR VGND sky130_ef_sc_hd__decap_12
XFILLER_0_67_673 VGND VGND VPWR VPWR sky130_fd_sc_hd__fill_2
XFILLER_0_66_150 VGND VGND VPWR VPWR sky130_fd_sc_hd__fill_2
XANTENNA__5725__C1 _2276_ VGND VGND VPWR VPWR sky130_fd_sc_hd__diode_2
XFILLER_0_81_164 VGND VGND VPWR VPWR sky130_fd_sc_hd__fill_1
XTAP_TAPCELL_ROW_80_1298 VGND VPWR sky130_fd_sc_hd__tapvpwrvgnd_1
XTAP_TAPCELL_ROW_30_649 VGND VPWR sky130_fd_sc_hd__tapvpwrvgnd_1
XFILLER_0_35_570 VGND VGND VPWR VPWR sky130_fd_sc_hd__decap_3
XPHY_EDGE_ROW_112_Left_232 VGND VGND VPWR VPWR sky130_fd_sc_hd__decap_3
XFILLER_0_50_562 VGND VGND VPWR VPWR sky130_fd_sc_hd__fill_2
XFILLER_0_2_626 VGND VGND VPWR VPWR sky130_fd_sc_hd__decap_3
XFILLER_0_1_125 VPWR VGND VPWR VGND sky130_ef_sc_hd__decap_12
XTAP_TAPCELL_ROW_10_384 VGND VPWR sky130_fd_sc_hd__tapvpwrvgnd_1
XTAP_TAPCELL_ROW_10_395 VGND VPWR sky130_fd_sc_hd__tapvpwrvgnd_1
XFILLER_0_22_253 VGND VGND VPWR VPWR sky130_fd_sc_hd__decap_4
XANTENNA__5179__S1 _1765_ VGND VGND VPWR VPWR sky130_fd_sc_hd__diode_2
X_4250_ _1049_ VGND VGND VPWR VPWR _1050_ sky130_fd_sc_hd__inv_2
XFILLER_0_10_437 VGND VGND VPWR VPWR sky130_fd_sc_hd__fill_2
XFILLER_0_89_220 VGND VGND VPWR VPWR sky130_fd_sc_hd__fill_2
X_7940_ _2968_ registers\[28\]\[3\] _3901_ VGND VGND VPWR VPWR _3905_ sky130_fd_sc_hd__mux2_1
XFILLER_0_77_404 VGND VGND VPWR VPWR sky130_fd_sc_hd__fill_1
XFILLER_0_54_64 VGND VGND VPWR VPWR sky130_fd_sc_hd__fill_2
XTAP_TAPCELL_ROW_38_749 VGND VPWR sky130_fd_sc_hd__tapvpwrvgnd_1
X_7871_ _3868_ VGND VGND VPWR VPWR _0347_ sky130_fd_sc_hd__clkbuf_1
X_6822_ _3295_ VGND VGND VPWR VPWR _0895_ sky130_fd_sc_hd__clkbuf_1
XFILLER_0_89_297 VGND VGND VPWR VPWR sky130_fd_sc_hd__fill_1
XFILLER_0_58_662 VGND VGND VPWR VPWR sky130_fd_sc_hd__fill_1
XFILLER_0_9_214 VGND VGND VPWR VPWR sky130_fd_sc_hd__decap_6
XTAP_TAPCELL_ROW_18_495 VGND VPWR sky130_fd_sc_hd__tapvpwrvgnd_1
X_9541_ clknet_leaf_32_clk _0638_ VGND VGND VPWR VPWR registers\[4\]\[5\] sky130_fd_sc_hd__dfxtp_1
X_6753_ registers\[11\]\[7\] _2976_ _3250_ VGND VGND VPWR VPWR _3258_ sky130_fd_sc_hd__mux2_1
XFILLER_0_9_258 VGND VGND VPWR VPWR sky130_fd_sc_hd__fill_1
X_6684_ _3221_ VGND VGND VPWR VPWR _0831_ sky130_fd_sc_hd__clkbuf_1
XFILLER_0_116_701 VPWR VGND VPWR VGND sky130_ef_sc_hd__decap_12
X_5704_ _2434_ _2436_ VGND VGND VPWR VPWR _2437_ sky130_fd_sc_hd__xnor2_1
XFILLER_0_70_85 VGND VGND VPWR VPWR sky130_fd_sc_hd__fill_2
XFILLER_0_9_269 VGND VGND VPWR VPWR sky130_fd_sc_hd__fill_2
XFILLER_0_18_537 VGND VGND VPWR VPWR sky130_fd_sc_hd__fill_2
X_9472_ clknet_leaf_4_clk _0569_ VGND VGND VPWR VPWR registers\[5\]\[0\] sky130_fd_sc_hd__dfxtp_1
XANTENNA__4862__S0 _1628_ VGND VGND VPWR VPWR sky130_fd_sc_hd__diode_2
X_8423_ _4160_ VGND VGND VPWR VPWR _0607_ sky130_fd_sc_hd__clkbuf_1
XFILLER_0_115_200 VGND VGND VPWR VPWR sky130_fd_sc_hd__fill_2
XTAP_TAPCELL_ROW_98_1537 VGND VPWR sky130_fd_sc_hd__tapvpwrvgnd_1
X_5635_ _2368_ _2369_ VGND VGND VPWR VPWR _2370_ sky130_fd_sc_hd__nand2_1
XFILLER_0_85_3 VGND VGND VPWR VPWR sky130_fd_sc_hd__fill_1
XFILLER_0_72_197 VGND VGND VPWR VPWR sky130_fd_sc_hd__fill_2
XFILLER_0_60_348 VGND VGND VPWR VPWR sky130_fd_sc_hd__fill_2
XFILLER_0_14_732 VGND VGND VPWR VPWR sky130_fd_sc_hd__fill_1
X_8354_ registers\[5\]\[6\] _3447_ _4117_ VGND VGND VPWR VPWR _4124_ sky130_fd_sc_hd__mux2_1
X_5566_ _1725_ _2214_ VGND VGND VPWR VPWR _2302_ sky130_fd_sc_hd__or2_1
XFILLER_0_41_551 VGND VGND VPWR VPWR sky130_fd_sc_hd__fill_2
XFILLER_0_5_486 VGND VGND VPWR VPWR sky130_fd_sc_hd__fill_2
X_4517_ registers\[24\]\[14\] registers\[25\]\[14\] registers\[26\]\[14\] registers\[27\]\[14\]
+ _1198_ _1199_ VGND VGND VPWR VPWR _1303_ sky130_fd_sc_hd__mux4_1
XANTENNA__4479__S _1116_ VGND VGND VPWR VPWR sky130_fd_sc_hd__diode_2
X_8285_ _4087_ VGND VGND VPWR VPWR _0542_ sky130_fd_sc_hd__clkbuf_1
X_5497_ _2217_ _2232_ VGND VGND VPWR VPWR _2233_ sky130_fd_sc_hd__nand2_1
X_7305_ _3567_ VGND VGND VPWR VPWR _0082_ sky130_fd_sc_hd__clkbuf_1
XANTENNA__8130__A0 _3022_ VGND VGND VPWR VPWR sky130_fd_sc_hd__diode_2
XANTENNA_clkbuf_leaf_1_clk_A clknet_4_0_0_clk VGND VGND VPWR VPWR sky130_fd_sc_hd__diode_2
X_4448_ _1025_ _1238_ net8 VGND VGND VPWR VPWR _1239_ sky130_fd_sc_hd__a21o_1
X_7236_ registers\[17\]\[25\] _3487_ _3525_ VGND VGND VPWR VPWR _3531_ sky130_fd_sc_hd__mux2_1
XANTENNA__6694__S _3225_ VGND VGND VPWR VPWR sky130_fd_sc_hd__diode_2
X_4379_ registers\[24\]\[6\] registers\[25\]\[6\] registers\[26\]\[6\] registers\[27\]\[6\]
+ _1167_ _1168_ VGND VGND VPWR VPWR _1173_ sky130_fd_sc_hd__mux4_1
X_7167_ registers\[16\]\[27\] _3491_ _3477_ VGND VGND VPWR VPWR _3492_ sky130_fd_sc_hd__mux2_1
X_7098_ net43 VGND VGND VPWR VPWR _3445_ sky130_fd_sc_hd__buf_2
XANTENNA__8433__A1 net18 VGND VGND VPWR VPWR sky130_fd_sc_hd__diode_2
X_6118_ _2816_ _2818_ net96 VGND VGND VPWR VPWR _2830_ sky130_fd_sc_hd__a21o_1
XANTENNA__5103__S _1856_ VGND VGND VPWR VPWR sky130_fd_sc_hd__diode_2
X_6049_ _2690_ _2764_ _2460_ VGND VGND VPWR VPWR _2765_ sky130_fd_sc_hd__mux2_1
XANTENNA__5342__S1 _2028_ VGND VGND VPWR VPWR sky130_fd_sc_hd__diode_2
XTAP_TAPCELL_ROW_107_1644 VGND VPWR sky130_fd_sc_hd__tapvpwrvgnd_1
XANTENNA__6426__C net11 VGND VGND VPWR VPWR sky130_fd_sc_hd__diode_2
XTAP_TAPCELL_ROW_107_1655 VGND VPWR sky130_fd_sc_hd__tapvpwrvgnd_1
XANTENNA__7944__A0 _2972_ VGND VGND VPWR VPWR sky130_fd_sc_hd__diode_2
XANTENNA__8414__S _4153_ VGND VGND VPWR VPWR sky130_fd_sc_hd__diode_2
XFILLER_0_83_429 VGND VGND VPWR VPWR sky130_fd_sc_hd__fill_1
XFILLER_0_49_695 VGND VGND VPWR VPWR sky130_fd_sc_hd__fill_2
XFILLER_0_49_673 VPWR VGND VPWR VGND sky130_ef_sc_hd__decap_12
XFILLER_0_119_561 VGND VGND VPWR VPWR sky130_fd_sc_hd__decap_3
XFILLER_0_76_481 VGND VGND VPWR VPWR sky130_fd_sc_hd__fill_2
XFILLER_0_64_654 VGND VGND VPWR VPWR sky130_fd_sc_hd__fill_1
XFILLER_0_36_334 VGND VGND VPWR VPWR sky130_fd_sc_hd__fill_2
XANTENNA__6869__S _3310_ VGND VGND VPWR VPWR sky130_fd_sc_hd__diode_2
XFILLER_0_36_356 VGND VGND VPWR VPWR sky130_fd_sc_hd__decap_8
XANTENNA__5773__S net135 VGND VGND VPWR VPWR sky130_fd_sc_hd__diode_2
XFILLER_0_51_337 VGND VGND VPWR VPWR sky130_fd_sc_hd__fill_2
XFILLER_0_17_570 VGND VGND VPWR VPWR sky130_fd_sc_hd__decap_4
XTAP_TAPCELL_ROW_58_1009 VGND VPWR sky130_fd_sc_hd__tapvpwrvgnd_1
XTAP_TAPCELL_ROW_118_1795 VGND VPWR sky130_fd_sc_hd__tapvpwrvgnd_1
XANTENNA__5948__S _2490_ VGND VGND VPWR VPWR sky130_fd_sc_hd__diode_2
XFILLER_0_87_724 VGND VGND VPWR VPWR sky130_fd_sc_hd__fill_2
XANTENNA__7729__A _3792_ VGND VGND VPWR VPWR sky130_fd_sc_hd__diode_2
XTAP_TAPCELL_ROW_35_708 VGND VPWR sky130_fd_sc_hd__tapvpwrvgnd_1
XTAP_TAPCELL_ROW_35_719 VGND VPWR sky130_fd_sc_hd__tapvpwrvgnd_1
XFILLER_0_115_47 VGND VGND VPWR VPWR sky130_fd_sc_hd__decap_6
XANTENNA__5097__S0 _1763_ VGND VGND VPWR VPWR sky130_fd_sc_hd__diode_2
XTAP_TAPCELL_ROW_82_1327 VGND VPWR sky130_fd_sc_hd__tapvpwrvgnd_1
XANTENNA__8324__S _4103_ VGND VGND VPWR VPWR sky130_fd_sc_hd__diode_2
XFILLER_0_86_289 VGND VGND VPWR VPWR sky130_fd_sc_hd__fill_1
XFILLER_0_74_418 VGND VGND VPWR VPWR sky130_fd_sc_hd__fill_2
XFILLER_0_117_509 VGND VGND VPWR VPWR sky130_fd_sc_hd__fill_1
XANTENNA__5249__A _1775_ VGND VGND VPWR VPWR sky130_fd_sc_hd__diode_2
XFILLER_0_39_183 VGND VGND VPWR VPWR sky130_fd_sc_hd__decap_4
XFILLER_0_7_729 VGND VGND VPWR VPWR sky130_fd_sc_hd__decap_4
XTAP_TAPCELL_ROW_15_454 VGND VPWR sky130_fd_sc_hd__tapvpwrvgnd_1
XFILLER_0_27_334 VGND VGND VPWR VPWR sky130_fd_sc_hd__fill_2
XFILLER_0_6_228 VGND VGND VPWR VPWR sky130_fd_sc_hd__fill_2
XFILLER_0_27_367 VGND VGND VPWR VPWR sky130_fd_sc_hd__fill_2
XFILLER_0_42_326 VGND VGND VPWR VPWR sky130_fd_sc_hd__fill_1
XFILLER_0_112_225 VGND VGND VPWR VPWR sky130_fd_sc_hd__fill_2
X_5420_ _2155_ _2158_ _2019_ VGND VGND VPWR VPWR _2159_ sky130_fd_sc_hd__mux2_1
XFILLER_0_112_258 VGND VGND VPWR VPWR sky130_fd_sc_hd__fill_2
XANTENNA__4299__S _1030_ VGND VGND VPWR VPWR sky130_fd_sc_hd__diode_2
X_5351_ _2092_ _2093_ _2031_ VGND VGND VPWR VPWR _2094_ sky130_fd_sc_hd__mux2_1
XANTENNA__8112__A0 _3003_ VGND VGND VPWR VPWR sky130_fd_sc_hd__diode_2
XTAP_TAPCELL_ROW_93_1467 VGND VPWR sky130_fd_sc_hd__tapvpwrvgnd_1
X_4302_ _1031_ _1098_ VGND VGND VPWR VPWR _1099_ sky130_fd_sc_hd__or2_1
XFILLER_0_49_31 VGND VGND VPWR VPWR sky130_fd_sc_hd__fill_2
X_8070_ _2958_ registers\[30\]\[0\] _3973_ VGND VGND VPWR VPWR _3974_ sky130_fd_sc_hd__mux2_1
X_5282_ registers\[4\]\[21\] registers\[5\]\[21\] registers\[6\]\[21\] registers\[7\]\[21\]
+ _2027_ _2028_ VGND VGND VPWR VPWR _2029_ sky130_fd_sc_hd__mux4_1
XANTENNA__5021__S0 _1731_ VGND VGND VPWR VPWR sky130_fd_sc_hd__diode_2
X_7021_ _3075_ registers\[15\]\[3\] _3398_ VGND VGND VPWR VPWR _3402_ sky130_fd_sc_hd__mux2_1
X_4233_ _1025_ _1032_ VGND VGND VPWR VPWR _1033_ sky130_fd_sc_hd__nand2_1
XANTENNA__7403__S _3612_ VGND VGND VPWR VPWR sky130_fd_sc_hd__diode_2
XANTENNA__5712__A _1106_ VGND VGND VPWR VPWR sky130_fd_sc_hd__diode_2
XFILLER_0_4_11 VGND VGND VPWR VPWR sky130_fd_sc_hd__fill_1
XANTENNA__6808__A _3287_ VGND VGND VPWR VPWR sky130_fd_sc_hd__diode_2
XANTENNA__6527__B net12 VGND VGND VPWR VPWR sky130_fd_sc_hd__diode_2
X_8972_ clknet_leaf_42_clk _0069_ VGND VGND VPWR VPWR registers\[18\]\[12\] sky130_fd_sc_hd__dfxtp_1
XANTENNA__4328__A _1122_ VGND VGND VPWR VPWR sky130_fd_sc_hd__diode_2
XFILLER_0_65_52 VGND VGND VPWR VPWR sky130_fd_sc_hd__fill_2
XFILLER_0_65_96 VGND VGND VPWR VPWR sky130_fd_sc_hd__fill_2
XANTENNA__5324__S1 _2021_ VGND VGND VPWR VPWR sky130_fd_sc_hd__diode_2
X_7923_ _3895_ VGND VGND VPWR VPWR _0372_ sky130_fd_sc_hd__clkbuf_1
XFILLER_0_77_223 VGND VGND VPWR VPWR sky130_fd_sc_hd__fill_1
XFILLER_0_77_256 VGND VGND VPWR VPWR sky130_fd_sc_hd__fill_2
XANTENNA__6729__A1 _3020_ VGND VGND VPWR VPWR sky130_fd_sc_hd__diode_2
X_7854_ _3125_ registers\[26\]\[27\] _3851_ VGND VGND VPWR VPWR _3859_ sky130_fd_sc_hd__mux2_1
XFILLER_0_77_278 VGND VGND VPWR VPWR sky130_fd_sc_hd__fill_2
XFILLER_0_65_407 VGND VGND VPWR VPWR sky130_fd_sc_hd__decap_6
XFILLER_0_58_470 VGND VGND VPWR VPWR sky130_fd_sc_hd__decap_4
X_6805_ _3173_ VGND VGND VPWR VPWR _3285_ sky130_fd_sc_hd__inv_2
X_7785_ _3822_ VGND VGND VPWR VPWR _0307_ sky130_fd_sc_hd__clkbuf_1
XFILLER_0_92_237 VGND VGND VPWR VPWR sky130_fd_sc_hd__fill_2
XFILLER_0_92_248 VGND VGND VPWR VPWR sky130_fd_sc_hd__fill_2
X_4997_ _1706_ VGND VGND VPWR VPWR _1759_ sky130_fd_sc_hd__buf_4
X_6736_ _3248_ VGND VGND VPWR VPWR _0856_ sky130_fd_sc_hd__clkbuf_1
XFILLER_0_18_323 VGND VGND VPWR VPWR sky130_fd_sc_hd__fill_1
XANTENNA__4835__S0 _1555_ VGND VGND VPWR VPWR sky130_fd_sc_hd__diode_2
X_9524_ clknet_leaf_70_clk _0621_ VGND VGND VPWR VPWR registers\[8\]\[20\] sky130_fd_sc_hd__dfxtp_1
XTAP_TAPCELL_ROW_102_1585 VGND VPWR sky130_fd_sc_hd__tapvpwrvgnd_1
XANTENNA__5952__A2 _2666_ VGND VGND VPWR VPWR sky130_fd_sc_hd__diode_2
XFILLER_0_46_654 VGND VGND VPWR VPWR sky130_fd_sc_hd__fill_2
XFILLER_0_45_131 VGND VGND VPWR VPWR sky130_fd_sc_hd__fill_2
X_9455_ clknet_leaf_47_clk _0552_ VGND VGND VPWR VPWR registers\[31\]\[15\] sky130_fd_sc_hd__dfxtp_1
XANTENNA__6689__S _3214_ VGND VGND VPWR VPWR sky130_fd_sc_hd__diode_2
XANTENNA__4998__A _1759_ VGND VGND VPWR VPWR sky130_fd_sc_hd__diode_2
XFILLER_0_61_646 VGND VGND VPWR VPWR sky130_fd_sc_hd__decap_3
X_6667_ net10 net48 VGND VGND VPWR VPWR _3211_ sky130_fd_sc_hd__nand2_1
XFILLER_0_33_315 VGND VGND VPWR VPWR sky130_fd_sc_hd__fill_2
X_5618_ _2352_ VGND VGND VPWR VPWR _2353_ sky130_fd_sc_hd__clkbuf_4
XFILLER_0_103_203 VPWR VGND VPWR VGND sky130_ef_sc_hd__decap_12
X_9386_ clknet_leaf_41_clk _0483_ VGND VGND VPWR VPWR registers\[9\]\[10\] sky130_fd_sc_hd__dfxtp_1
XFILLER_0_60_145 VGND VGND VPWR VPWR sky130_fd_sc_hd__fill_2
X_6598_ _3028_ _3173_ VGND VGND VPWR VPWR _3174_ sky130_fd_sc_hd__nor2_2
X_8406_ registers\[5\]\[31\] _3499_ _4116_ VGND VGND VPWR VPWR _4151_ sky130_fd_sc_hd__mux2_1
XFILLER_0_103_258 VGND VGND VPWR VPWR sky130_fd_sc_hd__fill_2
XFILLER_0_103_247 VGND VGND VPWR VPWR sky130_fd_sc_hd__fill_1
XFILLER_0_103_225 VGND VGND VPWR VPWR sky130_fd_sc_hd__fill_2
X_5549_ _2283_ _2284_ VGND VGND VPWR VPWR _2285_ sky130_fd_sc_hd__nand2_1
X_8337_ _4114_ VGND VGND VPWR VPWR _0567_ sky130_fd_sc_hd__clkbuf_1
XANTENNA__5260__S0 _1758_ VGND VGND VPWR VPWR sky130_fd_sc_hd__diode_2
X_8268_ registers\[6\]\[30\] _3497_ _4044_ VGND VGND VPWR VPWR _4078_ sky130_fd_sc_hd__mux2_1
X_7219_ registers\[17\]\[17\] _3470_ _3514_ VGND VGND VPWR VPWR _3522_ sky130_fd_sc_hd__mux2_1
XFILLER_0_111_291 VGND VGND VPWR VPWR sky130_fd_sc_hd__fill_2
X_8199_ _4041_ VGND VGND VPWR VPWR _0502_ sky130_fd_sc_hd__clkbuf_1
XANTENNA__4238__A _1034_ VGND VGND VPWR VPWR sky130_fd_sc_hd__diode_2
XANTENNA__5315__S1 _1799_ VGND VGND VPWR VPWR sky130_fd_sc_hd__diode_2
XFILLER_0_96_510 VGND VGND VPWR VPWR sky130_fd_sc_hd__decap_3
XFILLER_0_68_201 VGND VGND VPWR VPWR sky130_fd_sc_hd__decap_6
XANTENNA__6453__A net46 VGND VGND VPWR VPWR sky130_fd_sc_hd__diode_2
XFILLER_0_68_245 VGND VGND VPWR VPWR sky130_fd_sc_hd__decap_4
XANTENNA__8144__S _4009_ VGND VGND VPWR VPWR sky130_fd_sc_hd__diode_2
XANTENNA__5079__S0 _1757_ VGND VGND VPWR VPWR sky130_fd_sc_hd__diode_2
XFILLER_0_56_418 VGND VGND VPWR VPWR sky130_fd_sc_hd__fill_2
XANTENNA__5069__A _1752_ VGND VGND VPWR VPWR sky130_fd_sc_hd__diode_2
XANTENNA__7393__A1 _3439_ VGND VGND VPWR VPWR sky130_fd_sc_hd__diode_2
XFILLER_0_52_602 VGND VGND VPWR VPWR sky130_fd_sc_hd__fill_1
XTAP_TAPCELL_ROW_12_413 VGND VPWR sky130_fd_sc_hd__tapvpwrvgnd_1
XFILLER_0_91_281 VGND VGND VPWR VPWR sky130_fd_sc_hd__fill_2
XTAP_TAPCELL_ROW_40_777 VGND VPWR sky130_fd_sc_hd__tapvpwrvgnd_1
XFILLER_0_52_657 VPWR VGND VPWR VGND sky130_ef_sc_hd__decap_12
XFILLER_0_24_359 VGND VGND VPWR VPWR sky130_fd_sc_hd__fill_2
XFILLER_0_36_197 VGND VGND VPWR VPWR sky130_fd_sc_hd__decap_3
XANTENNA__5251__S0 _1996_ VGND VGND VPWR VPWR sky130_fd_sc_hd__diode_2
XFILLER_0_20_565 VGND VGND VPWR VPWR sky130_fd_sc_hd__fill_2
XANTENNA__5459__A1 _1977_ VGND VGND VPWR VPWR sky130_fd_sc_hd__diode_2
XANTENNA__5532__A _2267_ VGND VGND VPWR VPWR sky130_fd_sc_hd__diode_2
XANTENNA__7223__S _3514_ VGND VGND VPWR VPWR sky130_fd_sc_hd__diode_2
XFILLER_0_19_34 VGND VGND VPWR VPWR sky130_fd_sc_hd__fill_1
XANTENNA__5631__A1 _1959_ VGND VGND VPWR VPWR sky130_fd_sc_hd__diode_2
XFILLER_0_59_212 VGND VGND VPWR VPWR sky130_fd_sc_hd__fill_2
XTAP_TAPCELL_ROW_48_888 VGND VPWR sky130_fd_sc_hd__tapvpwrvgnd_1
XTAP_TAPCELL_ROW_48_877 VGND VPWR sky130_fd_sc_hd__tapvpwrvgnd_1
X_4920_ registers\[24\]\[3\] registers\[25\]\[3\] registers\[26\]\[3\] registers\[27\]\[3\]
+ _1678_ _1679_ VGND VGND VPWR VPWR _1685_ sky130_fd_sc_hd__mux4_1
XANTENNA__8054__S _3959_ VGND VGND VPWR VPWR sky130_fd_sc_hd__diode_2
XANTENNA__7908__A0 _3110_ VGND VGND VPWR VPWR sky130_fd_sc_hd__diode_2
XFILLER_0_35_77 VGND VGND VPWR VPWR sky130_fd_sc_hd__fill_2
X_4851_ registers\[20\]\[0\] registers\[21\]\[0\] registers\[22\]\[0\] registers\[23\]\[0\]
+ _1617_ _1618_ VGND VGND VPWR VPWR _1619_ sky130_fd_sc_hd__mux4_1
XANTENNA__7893__S _3876_ VGND VGND VPWR VPWR sky130_fd_sc_hd__diode_2
XANTENNA__4817__S0 _1390_ VGND VGND VPWR VPWR sky130_fd_sc_hd__diode_2
XFILLER_0_28_632 VGND VGND VPWR VPWR sky130_fd_sc_hd__fill_2
XFILLER_0_51_65 VGND VGND VPWR VPWR sky130_fd_sc_hd__fill_2
X_4782_ _1552_ _1553_ _1513_ VGND VGND VPWR VPWR _1554_ sky130_fd_sc_hd__mux2_1
X_7570_ _3708_ VGND VGND VPWR VPWR _0206_ sky130_fd_sc_hd__clkbuf_1
XANTENNA__7136__A1 _3470_ VGND VGND VPWR VPWR sky130_fd_sc_hd__diode_2
X_6521_ net39 VGND VGND VPWR VPWR _3131_ sky130_fd_sc_hd__clkbuf_2
XFILLER_0_15_315 VGND VGND VPWR VPWR sky130_fd_sc_hd__decap_4
XANTENNA__6302__S _2983_ VGND VGND VPWR VPWR sky130_fd_sc_hd__diode_2
X_6452_ _3084_ VGND VGND VPWR VPWR _0736_ sky130_fd_sc_hd__clkbuf_1
X_9240_ clknet_leaf_86_clk _0337_ VGND VGND VPWR VPWR registers\[26\]\[24\] sky130_fd_sc_hd__dfxtp_1
XFILLER_0_15_359 VGND VGND VPWR VPWR sky130_fd_sc_hd__fill_1
XFILLER_0_113_545 VGND VGND VPWR VPWR sky130_fd_sc_hd__fill_2
Xclkload41 clknet_leaf_24_clk VGND VGND VPWR VPWR clkload41/Y sky130_fd_sc_hd__bufinv_16
Xclkload52 clknet_leaf_17_clk VGND VGND VPWR VPWR clkload52/Y sky130_fd_sc_hd__bufinv_16
XANTENNA__6895__A0 _3087_ VGND VGND VPWR VPWR sky130_fd_sc_hd__diode_2
XANTENNA__5242__S0 _1690_ VGND VGND VPWR VPWR sky130_fd_sc_hd__diode_2
X_9171_ clknet_leaf_66_clk _0268_ VGND VGND VPWR VPWR registers\[24\]\[19\] sky130_fd_sc_hd__dfxtp_1
X_5403_ _2139_ _2142_ _2019_ VGND VGND VPWR VPWR _2143_ sky130_fd_sc_hd__mux2_1
Xclkload30 clknet_leaf_100_clk VGND VGND VPWR VPWR clkload30/Y sky130_fd_sc_hd__bufinv_16
Xclkload96 clknet_leaf_54_clk VGND VGND VPWR VPWR clkload96/Y sky130_fd_sc_hd__bufinv_16
XFILLER_0_113_589 VGND VGND VPWR VPWR sky130_fd_sc_hd__decap_3
XFILLER_0_101_729 VGND VGND VPWR VPWR sky130_fd_sc_hd__fill_1
XFILLER_0_101_707 VGND VGND VPWR VPWR sky130_fd_sc_hd__decap_6
X_6383_ _3043_ VGND VGND VPWR VPWR _0708_ sky130_fd_sc_hd__clkbuf_1
XANTENNA__4370__A1 _1159_ VGND VGND VPWR VPWR sky130_fd_sc_hd__diode_2
Xclkload85 clknet_leaf_73_clk VGND VGND VPWR VPWR clkload85/Y sky130_fd_sc_hd__inv_6
Xclkload63 clknet_leaf_88_clk VGND VGND VPWR VPWR clkload63/Y sky130_fd_sc_hd__clkinvlp_2
X_8122_ _3014_ registers\[30\]\[25\] _3995_ VGND VGND VPWR VPWR _4001_ sky130_fd_sc_hd__mux2_1
Xclkload74 clknet_leaf_78_clk VGND VGND VPWR VPWR clkload74/Y sky130_fd_sc_hd__clkinvlp_4
X_5334_ _2026_ _2077_ VGND VGND VPWR VPWR _2078_ sky130_fd_sc_hd__nor2_1
XFILLER_0_11_554 VGND VGND VPWR VPWR sky130_fd_sc_hd__fill_2
XANTENNA__8229__S _4056_ VGND VGND VPWR VPWR sky130_fd_sc_hd__diode_2
XANTENNA__7133__S _3456_ VGND VGND VPWR VPWR sky130_fd_sc_hd__diode_2
XANTENNA_clkbuf_4_1_0_clk_A clknet_0_clk VGND VGND VPWR VPWR sky130_fd_sc_hd__diode_2
X_8053_ _3964_ VGND VGND VPWR VPWR _0433_ sky130_fd_sc_hd__clkbuf_1
X_5265_ registers\[20\]\[21\] registers\[21\]\[21\] registers\[22\]\[21\] registers\[23\]\[21\]
+ _1968_ _1969_ VGND VGND VPWR VPWR _2012_ sky130_fd_sc_hd__mux4_1
X_5196_ registers\[28\]\[17\] registers\[29\]\[17\] registers\[30\]\[17\] registers\[31\]\[17\]
+ _1757_ _1814_ VGND VGND VPWR VPWR _1947_ sky130_fd_sc_hd__mux4_1
X_7004_ _3127_ registers\[14\]\[28\] _3383_ VGND VGND VPWR VPWR _3392_ sky130_fd_sc_hd__mux2_1
X_8955_ clknet_leaf_102_clk _0052_ VGND VGND VPWR VPWR registers\[17\]\[27\] sky130_fd_sc_hd__dfxtp_1
XTAP_TAPCELL_ROW_104_1614 VGND VPWR sky130_fd_sc_hd__tapvpwrvgnd_1
X_7906_ _3886_ VGND VGND VPWR VPWR _0364_ sky130_fd_sc_hd__clkbuf_1
X_8886_ clknet_leaf_95_clk _1007_ VGND VGND VPWR VPWR registers\[15\]\[22\] sky130_fd_sc_hd__dfxtp_1
X_7837_ _3108_ registers\[26\]\[19\] _3840_ VGND VGND VPWR VPWR _3850_ sky130_fd_sc_hd__mux2_1
XFILLER_0_93_557 VGND VGND VPWR VPWR sky130_fd_sc_hd__decap_3
XFILLER_0_19_621 VGND VGND VPWR VPWR sky130_fd_sc_hd__decap_4
XFILLER_0_108_339 VGND VGND VPWR VPWR sky130_fd_sc_hd__fill_2
X_7768_ _3813_ VGND VGND VPWR VPWR _0299_ sky130_fd_sc_hd__clkbuf_1
XFILLER_0_73_281 VGND VGND VPWR VPWR sky130_fd_sc_hd__fill_2
X_9507_ clknet_leaf_22_clk _0604_ VGND VGND VPWR VPWR registers\[8\]\[3\] sky130_fd_sc_hd__dfxtp_1
X_7699_ registers\[24\]\[18\] _3472_ _3768_ VGND VGND VPWR VPWR _3777_ sky130_fd_sc_hd__mux2_1
X_6719_ registers\[10\]\[23\] _3010_ _3236_ VGND VGND VPWR VPWR _3240_ sky130_fd_sc_hd__mux2_1
Xclkload2 clknet_4_3_0_clk VGND VGND VPWR VPWR clkload2/Y sky130_fd_sc_hd__inv_6
XFILLER_0_19_698 VPWR VGND VPWR VGND sky130_ef_sc_hd__decap_12
XFILLER_0_116_350 VGND VGND VPWR VPWR sky130_fd_sc_hd__fill_2
XANTENNA__5617__A _1070_ VGND VGND VPWR VPWR sky130_fd_sc_hd__diode_2
XFILLER_0_61_443 VGND VGND VPWR VPWR sky130_fd_sc_hd__decap_4
X_9438_ clknet_leaf_11_clk _0535_ VGND VGND VPWR VPWR registers\[6\]\[30\] sky130_fd_sc_hd__dfxtp_1
XANTENNA__7308__S _3561_ VGND VGND VPWR VPWR sky130_fd_sc_hd__diode_2
XANTENNA__5689__A1 _1049_ VGND VGND VPWR VPWR sky130_fd_sc_hd__diode_2
XTAP_TAPCELL_ROW_115_1754 VGND VPWR sky130_fd_sc_hd__tapvpwrvgnd_1
XFILLER_0_104_589 VGND VGND VPWR VPWR sky130_fd_sc_hd__fill_2
X_9369_ clknet_leaf_81_clk _0466_ VGND VGND VPWR VPWR registers\[30\]\[25\] sky130_fd_sc_hd__dfxtp_1
XANTENNA__7978__S _3923_ VGND VGND VPWR VPWR sky130_fd_sc_hd__diode_2
XTAP_TAPCELL_ROW_66_1119 VGND VPWR sky130_fd_sc_hd__tapvpwrvgnd_1
XFILLER_0_84_513 VGND VGND VPWR VPWR sky130_fd_sc_hd__fill_2
XTAP_TAPCELL_ROW_45_847 VGND VPWR sky130_fd_sc_hd__tapvpwrvgnd_1
XFILLER_0_96_384 VGND VGND VPWR VPWR sky130_fd_sc_hd__decap_3
XFILLER_0_72_719 VGND VGND VPWR VPWR sky130_fd_sc_hd__fill_2
XTAP_TAPCELL_ROW_25_582 VGND VPWR sky130_fd_sc_hd__tapvpwrvgnd_1
XFILLER_0_25_602 VGND VGND VPWR VPWR sky130_fd_sc_hd__decap_6
XANTENNA__7118__A1 _3458_ VGND VGND VPWR VPWR sky130_fd_sc_hd__diode_2
XFILLER_0_52_421 VGND VGND VPWR VPWR sky130_fd_sc_hd__fill_2
XFILLER_0_37_484 VGND VGND VPWR VPWR sky130_fd_sc_hd__fill_1
XFILLER_0_25_613 VGND VGND VPWR VPWR sky130_fd_sc_hd__decap_3
XFILLER_0_115_7 VGND VGND VPWR VPWR sky130_fd_sc_hd__fill_2
XFILLER_0_114_309 VGND VGND VPWR VPWR sky130_fd_sc_hd__fill_1
XFILLER_0_107_361 VGND VGND VPWR VPWR sky130_fd_sc_hd__fill_2
XFILLER_0_25_657 VGND VGND VPWR VPWR sky130_fd_sc_hd__fill_2
XFILLER_0_25_668 VGND VGND VPWR VPWR sky130_fd_sc_hd__fill_2
XFILLER_0_52_487 VGND VGND VPWR VPWR sky130_fd_sc_hd__fill_2
XANTENNA__5224__S0 _1758_ VGND VGND VPWR VPWR sky130_fd_sc_hd__diode_2
XANTENNA__6877__A0 _3065_ VGND VGND VPWR VPWR sky130_fd_sc_hd__diode_2
XFILLER_0_97_39 VGND VGND VPWR VPWR sky130_fd_sc_hd__fill_1
XTAP_TAPCELL_ROW_77_1259 VGND VPWR sky130_fd_sc_hd__tapvpwrvgnd_1
XFILLER_0_0_713 VPWR VGND VPWR VGND sky130_ef_sc_hd__decap_12
XFILLER_0_24_189 VGND VGND VPWR VPWR sky130_fd_sc_hd__fill_1
XTAP_TAPCELL_ROW_90_1426 VGND VPWR sky130_fd_sc_hd__tapvpwrvgnd_1
XANTENNA__6358__A _3029_ VGND VGND VPWR VPWR sky130_fd_sc_hd__diode_2
X_5050_ _1705_ VGND VGND VPWR VPWR _1810_ sky130_fd_sc_hd__clkbuf_8
XANTENNA_clkbuf_leaf_41_clk_A clknet_4_7_0_clk VGND VGND VPWR VPWR sky130_fd_sc_hd__diode_2
XANTENNA__5301__B1 _1702_ VGND VGND VPWR VPWR sky130_fd_sc_hd__diode_2
XANTENNA__7054__A0 _3108_ VGND VGND VPWR VPWR sky130_fd_sc_hd__diode_2
XFILLER_0_46_54 VGND VGND VPWR VPWR sky130_fd_sc_hd__fill_2
XANTENNA_clkbuf_leaf_56_clk_A clknet_4_15_0_clk VGND VGND VPWR VPWR sky130_fd_sc_hd__diode_2
X_8740_ clknet_leaf_30_clk _0861_ VGND VGND VPWR VPWR registers\[11\]\[4\] sky130_fd_sc_hd__dfxtp_1
X_5952_ _2399_ _2666_ _2670_ _2560_ _2673_ VGND VGND VPWR VPWR net54 sky130_fd_sc_hd__o221ai_2
XTAP_TAPCELL_ROW_88_1399 VGND VPWR sky130_fd_sc_hd__tapvpwrvgnd_1
XANTENNA__4606__A _1381_ VGND VGND VPWR VPWR sky130_fd_sc_hd__diode_2
X_4903_ _1621_ _1668_ VGND VGND VPWR VPWR _1669_ sky130_fd_sc_hd__or2_1
X_5883_ _2560_ _2608_ VGND VGND VPWR VPWR _2609_ sky130_fd_sc_hd__nor2_1
XANTENNA__7357__A1 _3472_ VGND VGND VPWR VPWR sky130_fd_sc_hd__diode_2
X_8671_ clknet_leaf_99_clk _0792_ VGND VGND VPWR VPWR registers\[7\]\[31\] sky130_fd_sc_hd__dfxtp_1
X_7622_ _3098_ registers\[23\]\[14\] _3731_ VGND VGND VPWR VPWR _3736_ sky130_fd_sc_hd__mux2_1
XFILLER_0_7_312 VGND VGND VPWR VPWR sky130_fd_sc_hd__decap_4
X_4834_ registers\[16\]\[31\] registers\[17\]\[31\] registers\[18\]\[31\] registers\[19\]\[31\]
+ _1555_ _1556_ VGND VGND VPWR VPWR _1603_ sky130_fd_sc_hd__mux4_1
XFILLER_0_117_158 VGND VGND VPWR VPWR sky130_fd_sc_hd__fill_1
X_7553_ _3699_ VGND VGND VPWR VPWR _0198_ sky130_fd_sc_hd__clkbuf_1
XFILLER_0_90_527 VGND VGND VPWR VPWR sky130_fd_sc_hd__fill_2
X_4765_ registers\[24\]\[27\] registers\[25\]\[27\] registers\[26\]\[27\] registers\[27\]\[27\]
+ _1390_ _1391_ VGND VGND VPWR VPWR _1538_ sky130_fd_sc_hd__mux4_1
XANTENNA__4341__A _1127_ VGND VGND VPWR VPWR sky130_fd_sc_hd__diode_2
XFILLER_0_55_281 VGND VGND VPWR VPWR sky130_fd_sc_hd__fill_2
XANTENNA__5437__A _1856_ VGND VGND VPWR VPWR sky130_fd_sc_hd__diode_2
X_6504_ _3119_ registers\[29\]\[24\] _3111_ VGND VGND VPWR VPWR _3120_ sky130_fd_sc_hd__mux2_1
X_7484_ _3096_ registers\[21\]\[13\] _3659_ VGND VGND VPWR VPWR _3663_ sky130_fd_sc_hd__mux2_1
XFILLER_0_102_70 VGND VGND VPWR VPWR sky130_fd_sc_hd__decap_4
X_9223_ clknet_leaf_23_clk _0320_ VGND VGND VPWR VPWR registers\[26\]\[7\] sky130_fd_sc_hd__dfxtp_1
XFILLER_0_70_262 VGND VGND VPWR VPWR sky130_fd_sc_hd__decap_4
XANTENNA__5215__S0 _1820_ VGND VGND VPWR VPWR sky130_fd_sc_hd__diode_2
XFILLER_0_30_104 VGND VGND VPWR VPWR sky130_fd_sc_hd__fill_2
X_4696_ registers\[24\]\[23\] registers\[25\]\[23\] registers\[26\]\[23\] registers\[27\]\[23\]
+ _1323_ _1324_ VGND VGND VPWR VPWR _1473_ sky130_fd_sc_hd__mux4_1
XANTENNA__6967__S _3372_ VGND VGND VPWR VPWR sky130_fd_sc_hd__diode_2
XFILLER_0_3_551 VGND VGND VPWR VPWR sky130_fd_sc_hd__decap_6
XFILLER_0_24_690 VGND VGND VPWR VPWR sky130_fd_sc_hd__fill_2
X_6435_ net38 VGND VGND VPWR VPWR _3073_ sky130_fd_sc_hd__clkbuf_2
X_6366_ _3034_ VGND VGND VPWR VPWR _0700_ sky130_fd_sc_hd__clkbuf_1
XFILLER_0_3_595 VGND VGND VPWR VPWR sky130_fd_sc_hd__fill_2
X_9154_ clknet_leaf_0_clk _0251_ VGND VGND VPWR VPWR registers\[24\]\[2\] sky130_fd_sc_hd__dfxtp_1
X_8105_ _2997_ registers\[30\]\[17\] _3984_ VGND VGND VPWR VPWR _3992_ sky130_fd_sc_hd__mux2_1
XFILLER_0_101_559 VGND VGND VPWR VPWR sky130_fd_sc_hd__fill_1
X_5317_ _2060_ _2061_ _1695_ VGND VGND VPWR VPWR _2062_ sky130_fd_sc_hd__mux2_1
X_9085_ clknet_leaf_104_clk _0182_ VGND VGND VPWR VPWR registers\[21\]\[29\] sky130_fd_sc_hd__dfxtp_1
X_6297_ _2988_ VGND VGND VPWR VPWR _0677_ sky130_fd_sc_hd__clkbuf_1
XANTENNA__6096__A1 _2267_ VGND VGND VPWR VPWR sky130_fd_sc_hd__diode_2
X_8036_ _3955_ VGND VGND VPWR VPWR _0425_ sky130_fd_sc_hd__clkbuf_1
XTAP_TAPCELL_ROW_110_1684 VGND VPWR sky130_fd_sc_hd__tapvpwrvgnd_1
X_5248_ _1773_ VGND VGND VPWR VPWR _1996_ sky130_fd_sc_hd__buf_4
XANTENNA__7798__S _3829_ VGND VGND VPWR VPWR sky130_fd_sc_hd__diode_2
XTAP_TAPCELL_ROW_110_1695 VGND VPWR sky130_fd_sc_hd__tapvpwrvgnd_1
XANTENNA__5900__A _1882_ VGND VGND VPWR VPWR sky130_fd_sc_hd__diode_2
X_5179_ registers\[28\]\[16\] registers\[29\]\[16\] registers\[30\]\[16\] registers\[31\]\[16\]
+ _1763_ _1765_ VGND VGND VPWR VPWR _1931_ sky130_fd_sc_hd__mux4_1
XFILLER_0_97_126 VGND VGND VPWR VPWR sky130_fd_sc_hd__fill_2
X_8938_ clknet_leaf_37_clk _0035_ VGND VGND VPWR VPWR registers\[17\]\[10\] sky130_fd_sc_hd__dfxtp_1
XANTENNA__4516__A _1302_ VGND VGND VPWR VPWR sky130_fd_sc_hd__diode_2
XTAP_TAPCELL_ROW_3_299 VGND VPWR sky130_fd_sc_hd__tapvpwrvgnd_1
XFILLER_0_78_362 VGND VGND VPWR VPWR sky130_fd_sc_hd__fill_2
X_8869_ clknet_leaf_29_clk _0990_ VGND VGND VPWR VPWR registers\[15\]\[5\] sky130_fd_sc_hd__dfxtp_1
XFILLER_0_93_321 VGND VGND VPWR VPWR sky130_fd_sc_hd__fill_2
XTAP_TAPCELL_ROW_42_806 VGND VPWR sky130_fd_sc_hd__tapvpwrvgnd_1
XANTENNA__8422__S _4153_ VGND VGND VPWR VPWR sky130_fd_sc_hd__diode_2
XFILLER_0_109_637 VGND VGND VPWR VPWR sky130_fd_sc_hd__decap_4
XFILLER_0_109_626 VGND VGND VPWR VPWR sky130_fd_sc_hd__decap_4
XFILLER_0_93_365 VGND VGND VPWR VPWR sky130_fd_sc_hd__fill_2
XTAP_TAPCELL_ROW_61_1049 VGND VPWR sky130_fd_sc_hd__tapvpwrvgnd_1
XANTENNA__4257__S1 _1054_ VGND VGND VPWR VPWR sky130_fd_sc_hd__diode_2
XTAP_TAPCELL_ROW_22_541 VGND VPWR sky130_fd_sc_hd__tapvpwrvgnd_1
XANTENNA__7038__S _3409_ VGND VGND VPWR VPWR sky130_fd_sc_hd__diode_2
XFILLER_0_81_549 VGND VGND VPWR VPWR sky130_fd_sc_hd__decap_3
XFILLER_0_61_262 VGND VGND VPWR VPWR sky130_fd_sc_hd__fill_2
XFILLER_0_22_605 VGND VGND VPWR VPWR sky130_fd_sc_hd__fill_1
XFILLER_0_21_126 VGND VGND VPWR VPWR sky130_fd_sc_hd__fill_2
XANTENNA__6877__S _3324_ VGND VGND VPWR VPWR sky130_fd_sc_hd__diode_2
XANTENNA__4397__S _1117_ VGND VGND VPWR VPWR sky130_fd_sc_hd__diode_2
XANTENNA__6087__A1 _2034_ VGND VGND VPWR VPWR sky130_fd_sc_hd__diode_2
XTAP_TAPCELL_ROW_72_1189 VGND VPWR sky130_fd_sc_hd__tapvpwrvgnd_1
XANTENNA_output138_A net138 VGND VGND VPWR VPWR sky130_fd_sc_hd__diode_2
XANTENNA__7501__S _3670_ VGND VGND VPWR VPWR sky130_fd_sc_hd__diode_2
XFILLER_0_88_115 VGND VGND VPWR VPWR sky130_fd_sc_hd__fill_2
XFILLER_0_57_513 VGND VGND VPWR VPWR sky130_fd_sc_hd__fill_1
XFILLER_0_84_365 VGND VGND VPWR VPWR sky130_fd_sc_hd__decap_3
XANTENNA__8332__S _4103_ VGND VGND VPWR VPWR sky130_fd_sc_hd__diode_2
XANTENNA__6641__A _3174_ VGND VGND VPWR VPWR sky130_fd_sc_hd__diode_2
XFILLER_0_108_670 VGND VGND VPWR VPWR sky130_fd_sc_hd__fill_2
XANTENNA__4573__A1 _1109_ VGND VGND VPWR VPWR sky130_fd_sc_hd__diode_2
XFILLER_0_37_281 VGND VGND VPWR VPWR sky130_fd_sc_hd__decap_3
XFILLER_0_4_304 VGND VGND VPWR VPWR sky130_fd_sc_hd__fill_2
XFILLER_0_25_432 VGND VGND VPWR VPWR sky130_fd_sc_hd__fill_1
XFILLER_0_114_128 VGND VGND VPWR VPWR sky130_fd_sc_hd__decap_3
XFILLER_0_108_692 VGND VGND VPWR VPWR sky130_fd_sc_hd__decap_8
XFILLER_0_106_3 VGND VGND VPWR VPWR sky130_fd_sc_hd__decap_8
X_4550_ _1333_ _1334_ _1131_ VGND VGND VPWR VPWR _1335_ sky130_fd_sc_hd__mux2_1
XFILLER_0_52_262 VGND VGND VPWR VPWR sky130_fd_sc_hd__fill_2
XFILLER_0_52_251 VGND VGND VPWR VPWR sky130_fd_sc_hd__fill_1
XFILLER_0_40_402 VGND VGND VPWR VPWR sky130_fd_sc_hd__fill_1
X_4481_ _1073_ _1261_ _1269_ VGND VGND VPWR VPWR _1270_ sky130_fd_sc_hd__o21ai_4
XANTENNA__6787__S _3272_ VGND VGND VPWR VPWR sky130_fd_sc_hd__diode_2
XFILLER_0_25_498 VGND VGND VPWR VPWR sky130_fd_sc_hd__decap_3
X_6220_ _2298_ _2850_ _2926_ VGND VGND VPWR VPWR _2927_ sky130_fd_sc_hd__a21oi_1
X_6151_ _2762_ _2793_ _2308_ VGND VGND VPWR VPWR _2861_ sky130_fd_sc_hd__mux2_1
XANTENNA__4420__S1 _1054_ VGND VGND VPWR VPWR sky130_fd_sc_hd__diode_2
XFILLER_0_21_682 VGND VGND VPWR VPWR sky130_fd_sc_hd__fill_1
X_5102_ registers\[12\]\[11\] registers\[13\]\[11\] registers\[14\]\[11\] registers\[15\]\[11\]
+ _1773_ _1775_ VGND VGND VPWR VPWR _1859_ sky130_fd_sc_hd__mux4_1
XFILLER_0_57_31 VGND VGND VPWR VPWR sky130_fd_sc_hd__fill_2
XFILLER_0_0_598 VGND VGND VPWR VPWR sky130_fd_sc_hd__fill_1
XFILLER_0_20_192 VGND VGND VPWR VPWR sky130_fd_sc_hd__fill_2
X_6082_ _2498_ _2795_ VGND VGND VPWR VPWR _2796_ sky130_fd_sc_hd__or2_1
XANTENNA__8507__S _4200_ VGND VGND VPWR VPWR sky130_fd_sc_hd__diode_2
X_5033_ _1792_ _1793_ _1682_ VGND VGND VPWR VPWR _1794_ sky130_fd_sc_hd__mux2_1
XANTENNA__4336__A _1131_ VGND VGND VPWR VPWR sky130_fd_sc_hd__diode_2
X_6984_ _3381_ VGND VGND VPWR VPWR _0971_ sky130_fd_sc_hd__clkbuf_1
XTAP_TAPCELL_ROW_0_247 VGND VPWR sky130_fd_sc_hd__tapvpwrvgnd_1
XTAP_TAPCELL_ROW_0_258 VGND VPWR sky130_fd_sc_hd__tapvpwrvgnd_1
XANTENNA__4487__S1 _1168_ VGND VGND VPWR VPWR sky130_fd_sc_hd__diode_2
X_5935_ _2422_ _2649_ _2657_ VGND VGND VPWR VPWR net53 sky130_fd_sc_hd__o21a_1
X_8723_ clknet_leaf_15_clk _0844_ VGND VGND VPWR VPWR registers\[10\]\[19\] sky130_fd_sc_hd__dfxtp_1
XFILLER_0_48_546 VGND VGND VPWR VPWR sky130_fd_sc_hd__fill_2
XFILLER_0_48_524 VGND VGND VPWR VPWR sky130_fd_sc_hd__fill_2
XFILLER_0_48_513 VGND VGND VPWR VPWR sky130_fd_sc_hd__fill_2
X_8654_ clknet_leaf_40_clk _0775_ VGND VGND VPWR VPWR registers\[7\]\[14\] sky130_fd_sc_hd__dfxtp_1
XFILLER_0_87_192 VGND VGND VPWR VPWR sky130_fd_sc_hd__decap_3
X_5866_ _1835_ _2575_ _2591_ VGND VGND VPWR VPWR _2592_ sky130_fd_sc_hd__a21oi_1
XFILLER_0_63_505 VGND VGND VPWR VPWR sky130_fd_sc_hd__fill_2
XFILLER_0_36_719 VGND VGND VPWR VPWR sky130_fd_sc_hd__decap_8
X_7605_ _3081_ registers\[23\]\[6\] _3720_ VGND VGND VPWR VPWR _3727_ sky130_fd_sc_hd__mux2_1
XFILLER_0_63_527 VGND VGND VPWR VPWR sky130_fd_sc_hd__decap_3
X_4817_ registers\[16\]\[30\] registers\[17\]\[30\] registers\[18\]\[30\] registers\[19\]\[30\]
+ _1390_ _1391_ VGND VGND VPWR VPWR _1587_ sky130_fd_sc_hd__mux4_1
XANTENNA__5436__S0 _1758_ VGND VGND VPWR VPWR sky130_fd_sc_hd__diode_2
XFILLER_0_7_131 VGND VGND VPWR VPWR sky130_fd_sc_hd__decap_4
XFILLER_0_35_229 VGND VGND VPWR VPWR sky130_fd_sc_hd__fill_1
X_5797_ _2518_ _2524_ _2519_ VGND VGND VPWR VPWR _2526_ sky130_fd_sc_hd__o21ba_1
X_8585_ clknet_leaf_16_clk _0706_ VGND VGND VPWR VPWR registers\[3\]\[9\] sky130_fd_sc_hd__dfxtp_1
XFILLER_0_7_175 VGND VGND VPWR VPWR sky130_fd_sc_hd__fill_1
XFILLER_0_7_164 VGND VGND VPWR VPWR sky130_fd_sc_hd__fill_2
X_7536_ _3690_ VGND VGND VPWR VPWR _0190_ sky130_fd_sc_hd__clkbuf_1
XFILLER_0_71_571 VGND VGND VPWR VPWR sky130_fd_sc_hd__fill_2
X_4748_ registers\[24\]\[26\] registers\[25\]\[26\] registers\[26\]\[26\] registers\[27\]\[26\]
+ _1415_ _1416_ VGND VGND VPWR VPWR _1522_ sky130_fd_sc_hd__mux4_1
XFILLER_0_114_640 VGND VGND VPWR VPWR sky130_fd_sc_hd__decap_4
X_7467_ _3079_ registers\[21\]\[5\] _3648_ VGND VGND VPWR VPWR _3654_ sky130_fd_sc_hd__mux2_1
X_4679_ registers\[16\]\[22\] registers\[17\]\[22\] registers\[18\]\[22\] registers\[19\]\[22\]
+ _1433_ _1434_ VGND VGND VPWR VPWR _1457_ sky130_fd_sc_hd__mux4_1
X_6418_ _3061_ VGND VGND VPWR VPWR _0725_ sky130_fd_sc_hd__clkbuf_1
XPHY_EDGE_ROW_1_Right_1 VGND VGND VPWR VPWR sky130_fd_sc_hd__decap_3
X_9206_ clknet_leaf_94_clk _0303_ VGND VGND VPWR VPWR registers\[25\]\[22\] sky130_fd_sc_hd__dfxtp_1
X_9137_ clknet_leaf_54_clk _0234_ VGND VGND VPWR VPWR registers\[23\]\[17\] sky130_fd_sc_hd__dfxtp_1
XTAP_TAPCELL_ROW_112_1713 VGND VPWR sky130_fd_sc_hd__tapvpwrvgnd_1
X_7398_ _3617_ VGND VGND VPWR VPWR _0125_ sky130_fd_sc_hd__clkbuf_1
XFILLER_0_12_682 VGND VGND VPWR VPWR sky130_fd_sc_hd__fill_2
Xoutput59 net59 VGND VGND VPWR VPWR alu_result[19] sky130_fd_sc_hd__buf_1
XTAP_TAPCELL_ROW_8_369 VGND VPWR sky130_fd_sc_hd__tapvpwrvgnd_1
XTAP_TAPCELL_ROW_8_358 VGND VPWR sky130_fd_sc_hd__tapvpwrvgnd_1
X_6349_ _3023_ VGND VGND VPWR VPWR _0694_ sky130_fd_sc_hd__clkbuf_1
X_9068_ clknet_leaf_43_clk _0165_ VGND VGND VPWR VPWR registers\[21\]\[12\] sky130_fd_sc_hd__dfxtp_1
XANTENNA__4945__S _1627_ VGND VGND VPWR VPWR sky130_fd_sc_hd__diode_2
X_8019_ _3946_ VGND VGND VPWR VPWR _0417_ sky130_fd_sc_hd__clkbuf_1
XTAP_TAPCELL_ROW_27_611 VGND VPWR sky130_fd_sc_hd__tapvpwrvgnd_1
XFILLER_0_79_660 VGND VGND VPWR VPWR sky130_fd_sc_hd__fill_2
XANTENNA__4478__S1 _1203_ VGND VGND VPWR VPWR sky130_fd_sc_hd__diode_2
XANTENNA__6241__B2 _2399_ VGND VGND VPWR VPWR sky130_fd_sc_hd__diode_2
XTAP_TAPCELL_ROW_55_975 VGND VPWR sky130_fd_sc_hd__tapvpwrvgnd_1
XFILLER_0_39_513 VGND VGND VPWR VPWR sky130_fd_sc_hd__fill_2
XANTENNA__8152__S _4009_ VGND VGND VPWR VPWR sky130_fd_sc_hd__diode_2
XFILLER_0_94_663 VGND VGND VPWR VPWR sky130_fd_sc_hd__decap_3
XFILLER_0_39_557 VGND VGND VPWR VPWR sky130_fd_sc_hd__fill_1
XFILLER_0_109_445 VGND VGND VPWR VPWR sky130_fd_sc_hd__decap_3
Xclkbuf_leaf_51_clk clknet_4_13_0_clk VGND VGND VPWR VPWR clknet_leaf_51_clk sky130_fd_sc_hd__clkbuf_8
XFILLER_0_54_527 VGND VGND VPWR VPWR sky130_fd_sc_hd__decap_3
XANTENNA__5077__A _1835_ VGND VGND VPWR VPWR sky130_fd_sc_hd__diode_2
XFILLER_0_81_379 VGND VGND VPWR VPWR sky130_fd_sc_hd__decap_8
XFILLER_0_111_109 VGND VGND VPWR VPWR sky130_fd_sc_hd__decap_3
XFILLER_0_105_651 VGND VGND VPWR VPWR sky130_fd_sc_hd__fill_1
XFILLER_0_105_640 VGND VGND VPWR VPWR sky130_fd_sc_hd__decap_3
XFILLER_0_78_19 VGND VGND VPWR VPWR sky130_fd_sc_hd__fill_2
XFILLER_0_22_413 VGND VGND VPWR VPWR sky130_fd_sc_hd__fill_1
XANTENNA__4650__S1 _1428_ VGND VGND VPWR VPWR sky130_fd_sc_hd__diode_2
XFILLER_0_34_295 VGND VGND VPWR VPWR sky130_fd_sc_hd__fill_2
XFILLER_0_105_695 VGND VGND VPWR VPWR sky130_fd_sc_hd__decap_4
XFILLER_0_105_673 VGND VGND VPWR VPWR sky130_fd_sc_hd__fill_2
XTAP_TAPCELL_ROW_74_1218 VGND VPWR sky130_fd_sc_hd__tapvpwrvgnd_1
XFILLER_0_22_457 VGND VGND VPWR VPWR sky130_fd_sc_hd__fill_2
XFILLER_0_104_194 VGND VGND VPWR VPWR sky130_fd_sc_hd__fill_2
XFILLER_0_94_29 VGND VGND VPWR VPWR sky130_fd_sc_hd__fill_2
XANTENNA__5807__A1 _2295_ VGND VGND VPWR VPWR sky130_fd_sc_hd__diode_2
XANTENNA__5761__A1_N _2490_ VGND VGND VPWR VPWR sky130_fd_sc_hd__diode_2
XFILLER_0_27_45 VGND VGND VPWR VPWR sky130_fd_sc_hd__decap_4
XANTENNA__5540__A net15 VGND VGND VPWR VPWR sky130_fd_sc_hd__diode_2
XFILLER_0_119_209 VPWR VGND VPWR VGND sky130_ef_sc_hd__decap_12
XANTENNA__4469__S1 _1203_ VGND VGND VPWR VPWR sky130_fd_sc_hd__diode_2
XTAP_TAPCELL_ROW_85_1369 VGND VPWR sky130_fd_sc_hd__tapvpwrvgnd_1
XTAP_TAPCELL_ROW_85_1358 VGND VPWR sky130_fd_sc_hd__tapvpwrvgnd_1
XFILLER_0_69_181 VGND VGND VPWR VPWR sky130_fd_sc_hd__fill_2
XFILLER_0_43_55 VGND VGND VPWR VPWR sky130_fd_sc_hd__fill_1
X_5720_ _2339_ _2348_ _2352_ VGND VGND VPWR VPWR _2453_ sky130_fd_sc_hd__mux2_1
XFILLER_0_85_663 VGND VGND VPWR VPWR sky130_fd_sc_hd__decap_6
XANTENNA__8062__S _3959_ VGND VGND VPWR VPWR sky130_fd_sc_hd__diode_2
Xclkbuf_leaf_42_clk clknet_4_6_0_clk VGND VGND VPWR VPWR clknet_leaf_42_clk sky130_fd_sc_hd__clkbuf_8
XFILLER_0_45_505 VGND VGND VPWR VPWR sky130_fd_sc_hd__fill_2
XANTENNA__5418__S0 _2097_ VGND VGND VPWR VPWR sky130_fd_sc_hd__diode_2
XFILLER_0_84_195 VGND VGND VPWR VPWR sky130_fd_sc_hd__fill_1
X_5651_ _2385_ VGND VGND VPWR VPWR _2386_ sky130_fd_sc_hd__inv_2
XFILLER_0_45_549 VGND VGND VPWR VPWR sky130_fd_sc_hd__fill_2
X_5582_ _2269_ _2270_ _2316_ _2317_ VGND VGND VPWR VPWR _2318_ sky130_fd_sc_hd__a31o_1
X_8370_ _4132_ VGND VGND VPWR VPWR _0582_ sky130_fd_sc_hd__clkbuf_1
XANTENNA__5743__B1 _2394_ VGND VGND VPWR VPWR sky130_fd_sc_hd__diode_2
XFILLER_0_60_508 VGND VGND VPWR VPWR sky130_fd_sc_hd__fill_2
X_4602_ registers\[8\]\[18\] registers\[9\]\[18\] registers\[10\]\[18\] registers\[11\]\[18\]
+ _1382_ _1383_ VGND VGND VPWR VPWR _1384_ sky130_fd_sc_hd__mux4_1
XFILLER_0_4_101 VGND VGND VPWR VPWR sky130_fd_sc_hd__fill_2
XFILLER_0_25_240 VGND VGND VPWR VPWR sky130_fd_sc_hd__fill_1
X_4533_ _1143_ _1306_ _1310_ _1314_ _1318_ VGND VGND VPWR VPWR _1319_ sky130_fd_sc_hd__a32o_4
XFILLER_0_87_7 VGND VGND VPWR VPWR sky130_fd_sc_hd__fill_1
XFILLER_0_41_711 VPWR VGND VPWR VGND sky130_ef_sc_hd__decap_12
X_7321_ _3576_ VGND VGND VPWR VPWR _0089_ sky130_fd_sc_hd__clkbuf_1
XFILLER_0_4_167 VGND VGND VPWR VPWR sky130_fd_sc_hd__fill_2
XANTENNA__6299__A1 _2989_ VGND VGND VPWR VPWR sky130_fd_sc_hd__diode_2
XFILLER_0_80_390 VGND VGND VPWR VPWR sky130_fd_sc_hd__decap_4
XANTENNA__7496__A0 _3108_ VGND VGND VPWR VPWR sky130_fd_sc_hd__diode_2
XFILLER_0_13_457 VGND VGND VPWR VPWR sky130_fd_sc_hd__fill_2
X_7252_ registers\[18\]\[0\] _3433_ _3539_ VGND VGND VPWR VPWR _3540_ sky130_fd_sc_hd__mux2_1
X_4464_ _1073_ _1245_ _1249_ _1253_ VGND VGND VPWR VPWR _1254_ sky130_fd_sc_hd__o22a_2
X_6203_ _2909_ _2910_ VGND VGND VPWR VPWR _2911_ sky130_fd_sc_hd__nor2_1
XFILLER_0_111_698 VGND VGND VPWR VPWR sky130_fd_sc_hd__decap_4
X_4395_ registers\[28\]\[7\] registers\[29\]\[7\] registers\[30\]\[7\] registers\[31\]\[7\]
+ _1125_ _1127_ VGND VGND VPWR VPWR _1188_ sky130_fd_sc_hd__mux4_1
XFILLER_0_68_85 VGND VGND VPWR VPWR sky130_fd_sc_hd__decap_4
X_7183_ _3502_ VGND VGND VPWR VPWR _3503_ sky130_fd_sc_hd__clkbuf_8
XFILLER_0_110_197 VGND VGND VPWR VPWR sky130_fd_sc_hd__fill_2
X_6134_ _2263_ _2587_ _2845_ _2276_ VGND VGND VPWR VPWR _2846_ sky130_fd_sc_hd__o211a_1
XTAP_TAPCELL_ROW_5_328 VGND VPWR sky130_fd_sc_hd__tapvpwrvgnd_1
XANTENNA__8237__S _4056_ VGND VGND VPWR VPWR sky130_fd_sc_hd__diode_2
X_6065_ _2772_ _2777_ VGND VGND VPWR VPWR _2780_ sky130_fd_sc_hd__or2b_1
X_5016_ _1702_ VGND VGND VPWR VPWR _1778_ sky130_fd_sc_hd__buf_4
XFILLER_0_108_80 VGND VGND VPWR VPWR sky130_fd_sc_hd__fill_2
XFILLER_0_67_107 VGND VGND VPWR VPWR sky130_fd_sc_hd__fill_2
X_6967_ _3089_ registers\[14\]\[10\] _3372_ VGND VGND VPWR VPWR _3373_ sky130_fd_sc_hd__mux2_1
XFILLER_0_67_129 VGND VGND VPWR VPWR sky130_fd_sc_hd__fill_2
X_5918_ _2322_ _2638_ _2641_ VGND VGND VPWR VPWR _2642_ sky130_fd_sc_hd__a21oi_1
XFILLER_0_76_630 VGND VGND VPWR VPWR sky130_fd_sc_hd__fill_2
XTAP_TAPCELL_ROW_52_934 VGND VPWR sky130_fd_sc_hd__tapvpwrvgnd_1
X_8706_ clknet_leaf_5_clk _0827_ VGND VGND VPWR VPWR registers\[10\]\[2\] sky130_fd_sc_hd__dfxtp_1
X_6898_ _3089_ registers\[13\]\[10\] _3335_ VGND VGND VPWR VPWR _3336_ sky130_fd_sc_hd__mux2_1
Xclkbuf_leaf_33_clk clknet_4_5_0_clk VGND VGND VPWR VPWR clknet_leaf_33_clk sky130_fd_sc_hd__clkbuf_8
XFILLER_0_48_365 VGND VGND VPWR VPWR sky130_fd_sc_hd__fill_2
XANTENNA__5409__S0 _2072_ VGND VGND VPWR VPWR sky130_fd_sc_hd__diode_2
XFILLER_0_118_253 VGND VGND VPWR VPWR sky130_fd_sc_hd__decap_8
XFILLER_0_91_655 VGND VGND VPWR VPWR sky130_fd_sc_hd__fill_2
XFILLER_0_75_195 VGND VGND VPWR VPWR sky130_fd_sc_hd__decap_4
X_5849_ net112 _2575_ VGND VGND VPWR VPWR _2576_ sky130_fd_sc_hd__xnor2_1
XFILLER_0_8_451 VGND VGND VPWR VPWR sky130_fd_sc_hd__fill_1
XANTENNA__4880__S1 _1643_ VGND VGND VPWR VPWR sky130_fd_sc_hd__diode_2
X_8637_ clknet_leaf_88_clk _0758_ VGND VGND VPWR VPWR registers\[29\]\[29\] sky130_fd_sc_hd__dfxtp_1
XFILLER_0_36_549 VGND VGND VPWR VPWR sky130_fd_sc_hd__decap_4
XFILLER_0_106_448 VGND VGND VPWR VPWR sky130_fd_sc_hd__decap_3
X_8568_ clknet_leaf_85_clk _0689_ VGND VGND VPWR VPWR registers\[19\]\[24\] sky130_fd_sc_hd__dfxtp_1
XFILLER_0_16_251 VGND VGND VPWR VPWR sky130_fd_sc_hd__fill_1
XTAP_TAPCELL_ROW_32_680 VGND VPWR sky130_fd_sc_hd__tapvpwrvgnd_1
XFILLER_0_91_699 VGND VGND VPWR VPWR sky130_fd_sc_hd__fill_2
X_7519_ _3131_ registers\[21\]\[30\] _3647_ VGND VGND VPWR VPWR _3681_ sky130_fd_sc_hd__mux2_1
XFILLER_0_44_593 VGND VGND VPWR VPWR sky130_fd_sc_hd__fill_2
XFILLER_0_44_571 VGND VGND VPWR VPWR sky130_fd_sc_hd__fill_2
XFILLER_0_114_470 VGND VGND VPWR VPWR sky130_fd_sc_hd__fill_2
X_8499_ registers\[4\]\[10\] net17 _4200_ VGND VGND VPWR VPWR _4201_ sky130_fd_sc_hd__mux2_1
XANTENNA__7316__S _3538_ VGND VGND VPWR VPWR sky130_fd_sc_hd__diode_2
XFILLER_0_102_643 VGND VGND VPWR VPWR sky130_fd_sc_hd__fill_1
XANTENNA__8001__A _3936_ VGND VGND VPWR VPWR sky130_fd_sc_hd__diode_2
XFILLER_0_102_676 VGND VGND VPWR VPWR sky130_fd_sc_hd__fill_2
XANTENNA__4396__S0 _1125_ VGND VGND VPWR VPWR sky130_fd_sc_hd__diode_2
XFILLER_0_99_722 VGND VGND VPWR VPWR sky130_fd_sc_hd__decap_3
XFILLER_0_99_711 VGND VGND VPWR VPWR sky130_fd_sc_hd__decap_3
XANTENNA__6456__A net47 VGND VGND VPWR VPWR sky130_fd_sc_hd__diode_2
XANTENNA__4699__S1 _1348_ VGND VGND VPWR VPWR sky130_fd_sc_hd__diode_2
XANTENNA__7986__S _3923_ VGND VGND VPWR VPWR sky130_fd_sc_hd__diode_2
XANTENNA_input14_A alu_op[0] VGND VGND VPWR VPWR sky130_fd_sc_hd__diode_2
XFILLER_0_58_118 VGND VGND VPWR VPWR sky130_fd_sc_hd__fill_1
XFILLER_0_79_490 VGND VGND VPWR VPWR sky130_fd_sc_hd__fill_1
XFILLER_0_67_630 VGND VGND VPWR VPWR sky130_fd_sc_hd__fill_2
XFILLER_0_13_14 VGND VGND VPWR VPWR sky130_fd_sc_hd__fill_1
XANTENNA__4776__A1 _1438_ VGND VGND VPWR VPWR sky130_fd_sc_hd__diode_2
XFILLER_0_94_471 VGND VGND VPWR VPWR sky130_fd_sc_hd__fill_2
Xclkbuf_leaf_24_clk clknet_4_4_0_clk VGND VGND VPWR VPWR clknet_leaf_24_clk sky130_fd_sc_hd__clkbuf_8
XFILLER_0_27_505 VGND VGND VPWR VPWR sky130_fd_sc_hd__fill_2
XFILLER_0_82_633 VGND VGND VPWR VPWR sky130_fd_sc_hd__fill_2
XANTENNA__7714__A1 _3487_ VGND VGND VPWR VPWR sky130_fd_sc_hd__diode_2
XFILLER_0_27_549 VGND VGND VPWR VPWR sky130_fd_sc_hd__fill_2
XFILLER_0_109_275 VGND VGND VPWR VPWR sky130_fd_sc_hd__decap_3
XFILLER_0_82_688 VPWR VGND VPWR VGND sky130_ef_sc_hd__decap_12
XTAP_TAPCELL_ROW_80_1299 VGND VPWR sky130_fd_sc_hd__tapvpwrvgnd_1
XANTENNA__5535__A net14 VGND VGND VPWR VPWR sky130_fd_sc_hd__diode_2
XFILLER_0_62_390 VGND VGND VPWR VPWR sky130_fd_sc_hd__fill_2
XFILLER_0_50_530 VGND VGND VPWR VPWR sky130_fd_sc_hd__fill_2
XANTENNA__7226__S _3525_ VGND VGND VPWR VPWR sky130_fd_sc_hd__diode_2
XFILLER_0_2_638 VGND VGND VPWR VPWR sky130_fd_sc_hd__fill_2
XTAP_TAPCELL_ROW_10_385 VGND VPWR sky130_fd_sc_hd__tapvpwrvgnd_1
XFILLER_0_2_649 VGND VGND VPWR VPWR sky130_fd_sc_hd__decap_4
XFILLER_0_1_137 VPWR VGND VPWR VGND sky130_ef_sc_hd__decap_12
XFILLER_0_10_416 VGND VGND VPWR VPWR sky130_fd_sc_hd__fill_2
XANTENNA__4387__S0 _1136_ VGND VGND VPWR VPWR sky130_fd_sc_hd__diode_2
XANTENNA__6150__B1 _2860_ VGND VGND VPWR VPWR sky130_fd_sc_hd__diode_2
XFILLER_0_22_298 VGND VGND VPWR VPWR sky130_fd_sc_hd__decap_4
XANTENNA__7750__A _3792_ VGND VGND VPWR VPWR sky130_fd_sc_hd__diode_2
XFILLER_0_89_265 VGND VGND VPWR VPWR sky130_fd_sc_hd__fill_2
X_7870_ _3073_ registers\[27\]\[2\] _3865_ VGND VGND VPWR VPWR _3868_ sky130_fd_sc_hd__mux2_1
X_6821_ registers\[12\]\[6\] _2974_ _3288_ VGND VGND VPWR VPWR _3295_ sky130_fd_sc_hd__mux2_1
X_9540_ clknet_leaf_30_clk _0637_ VGND VGND VPWR VPWR registers\[4\]\[4\] sky130_fd_sc_hd__dfxtp_1
X_6752_ _3257_ VGND VGND VPWR VPWR _0863_ sky130_fd_sc_hd__clkbuf_1
XANTENNA__6305__S _2983_ VGND VGND VPWR VPWR sky130_fd_sc_hd__diode_2
Xclkbuf_leaf_15_clk clknet_4_6_0_clk VGND VGND VPWR VPWR clknet_leaf_15_clk sky130_fd_sc_hd__clkbuf_8
XANTENNA__5964__B1 _2276_ VGND VGND VPWR VPWR sky130_fd_sc_hd__diode_2
XFILLER_0_58_685 VGND VGND VPWR VPWR sky130_fd_sc_hd__fill_1
XTAP_TAPCELL_ROW_18_496 VGND VPWR sky130_fd_sc_hd__tapvpwrvgnd_1
XFILLER_0_116_713 VPWR VGND VPWR VGND sky130_ef_sc_hd__decap_12
X_6683_ registers\[10\]\[6\] _2974_ _3214_ VGND VGND VPWR VPWR _3221_ sky130_fd_sc_hd__mux2_1
XFILLER_0_72_110 VGND VGND VPWR VPWR sky130_fd_sc_hd__fill_2
XFILLER_0_70_75 VGND VGND VPWR VPWR sky130_fd_sc_hd__decap_4
X_5703_ _2425_ _2427_ _2435_ VGND VGND VPWR VPWR _2436_ sky130_fd_sc_hd__a21o_1
XFILLER_0_45_335 VGND VGND VPWR VPWR sky130_fd_sc_hd__fill_1
X_9471_ clknet_leaf_2_clk _0568_ VGND VGND VPWR VPWR registers\[31\]\[31\] sky130_fd_sc_hd__dfxtp_1
XANTENNA__4862__S1 _1629_ VGND VGND VPWR VPWR sky130_fd_sc_hd__diode_2
X_8422_ registers\[8\]\[6\] net44 _4153_ VGND VGND VPWR VPWR _4160_ sky130_fd_sc_hd__mux2_1
XFILLER_0_115_223 VGND VGND VPWR VPWR sky130_fd_sc_hd__fill_1
XTAP_TAPCELL_ROW_98_1538 VGND VPWR sky130_fd_sc_hd__tapvpwrvgnd_1
XTAP_TAPCELL_ROW_98_1527 VGND VPWR sky130_fd_sc_hd__tapvpwrvgnd_1
X_5634_ _1995_ _2234_ _2219_ VGND VGND VPWR VPWR _2369_ sky130_fd_sc_hd__o21ai_1
XFILLER_0_5_410 VGND VGND VPWR VPWR sky130_fd_sc_hd__fill_2
XANTENNA__8520__S _4211_ VGND VGND VPWR VPWR sky130_fd_sc_hd__diode_2
X_8353_ _4123_ VGND VGND VPWR VPWR _0574_ sky130_fd_sc_hd__clkbuf_1
XFILLER_0_115_256 VGND VGND VPWR VPWR sky130_fd_sc_hd__fill_2
XFILLER_0_5_432 VGND VGND VPWR VPWR sky130_fd_sc_hd__fill_1
XANTENNA__7136__S _3456_ VGND VGND VPWR VPWR sky130_fd_sc_hd__diode_2
X_5565_ _2299_ _2300_ net113 VGND VGND VPWR VPWR _2301_ sky130_fd_sc_hd__mux2_1
X_7304_ registers\[18\]\[25\] _3487_ _3561_ VGND VGND VPWR VPWR _3567_ sky130_fd_sc_hd__mux2_1
XANTENNA__5445__A _2182_ VGND VGND VPWR VPWR sky130_fd_sc_hd__diode_2
X_8284_ _2972_ registers\[31\]\[5\] _4081_ VGND VGND VPWR VPWR _4087_ sky130_fd_sc_hd__mux2_1
X_5496_ _2231_ _2214_ VGND VGND VPWR VPWR _2232_ sky130_fd_sc_hd__or2_1
X_4516_ _1302_ VGND VGND VPWR VPWR net117 sky130_fd_sc_hd__inv_2
XFILLER_0_41_585 VGND VGND VPWR VPWR sky130_fd_sc_hd__decap_4
XFILLER_0_13_265 VGND VGND VPWR VPWR sky130_fd_sc_hd__decap_4
XANTENNA__6975__S _3372_ VGND VGND VPWR VPWR sky130_fd_sc_hd__diode_2
XANTENNA__4378__S0 _1167_ VGND VGND VPWR VPWR sky130_fd_sc_hd__diode_2
X_4447_ _1236_ _1237_ _1031_ VGND VGND VPWR VPWR _1238_ sky130_fd_sc_hd__mux2_1
X_7235_ _3530_ VGND VGND VPWR VPWR _0049_ sky130_fd_sc_hd__clkbuf_1
XFILLER_0_1_693 VPWR VGND VPWR VGND sky130_ef_sc_hd__decap_12
X_7166_ net35 VGND VGND VPWR VPWR _3491_ sky130_fd_sc_hd__buf_2
X_4378_ registers\[28\]\[6\] registers\[29\]\[6\] registers\[30\]\[6\] registers\[31\]\[6\]
+ _1167_ _1168_ VGND VGND VPWR VPWR _1172_ sky130_fd_sc_hd__mux4_1
XFILLER_0_95_61 VGND VGND VPWR VPWR sky130_fd_sc_hd__fill_2
X_6117_ _2828_ VGND VGND VPWR VPWR _2829_ sky130_fd_sc_hd__inv_2
XANTENNA_input6_A a2[2] VGND VGND VPWR VPWR sky130_fd_sc_hd__diode_2
XFILLER_0_0_192 VGND VGND VPWR VPWR sky130_fd_sc_hd__fill_2
XANTENNA__6276__A net44 VGND VGND VPWR VPWR sky130_fd_sc_hd__diode_2
X_7097_ _3444_ VGND VGND VPWR VPWR _1021_ sky130_fd_sc_hd__clkbuf_1
X_6048_ _2763_ VGND VGND VPWR VPWR _2764_ sky130_fd_sc_hd__inv_2
XTAP_TAPCELL_ROW_107_1656 VGND VPWR sky130_fd_sc_hd__tapvpwrvgnd_1
XTAP_TAPCELL_ROW_107_1645 VGND VPWR sky130_fd_sc_hd__tapvpwrvgnd_1
XFILLER_0_49_652 VGND VGND VPWR VPWR sky130_fd_sc_hd__decap_8
X_7999_ _3935_ VGND VGND VPWR VPWR _0408_ sky130_fd_sc_hd__clkbuf_1
XANTENNA__4524__A _1135_ VGND VGND VPWR VPWR sky130_fd_sc_hd__diode_2
XFILLER_0_95_279 VGND VGND VPWR VPWR sky130_fd_sc_hd__fill_1
XFILLER_0_64_600 VGND VGND VPWR VPWR sky130_fd_sc_hd__fill_1
XANTENNA__4758__A1 _1159_ VGND VGND VPWR VPWR sky130_fd_sc_hd__diode_2
XFILLER_0_119_573 VGND VGND VPWR VPWR sky130_fd_sc_hd__decap_8
XFILLER_0_36_313 VGND VGND VPWR VPWR sky130_fd_sc_hd__fill_2
XFILLER_0_119_584 VGND VGND VPWR VPWR sky130_fd_sc_hd__fill_1
XFILLER_0_64_666 VGND VGND VPWR VPWR sky130_fd_sc_hd__fill_1
XFILLER_0_36_346 VGND VGND VPWR VPWR sky130_fd_sc_hd__fill_1
XFILLER_0_17_593 VGND VGND VPWR VPWR sky130_fd_sc_hd__fill_2
XFILLER_0_106_289 VPWR VGND VPWR VGND sky130_ef_sc_hd__decap_12
XANTENNA__7046__S _3409_ VGND VGND VPWR VPWR sky130_fd_sc_hd__diode_2
XTAP_TAPCELL_ROW_118_1796 VGND VPWR sky130_fd_sc_hd__tapvpwrvgnd_1
XFILLER_0_20_725 VGND VGND VPWR VPWR sky130_fd_sc_hd__decap_3
XANTENNA__6885__S _3324_ VGND VGND VPWR VPWR sky130_fd_sc_hd__diode_2
XANTENNA__7880__A0 _3083_ VGND VGND VPWR VPWR sky130_fd_sc_hd__diode_2
XANTENNA__7632__A0 _3108_ VGND VGND VPWR VPWR sky130_fd_sc_hd__diode_2
XANTENNA_output120_A net120 VGND VGND VPWR VPWR sky130_fd_sc_hd__diode_2
XANTENNA__4541__S0 _1320_ VGND VGND VPWR VPWR sky130_fd_sc_hd__diode_2
XANTENNA__8188__A1 _3485_ VGND VGND VPWR VPWR sky130_fd_sc_hd__diode_2
XTAP_TAPCELL_ROW_35_709 VGND VPWR sky130_fd_sc_hd__tapvpwrvgnd_1
XTAP_TAPCELL_ROW_82_1328 VGND VPWR sky130_fd_sc_hd__tapvpwrvgnd_1
XANTENNA__5097__S1 _1765_ VGND VGND VPWR VPWR sky130_fd_sc_hd__diode_2
XFILLER_0_24_79 VGND VGND VPWR VPWR sky130_fd_sc_hd__decap_3
XFILLER_0_67_482 VGND VGND VPWR VPWR sky130_fd_sc_hd__fill_2
XTAP_TAPCELL_ROW_15_455 VGND VPWR sky130_fd_sc_hd__tapvpwrvgnd_1
XANTENNA__8360__A1 _3453_ VGND VGND VPWR VPWR sky130_fd_sc_hd__diode_2
XFILLER_0_70_625 VGND VGND VPWR VPWR sky130_fd_sc_hd__fill_1
XFILLER_0_54_165 VGND VGND VPWR VPWR sky130_fd_sc_hd__fill_2
XFILLER_0_113_727 VGND VGND VPWR VPWR sky130_fd_sc_hd__fill_1
XFILLER_0_70_669 VGND VGND VPWR VPWR sky130_fd_sc_hd__fill_2
XFILLER_0_50_360 VGND VGND VPWR VPWR sky130_fd_sc_hd__fill_2
XFILLER_0_49_10 VGND VGND VPWR VPWR sky130_fd_sc_hd__fill_2
X_5350_ registers\[8\]\[25\] registers\[9\]\[25\] registers\[10\]\[25\] registers\[11\]\[25\]
+ _2027_ _2028_ VGND VGND VPWR VPWR _2093_ sky130_fd_sc_hd__mux4_1
XFILLER_0_11_714 VPWR VGND VPWR VGND sky130_ef_sc_hd__decap_12
XTAP_TAPCELL_ROW_93_1468 VGND VPWR sky130_fd_sc_hd__tapvpwrvgnd_1
X_4301_ registers\[4\]\[3\] registers\[5\]\[3\] registers\[6\]\[3\] registers\[7\]\[3\]
+ _1026_ _1027_ VGND VGND VPWR VPWR _1098_ sky130_fd_sc_hd__mux4_1
XFILLER_0_50_382 VPWR VGND VPWR VGND sky130_ef_sc_hd__decap_12
X_5281_ _1775_ VGND VGND VPWR VPWR _2028_ sky130_fd_sc_hd__buf_4
XFILLER_0_2_468 VGND VGND VPWR VPWR sky130_fd_sc_hd__decap_8
XFILLER_0_10_213 VGND VGND VPWR VPWR sky130_fd_sc_hd__decap_6
XFILLER_0_10_235 VGND VGND VPWR VPWR sky130_fd_sc_hd__fill_1
XFILLER_0_23_596 VGND VGND VPWR VPWR sky130_fd_sc_hd__decap_8
XANTENNA__6795__S _3272_ VGND VGND VPWR VPWR sky130_fd_sc_hd__diode_2
XANTENNA__5021__S1 _1629_ VGND VGND VPWR VPWR sky130_fd_sc_hd__diode_2
XFILLER_0_49_87 VGND VGND VPWR VPWR sky130_fd_sc_hd__fill_2
X_4232_ _1028_ _1029_ _1031_ VGND VGND VPWR VPWR _1032_ sky130_fd_sc_hd__mux2_1
X_7020_ _3401_ VGND VGND VPWR VPWR _0987_ sky130_fd_sc_hd__clkbuf_1
XANTENNA__4685__B1 _1135_ VGND VGND VPWR VPWR sky130_fd_sc_hd__diode_2
Xclkbuf_leaf_4_clk clknet_4_0_0_clk VGND VGND VPWR VPWR clknet_leaf_4_clk sky130_fd_sc_hd__clkbuf_8
XANTENNA__4780__S0 _1550_ VGND VGND VPWR VPWR sky130_fd_sc_hd__diode_2
XANTENNA__4609__A _1324_ VGND VGND VPWR VPWR sky130_fd_sc_hd__diode_2
X_8971_ clknet_leaf_58_clk _0068_ VGND VGND VPWR VPWR registers\[18\]\[11\] sky130_fd_sc_hd__dfxtp_1
XFILLER_0_65_75 VGND VGND VPWR VPWR sky130_fd_sc_hd__fill_1
XFILLER_0_65_64 VGND VGND VPWR VPWR sky130_fd_sc_hd__fill_2
XANTENNA__8515__S _4200_ VGND VGND VPWR VPWR sky130_fd_sc_hd__diode_2
X_7922_ _3125_ registers\[27\]\[27\] _3887_ VGND VGND VPWR VPWR _3895_ sky130_fd_sc_hd__mux2_1
XFILLER_0_78_714 VGND VGND VPWR VPWR sky130_fd_sc_hd__fill_2
XFILLER_0_77_213 VGND VGND VPWR VPWR sky130_fd_sc_hd__fill_1
XFILLER_0_81_52 VGND VGND VPWR VPWR sky130_fd_sc_hd__fill_2
X_7853_ _3858_ VGND VGND VPWR VPWR _0339_ sky130_fd_sc_hd__clkbuf_1
X_4996_ _1757_ VGND VGND VPWR VPWR _1758_ sky130_fd_sc_hd__buf_8
XANTENNA__4344__A _1116_ VGND VGND VPWR VPWR sky130_fd_sc_hd__diode_2
XFILLER_0_65_419 VGND VGND VPWR VPWR sky130_fd_sc_hd__decap_4
X_7784_ _3123_ registers\[25\]\[26\] _3815_ VGND VGND VPWR VPWR _3822_ sky130_fd_sc_hd__mux2_1
X_6804_ _3284_ VGND VGND VPWR VPWR _0888_ sky130_fd_sc_hd__clkbuf_1
X_9523_ clknet_leaf_15_clk _0620_ VGND VGND VPWR VPWR registers\[8\]\[19\] sky130_fd_sc_hd__dfxtp_1
XFILLER_0_58_493 VGND VGND VPWR VPWR sky130_fd_sc_hd__fill_1
XFILLER_0_46_633 VGND VGND VPWR VPWR sky130_fd_sc_hd__decap_4
X_6735_ registers\[10\]\[31\] _3026_ _3213_ VGND VGND VPWR VPWR _3248_ sky130_fd_sc_hd__mux2_1
XANTENNA__4835__S1 _1556_ VGND VGND VPWR VPWR sky130_fd_sc_hd__diode_2
X_9454_ clknet_leaf_54_clk _0551_ VGND VGND VPWR VPWR registers\[31\]\[14\] sky130_fd_sc_hd__dfxtp_1
XTAP_TAPCELL_ROW_102_1586 VGND VPWR sky130_fd_sc_hd__tapvpwrvgnd_1
XFILLER_0_46_677 VGND VGND VPWR VPWR sky130_fd_sc_hd__decap_8
XFILLER_0_46_666 VGND VGND VPWR VPWR sky130_fd_sc_hd__fill_1
XFILLER_0_45_143 VGND VGND VPWR VPWR sky130_fd_sc_hd__fill_2
XFILLER_0_18_346 VGND VGND VPWR VPWR sky130_fd_sc_hd__fill_2
XFILLER_0_18_357 VGND VGND VPWR VPWR sky130_fd_sc_hd__fill_2
XANTENNA__8250__S _4067_ VGND VGND VPWR VPWR sky130_fd_sc_hd__diode_2
XFILLER_0_116_565 VGND VGND VPWR VPWR sky130_fd_sc_hd__decap_4
XFILLER_0_116_554 VGND VGND VPWR VPWR sky130_fd_sc_hd__decap_4
XFILLER_0_104_705 VPWR VGND VPWR VGND sky130_ef_sc_hd__decap_12
X_6666_ net13 net11 net12 VGND VGND VPWR VPWR _3210_ sky130_fd_sc_hd__or3b_4
XFILLER_0_18_379 VGND VGND VPWR VPWR sky130_fd_sc_hd__fill_2
XFILLER_0_116_587 VGND VGND VPWR VPWR sky130_fd_sc_hd__fill_1
XFILLER_0_103_215 VGND VGND VPWR VPWR sky130_fd_sc_hd__decap_6
X_5617_ _1070_ VGND VGND VPWR VPWR _2352_ sky130_fd_sc_hd__clkbuf_4
X_9385_ clknet_leaf_19_clk _0482_ VGND VGND VPWR VPWR registers\[9\]\[9\] sky130_fd_sc_hd__dfxtp_1
XFILLER_0_60_135 VGND VGND VPWR VPWR sky130_fd_sc_hd__fill_2
X_8405_ _4150_ VGND VGND VPWR VPWR _0599_ sky130_fd_sc_hd__clkbuf_1
X_6597_ _3172_ VGND VGND VPWR VPWR _3173_ sky130_fd_sc_hd__buf_2
XFILLER_0_5_251 VGND VGND VPWR VPWR sky130_fd_sc_hd__fill_1
X_5548_ _1913_ _2215_ _2220_ VGND VGND VPWR VPWR _2284_ sky130_fd_sc_hd__o21ai_1
XFILLER_0_60_157 VGND VGND VPWR VPWR sky130_fd_sc_hd__decap_6
X_8336_ _3024_ registers\[31\]\[30\] _4080_ VGND VGND VPWR VPWR _4114_ sky130_fd_sc_hd__mux2_1
XANTENNA__5260__S1 _1760_ VGND VGND VPWR VPWR sky130_fd_sc_hd__diode_2
X_8267_ _4077_ VGND VGND VPWR VPWR _0534_ sky130_fd_sc_hd__clkbuf_1
XFILLER_0_111_281 VGND VGND VPWR VPWR sky130_fd_sc_hd__decap_4
X_5479_ _2214_ VGND VGND VPWR VPWR _2215_ sky130_fd_sc_hd__buf_2
X_7218_ _3521_ VGND VGND VPWR VPWR _0041_ sky130_fd_sc_hd__clkbuf_1
X_8198_ registers\[9\]\[29\] _3495_ _4031_ VGND VGND VPWR VPWR _4041_ sky130_fd_sc_hd__mux2_1
X_7149_ registers\[16\]\[21\] _3479_ _3477_ VGND VGND VPWR VPWR _3480_ sky130_fd_sc_hd__mux2_1
XANTENNA__6417__A1 _3020_ VGND VGND VPWR VPWR sky130_fd_sc_hd__diode_2
XANTENNA__4953__S _1689_ VGND VGND VPWR VPWR sky130_fd_sc_hd__diode_2
XANTENNA__4238__B _1037_ VGND VGND VPWR VPWR sky130_fd_sc_hd__diode_2
XANTENNA__7090__A1 _3439_ VGND VGND VPWR VPWR sky130_fd_sc_hd__diode_2
XFILLER_0_96_533 VGND VGND VPWR VPWR sky130_fd_sc_hd__fill_2
XANTENNA__5079__S1 _1814_ VGND VGND VPWR VPWR sky130_fd_sc_hd__diode_2
XFILLER_0_96_566 VGND VGND VPWR VPWR sky130_fd_sc_hd__fill_2
XANTENNA__4254__A a2[0] VGND VGND VPWR VPWR sky130_fd_sc_hd__diode_2
XTAP_TAPCELL_ROW_12_414 VGND VPWR sky130_fd_sc_hd__tapvpwrvgnd_1
XFILLER_0_64_485 VGND VGND VPWR VPWR sky130_fd_sc_hd__fill_2
XTAP_TAPCELL_ROW_40_778 VGND VPWR sky130_fd_sc_hd__tapvpwrvgnd_1
XFILLER_0_37_699 VGND VGND VPWR VPWR sky130_fd_sc_hd__fill_2
XANTENNA__8342__A1 _3433_ VGND VGND VPWR VPWR sky130_fd_sc_hd__diode_2
XFILLER_0_36_165 VGND VGND VPWR VPWR sky130_fd_sc_hd__fill_1
XFILLER_0_52_669 VGND VGND VPWR VPWR sky130_fd_sc_hd__decap_6
XFILLER_0_51_135 VGND VGND VPWR VPWR sky130_fd_sc_hd__fill_2
XANTENNA__5251__S1 _1997_ VGND VGND VPWR VPWR sky130_fd_sc_hd__diode_2
XTAP_TAPCELL_ROW_79_1290 VGND VPWR sky130_fd_sc_hd__tapvpwrvgnd_1
XFILLER_0_20_533 VGND VGND VPWR VPWR sky130_fd_sc_hd__fill_2
XFILLER_0_32_371 VGND VGND VPWR VPWR sky130_fd_sc_hd__fill_2
XFILLER_0_32_382 VGND VGND VPWR VPWR sky130_fd_sc_hd__fill_2
XANTENNA__6656__A1 _3018_ VGND VGND VPWR VPWR sky130_fd_sc_hd__diode_2
XFILLER_0_20_544 VGND VGND VPWR VPWR sky130_fd_sc_hd__fill_2
XANTENNA__5532__B net81 VGND VGND VPWR VPWR sky130_fd_sc_hd__diode_2
XFILLER_0_19_57 VGND VGND VPWR VPWR sky130_fd_sc_hd__fill_2
XANTENNA__4762__S0 _1404_ VGND VGND VPWR VPWR sky130_fd_sc_hd__diode_2
XANTENNA__5092__B1 _1778_ VGND VGND VPWR VPWR sky130_fd_sc_hd__diode_2
XTAP_TAPCELL_ROW_48_878 VGND VPWR sky130_fd_sc_hd__tapvpwrvgnd_1
XFILLER_0_87_555 VGND VGND VPWR VPWR sky130_fd_sc_hd__decap_4
XFILLER_0_87_544 VGND VGND VPWR VPWR sky130_fd_sc_hd__fill_2
XFILLER_0_87_533 VGND VGND VPWR VPWR sky130_fd_sc_hd__fill_2
XTAP_TAPCELL_ROW_48_889 VGND VPWR sky130_fd_sc_hd__tapvpwrvgnd_1
XFILLER_0_35_89 VGND VGND VPWR VPWR sky130_fd_sc_hd__fill_2
X_4850_ net2 VGND VGND VPWR VPWR _1618_ sky130_fd_sc_hd__clkbuf_4
XANTENNA_clkbuf_leaf_0_clk_A clknet_4_0_0_clk VGND VGND VPWR VPWR sky130_fd_sc_hd__diode_2
XFILLER_0_51_44 VGND VGND VPWR VPWR sky130_fd_sc_hd__decap_3
XANTENNA__4817__S1 _1391_ VGND VGND VPWR VPWR sky130_fd_sc_hd__diode_2
XANTENNA__5395__A1 _1977_ VGND VGND VPWR VPWR sky130_fd_sc_hd__diode_2
X_4781_ registers\[16\]\[28\] registers\[17\]\[28\] registers\[18\]\[28\] registers\[19\]\[28\]
+ _1550_ _1551_ VGND VGND VPWR VPWR _1553_ sky130_fd_sc_hd__mux4_1
XANTENNA__8070__S _3973_ VGND VGND VPWR VPWR sky130_fd_sc_hd__diode_2
X_6520_ _3130_ VGND VGND VPWR VPWR _0758_ sky130_fd_sc_hd__clkbuf_1
XFILLER_0_51_99 VGND VGND VPWR VPWR sky130_fd_sc_hd__fill_2
XFILLER_0_27_154 VGND VGND VPWR VPWR sky130_fd_sc_hd__fill_2
XFILLER_0_113_502 VGND VGND VPWR VPWR sky130_fd_sc_hd__fill_2
X_6451_ _3083_ registers\[29\]\[7\] _3069_ VGND VGND VPWR VPWR _3084_ sky130_fd_sc_hd__mux2_1
XFILLER_0_42_124 VGND VGND VPWR VPWR sky130_fd_sc_hd__decap_3
Xclkload20 clknet_leaf_110_clk VGND VGND VPWR VPWR clkload20/Y sky130_fd_sc_hd__inv_6
XFILLER_0_3_711 VPWR VGND VPWR VGND sky130_ef_sc_hd__decap_12
XFILLER_0_27_198 VGND VGND VPWR VPWR sky130_fd_sc_hd__fill_1
X_6382_ registers\[3\]\[11\] _2985_ _3041_ VGND VGND VPWR VPWR _3043_ sky130_fd_sc_hd__mux2_1
Xclkload53 clknet_leaf_42_clk VGND VGND VPWR VPWR clkload53/Y sky130_fd_sc_hd__clkinvlp_2
Xclkload42 clknet_leaf_25_clk VGND VGND VPWR VPWR clkload42/Y sky130_fd_sc_hd__clkinvlp_4
XANTENNA__5242__S1 _1692_ VGND VGND VPWR VPWR sky130_fd_sc_hd__diode_2
X_9170_ clknet_leaf_72_clk _0267_ VGND VGND VPWR VPWR registers\[24\]\[18\] sky130_fd_sc_hd__dfxtp_1
X_5402_ _2140_ _2141_ _2031_ VGND VGND VPWR VPWR _2142_ sky130_fd_sc_hd__mux2_1
XFILLER_0_2_210 VGND VGND VPWR VPWR sky130_fd_sc_hd__fill_2
XFILLER_0_2_221 VGND VGND VPWR VPWR sky130_fd_sc_hd__fill_2
Xclkload31 clknet_leaf_101_clk VGND VGND VPWR VPWR clkload31/Y sky130_fd_sc_hd__clkinvlp_4
XANTENNA__8097__A0 _2989_ VGND VGND VPWR VPWR sky130_fd_sc_hd__diode_2
XFILLER_0_101_719 VGND VGND VPWR VPWR sky130_fd_sc_hd__decap_8
X_8121_ _4000_ VGND VGND VPWR VPWR _0465_ sky130_fd_sc_hd__clkbuf_1
X_5333_ _2074_ _2075_ _2076_ VGND VGND VPWR VPWR _2077_ sky130_fd_sc_hd__mux2_1
Xclkload75 clknet_leaf_79_clk VGND VGND VPWR VPWR clkload75/Y sky130_fd_sc_hd__clkinv_4
Xclkload64 clknet_leaf_89_clk VGND VGND VPWR VPWR clkload64/Y sky130_fd_sc_hd__clkinv_4
XFILLER_0_23_393 VGND VGND VPWR VPWR sky130_fd_sc_hd__fill_2
Xclkload86 clknet_leaf_75_clk VGND VGND VPWR VPWR clkload86/Y sky130_fd_sc_hd__clkinvlp_2
XANTENNA__7414__S _3623_ VGND VGND VPWR VPWR sky130_fd_sc_hd__diode_2
Xclkload97 clknet_leaf_61_clk VGND VGND VPWR VPWR clkload97/Y sky130_fd_sc_hd__clkinv_1
XANTENNA__4707__A1_N _1372_ VGND VGND VPWR VPWR sky130_fd_sc_hd__diode_2
XFILLER_0_2_276 VGND VGND VPWR VPWR sky130_fd_sc_hd__fill_2
X_8052_ registers\[2\]\[24\] _3485_ _3959_ VGND VGND VPWR VPWR _3964_ sky130_fd_sc_hd__mux2_1
X_5264_ _2011_ VGND VGND VPWR VPWR net93 sky130_fd_sc_hd__inv_2
X_5195_ _1944_ _1945_ _1767_ VGND VGND VPWR VPWR _1946_ sky130_fd_sc_hd__mux2_1
XFILLER_0_76_85 VGND VGND VPWR VPWR sky130_fd_sc_hd__fill_2
XANTENNA__4339__A _1025_ VGND VGND VPWR VPWR sky130_fd_sc_hd__diode_2
X_7003_ _3391_ VGND VGND VPWR VPWR _0980_ sky130_fd_sc_hd__clkbuf_1
XANTENNA__8245__S _4056_ VGND VGND VPWR VPWR sky130_fd_sc_hd__diode_2
X_8954_ clknet_leaf_78_clk _0051_ VGND VGND VPWR VPWR registers\[17\]\[26\] sky130_fd_sc_hd__dfxtp_1
XTAP_TAPCELL_ROW_104_1615 VGND VPWR sky130_fd_sc_hd__tapvpwrvgnd_1
XFILLER_0_78_533 VGND VGND VPWR VPWR sky130_fd_sc_hd__fill_2
X_7905_ _3108_ registers\[27\]\[19\] _3876_ VGND VGND VPWR VPWR _3886_ sky130_fd_sc_hd__mux2_1
X_8885_ clknet_leaf_82_clk _1006_ VGND VGND VPWR VPWR registers\[15\]\[21\] sky130_fd_sc_hd__dfxtp_1
X_7836_ _3849_ VGND VGND VPWR VPWR _0331_ sky130_fd_sc_hd__clkbuf_1
XANTENNA__4830__B1 _1372_ VGND VGND VPWR VPWR sky130_fd_sc_hd__diode_2
XFILLER_0_78_599 VGND VGND VPWR VPWR sky130_fd_sc_hd__fill_2
XFILLER_0_65_249 VGND VGND VPWR VPWR sky130_fd_sc_hd__decap_4
XTAP_TAPCELL_ROW_63_1080 VGND VPWR sky130_fd_sc_hd__tapvpwrvgnd_1
X_4979_ _1677_ VGND VGND VPWR VPWR _1741_ sky130_fd_sc_hd__buf_8
X_7767_ _3106_ registers\[25\]\[18\] _3804_ VGND VGND VPWR VPWR _3813_ sky130_fd_sc_hd__mux2_1
XFILLER_0_19_644 VGND VGND VPWR VPWR sky130_fd_sc_hd__fill_2
XFILLER_0_19_655 VGND VGND VPWR VPWR sky130_fd_sc_hd__fill_2
X_7698_ _3776_ VGND VGND VPWR VPWR _0266_ sky130_fd_sc_hd__clkbuf_1
Xclkload3 clknet_4_4_0_clk VGND VGND VPWR VPWR clkload3/Y sky130_fd_sc_hd__inv_6
X_6718_ _3239_ VGND VGND VPWR VPWR _0847_ sky130_fd_sc_hd__clkbuf_1
X_9506_ clknet_leaf_4_clk _0603_ VGND VGND VPWR VPWR registers\[8\]\[2\] sky130_fd_sc_hd__dfxtp_1
XFILLER_0_34_614 VGND VGND VPWR VPWR sky130_fd_sc_hd__fill_1
XFILLER_0_73_293 VGND VGND VPWR VPWR sky130_fd_sc_hd__fill_2
X_6649_ _3201_ VGND VGND VPWR VPWR _0816_ sky130_fd_sc_hd__clkbuf_1
X_9437_ clknet_leaf_107_clk _0534_ VGND VGND VPWR VPWR registers\[6\]\[29\] sky130_fd_sc_hd__dfxtp_1
XFILLER_0_33_135 VGND VGND VPWR VPWR sky130_fd_sc_hd__fill_2
XFILLER_0_34_669 VGND VGND VPWR VPWR sky130_fd_sc_hd__fill_2
XANTENNA__5689__A2 _1070_ VGND VGND VPWR VPWR sky130_fd_sc_hd__diode_2
XFILLER_0_6_593 VGND VGND VPWR VPWR sky130_fd_sc_hd__fill_2
XANTENNA__8088__A0 _2980_ VGND VGND VPWR VPWR sky130_fd_sc_hd__diode_2
X_9368_ clknet_leaf_86_clk _0465_ VGND VGND VPWR VPWR registers\[30\]\[24\] sky130_fd_sc_hd__dfxtp_1
XFILLER_0_14_393 VGND VGND VPWR VPWR sky130_fd_sc_hd__decap_6
XTAP_TAPCELL_ROW_115_1755 VGND VPWR sky130_fd_sc_hd__tapvpwrvgnd_1
XANTENNA__4948__S _1627_ VGND VGND VPWR VPWR sky130_fd_sc_hd__diode_2
X_9299_ clknet_leaf_14_clk _0396_ VGND VGND VPWR VPWR registers\[28\]\[19\] sky130_fd_sc_hd__dfxtp_1
X_8319_ _4105_ VGND VGND VPWR VPWR _0558_ sky130_fd_sc_hd__clkbuf_1
XANTENNA__7324__S _3575_ VGND VGND VPWR VPWR sky130_fd_sc_hd__diode_2
XANTENNA__4744__S0 _1347_ VGND VGND VPWR VPWR sky130_fd_sc_hd__diode_2
XFILLER_0_69_500 VGND VGND VPWR VPWR sky130_fd_sc_hd__fill_2
XTAP_TAPCELL_ROW_45_848 VGND VPWR sky130_fd_sc_hd__tapvpwrvgnd_1
XANTENNA__7994__S _3923_ VGND VGND VPWR VPWR sky130_fd_sc_hd__diode_2
XTAP_TAPCELL_ROW_25_583 VGND VPWR sky130_fd_sc_hd__tapvpwrvgnd_1
XFILLER_0_37_474 VGND VGND VPWR VPWR sky130_fd_sc_hd__fill_2
XANTENNA__6403__S _3052_ VGND VGND VPWR VPWR sky130_fd_sc_hd__diode_2
XFILLER_0_52_477 VGND VGND VPWR VPWR sky130_fd_sc_hd__decap_3
XANTENNA__5224__S1 _1760_ VGND VGND VPWR VPWR sky130_fd_sc_hd__diode_2
XFILLER_0_24_157 VGND VGND VPWR VPWR sky130_fd_sc_hd__fill_1
XFILLER_0_110_505 VGND VGND VPWR VPWR sky130_fd_sc_hd__decap_3
XANTENNA__5543__A _1108_ VGND VGND VPWR VPWR sky130_fd_sc_hd__diode_2
XANTENNA__4983__S0 _1742_ VGND VGND VPWR VPWR sky130_fd_sc_hd__diode_2
XFILLER_0_0_725 VGND VGND VPWR VPWR sky130_fd_sc_hd__decap_3
XANTENNA__4858__S net4 VGND VGND VPWR VPWR sky130_fd_sc_hd__diode_2
XANTENNA__7234__S _3525_ VGND VGND VPWR VPWR sky130_fd_sc_hd__diode_2
XFILLER_0_103_590 VGND VGND VPWR VPWR sky130_fd_sc_hd__fill_1
XANTENNA__6629__A1 _2991_ VGND VGND VPWR VPWR sky130_fd_sc_hd__diode_2
XTAP_TAPCELL_ROW_90_1427 VGND VPWR sky130_fd_sc_hd__tapvpwrvgnd_1
XFILLER_0_20_363 VGND VGND VPWR VPWR sky130_fd_sc_hd__fill_1
XANTENNA__5301__A1 _1701_ VGND VGND VPWR VPWR sky130_fd_sc_hd__diode_2
XFILLER_0_46_33 VGND VGND VPWR VPWR sky130_fd_sc_hd__fill_1
XFILLER_0_46_77 VGND VGND VPWR VPWR sky130_fd_sc_hd__fill_1
XANTENNA__4593__S _1344_ VGND VGND VPWR VPWR sky130_fd_sc_hd__diode_2
XFILLER_0_27_9 VGND VGND VPWR VPWR sky130_fd_sc_hd__fill_2
X_5951_ _2362_ _2671_ _2672_ _1145_ VGND VGND VPWR VPWR _2673_ sky130_fd_sc_hd__a22o_1
XFILLER_0_75_503 VGND VGND VPWR VPWR sky130_fd_sc_hd__fill_1
X_8670_ clknet_leaf_11_clk _0791_ VGND VGND VPWR VPWR registers\[7\]\[30\] sky130_fd_sc_hd__dfxtp_1
XFILLER_0_1_57 VPWR VGND VPWR VGND sky130_ef_sc_hd__decap_12
X_4902_ registers\[4\]\[2\] registers\[5\]\[2\] registers\[6\]\[2\] registers\[7\]\[2\]
+ _1642_ _1643_ VGND VGND VPWR VPWR _1668_ sky130_fd_sc_hd__mux4_1
X_5882_ _2419_ _2465_ _2607_ _2279_ VGND VGND VPWR VPWR _2608_ sky130_fd_sc_hd__o22a_1
X_7621_ _3735_ VGND VGND VPWR VPWR _0230_ sky130_fd_sc_hd__clkbuf_1
XFILLER_0_75_569 VGND VGND VPWR VPWR sky130_fd_sc_hd__decap_3
X_4833_ registers\[20\]\[31\] registers\[21\]\[31\] registers\[22\]\[31\] registers\[23\]\[31\]
+ _1555_ _1556_ VGND VGND VPWR VPWR _1602_ sky130_fd_sc_hd__mux4_1
XFILLER_0_117_126 VGND VGND VPWR VPWR sky130_fd_sc_hd__fill_2
X_7552_ _3096_ registers\[22\]\[13\] _3695_ VGND VGND VPWR VPWR _3699_ sky130_fd_sc_hd__mux2_1
XFILLER_0_55_271 VGND VGND VPWR VPWR sky130_fd_sc_hd__decap_3
XFILLER_0_7_335 VGND VGND VPWR VPWR sky130_fd_sc_hd__fill_1
X_4764_ registers\[28\]\[27\] registers\[29\]\[27\] registers\[30\]\[27\] registers\[31\]\[27\]
+ _1404_ _1391_ VGND VGND VPWR VPWR _1537_ sky130_fd_sc_hd__mux4_1
XFILLER_0_28_474 VGND VGND VPWR VPWR sky130_fd_sc_hd__fill_2
X_7483_ _3662_ VGND VGND VPWR VPWR _0165_ sky130_fd_sc_hd__clkbuf_1
XFILLER_0_43_444 VGND VGND VPWR VPWR sky130_fd_sc_hd__decap_4
XFILLER_0_7_379 VGND VGND VPWR VPWR sky130_fd_sc_hd__decap_4
X_6503_ net32 VGND VGND VPWR VPWR _3119_ sky130_fd_sc_hd__clkbuf_2
XFILLER_0_15_113 VGND VGND VPWR VPWR sky130_fd_sc_hd__decap_3
X_9222_ clknet_leaf_26_clk _0319_ VGND VGND VPWR VPWR registers\[26\]\[6\] sky130_fd_sc_hd__dfxtp_1
XANTENNA__5215__S1 _1821_ VGND VGND VPWR VPWR sky130_fd_sc_hd__diode_2
XFILLER_0_43_477 VGND VGND VPWR VPWR sky130_fd_sc_hd__decap_8
X_4695_ registers\[28\]\[23\] registers\[29\]\[23\] registers\[30\]\[23\] registers\[31\]\[23\]
+ _1323_ _1324_ VGND VGND VPWR VPWR _1472_ sky130_fd_sc_hd__mux4_1
X_6434_ _3072_ VGND VGND VPWR VPWR _0730_ sky130_fd_sc_hd__clkbuf_1
XANTENNA__7933__A _3900_ VGND VGND VPWR VPWR sky130_fd_sc_hd__diode_2
XANTENNA__4974__S0 _1731_ VGND VGND VPWR VPWR sky130_fd_sc_hd__diode_2
X_6365_ registers\[3\]\[3\] _2968_ _3030_ VGND VGND VPWR VPWR _3034_ sky130_fd_sc_hd__mux2_1
X_9153_ clknet_leaf_108_clk _0250_ VGND VGND VPWR VPWR registers\[24\]\[1\] sky130_fd_sc_hd__dfxtp_1
X_6296_ registers\[19\]\[12\] _2987_ _2983_ VGND VGND VPWR VPWR _2988_ sky130_fd_sc_hd__mux2_1
X_8104_ _3991_ VGND VGND VPWR VPWR _0457_ sky130_fd_sc_hd__clkbuf_1
X_5316_ registers\[0\]\[23\] registers\[1\]\[23\] registers\[2\]\[23\] registers\[3\]\[23\]
+ _1883_ _1774_ VGND VGND VPWR VPWR _2061_ sky130_fd_sc_hd__mux4_1
X_9084_ clknet_leaf_104_clk _0181_ VGND VGND VPWR VPWR registers\[21\]\[28\] sky130_fd_sc_hd__dfxtp_1
XFILLER_0_11_374 VGND VGND VPWR VPWR sky130_fd_sc_hd__fill_2
X_8035_ registers\[2\]\[16\] _3468_ _3948_ VGND VGND VPWR VPWR _3955_ sky130_fd_sc_hd__mux2_1
X_5247_ _1995_ VGND VGND VPWR VPWR net91 sky130_fd_sc_hd__inv_2
XANTENNA__6983__S _3372_ VGND VGND VPWR VPWR sky130_fd_sc_hd__diode_2
XANTENNA__4726__S0 _1415_ VGND VGND VPWR VPWR sky130_fd_sc_hd__diode_2
XTAP_TAPCELL_ROW_110_1685 VGND VPWR sky130_fd_sc_hd__tapvpwrvgnd_1
X_5178_ registers\[24\]\[16\] registers\[25\]\[16\] registers\[26\]\[16\] registers\[27\]\[16\]
+ _1763_ _1765_ VGND VGND VPWR VPWR _1930_ sky130_fd_sc_hd__mux4_1
XFILLER_0_98_628 VGND VGND VPWR VPWR sky130_fd_sc_hd__fill_2
XANTENNA__5151__S0 _1719_ VGND VGND VPWR VPWR sky130_fd_sc_hd__diode_2
XFILLER_0_78_330 VGND VGND VPWR VPWR sky130_fd_sc_hd__fill_2
X_8937_ clknet_leaf_11_clk _0034_ VGND VGND VPWR VPWR registers\[17\]\[9\] sky130_fd_sc_hd__dfxtp_1
XFILLER_0_78_352 VGND VGND VPWR VPWR sky130_fd_sc_hd__decap_4
X_8868_ clknet_leaf_29_clk _0989_ VGND VGND VPWR VPWR registers\[15\]\[4\] sky130_fd_sc_hd__dfxtp_1
XFILLER_0_78_374 VGND VGND VPWR VPWR sky130_fd_sc_hd__fill_2
XFILLER_0_66_525 VGND VGND VPWR VPWR sky130_fd_sc_hd__decap_4
XTAP_TAPCELL_ROW_42_807 VGND VPWR sky130_fd_sc_hd__tapvpwrvgnd_1
X_7819_ _3089_ registers\[26\]\[10\] _3840_ VGND VGND VPWR VPWR _3841_ sky130_fd_sc_hd__mux2_1
X_8799_ clknet_leaf_99_clk _0920_ VGND VGND VPWR VPWR registers\[12\]\[31\] sky130_fd_sc_hd__dfxtp_1
XFILLER_0_81_517 VGND VGND VPWR VPWR sky130_fd_sc_hd__fill_2
XTAP_TAPCELL_ROW_22_542 VGND VPWR sky130_fd_sc_hd__tapvpwrvgnd_1
XFILLER_0_117_671 VGND VGND VPWR VPWR sky130_fd_sc_hd__fill_1
XFILLER_0_104_398 VGND VGND VPWR VPWR sky130_fd_sc_hd__fill_2
XANTENNA__6459__A net17 VGND VGND VPWR VPWR sky130_fd_sc_hd__diode_2
XANTENNA__4965__S0 _1719_ VGND VGND VPWR VPWR sky130_fd_sc_hd__diode_2
XANTENNA__7054__S _3409_ VGND VGND VPWR VPWR sky130_fd_sc_hd__diode_2
XANTENNA__7808__A0 _3079_ VGND VGND VPWR VPWR sky130_fd_sc_hd__diode_2
XFILLER_0_30_683 VGND VGND VPWR VPWR sky130_fd_sc_hd__fill_2
XANTENNA_input44_A wd3[6] VGND VGND VPWR VPWR sky130_fd_sc_hd__diode_2
XANTENNA__6893__S _3324_ VGND VGND VPWR VPWR sky130_fd_sc_hd__diode_2
XANTENNA__4717__S0 _1433_ VGND VGND VPWR VPWR sky130_fd_sc_hd__diode_2
XFILLER_0_89_617 VGND VGND VPWR VPWR sky130_fd_sc_hd__fill_1
XFILLER_0_88_138 VGND VGND VPWR VPWR sky130_fd_sc_hd__fill_2
XANTENNA__5598__A1 _1943_ VGND VGND VPWR VPWR sky130_fd_sc_hd__diode_2
XFILLER_0_97_650 VGND VGND VPWR VPWR sky130_fd_sc_hd__fill_2
XANTENNA__4270__B2 _1024_ VGND VGND VPWR VPWR sky130_fd_sc_hd__diode_2
XANTENNA__8536__A1 net36 VGND VGND VPWR VPWR sky130_fd_sc_hd__diode_2
XFILLER_0_32_35 VGND VGND VPWR VPWR sky130_fd_sc_hd__fill_2
XANTENNA__5538__A _1049_ VGND VGND VPWR VPWR sky130_fd_sc_hd__diode_2
XFILLER_0_114_107 VGND VGND VPWR VPWR sky130_fd_sc_hd__fill_2
XFILLER_0_37_293 VGND VGND VPWR VPWR sky130_fd_sc_hd__decap_4
XFILLER_0_107_181 VGND VGND VPWR VPWR sky130_fd_sc_hd__decap_8
XANTENNA__5770__A1 net138 VGND VGND VPWR VPWR sky130_fd_sc_hd__diode_2
XFILLER_0_4_327 VGND VGND VPWR VPWR sky130_fd_sc_hd__decap_3
XFILLER_0_13_617 VGND VGND VPWR VPWR sky130_fd_sc_hd__fill_1
XFILLER_0_107_192 VGND VGND VPWR VPWR sky130_fd_sc_hd__fill_1
X_4480_ _1263_ _1265_ _1268_ _1025_ _1142_ VGND VGND VPWR VPWR _1269_ sky130_fd_sc_hd__a221o_1
XFILLER_0_12_105 VGND VGND VPWR VPWR sky130_fd_sc_hd__fill_2
XFILLER_0_0_500 VGND VGND VPWR VPWR sky130_fd_sc_hd__decap_4
X_6150_ _2852_ _2855_ _2860_ _2422_ VGND VGND VPWR VPWR net66 sky130_fd_sc_hd__o2bb2a_1
XFILLER_0_0_533 VGND VGND VPWR VPWR sky130_fd_sc_hd__fill_2
XFILLER_0_0_544 VPWR VGND VPWR VGND sky130_ef_sc_hd__decap_12
XANTENNA__5273__A _1763_ VGND VGND VPWR VPWR sky130_fd_sc_hd__diode_2
XANTENNA__7275__A1 _3458_ VGND VGND VPWR VPWR sky130_fd_sc_hd__diode_2
X_5101_ registers\[8\]\[11\] registers\[9\]\[11\] registers\[10\]\[11\] registers\[11\]\[11\]
+ _1773_ _1775_ VGND VGND VPWR VPWR _1858_ sky130_fd_sc_hd__mux4_1
XANTENNA__7899__S _3876_ VGND VGND VPWR VPWR sky130_fd_sc_hd__diode_2
X_6081_ _2733_ _2794_ _2344_ VGND VGND VPWR VPWR _2795_ sky130_fd_sc_hd__mux2_1
XFILLER_0_57_87 VGND VGND VPWR VPWR sky130_fd_sc_hd__fill_2
XANTENNA__5286__B1 _1977_ VGND VGND VPWR VPWR sky130_fd_sc_hd__diode_2
X_5032_ registers\[0\]\[7\] registers\[1\]\[7\] registers\[2\]\[7\] registers\[3\]\[7\]
+ _1705_ _1706_ VGND VGND VPWR VPWR _1793_ sky130_fd_sc_hd__mux4_1
XANTENNA__5381__S0 _2119_ VGND VGND VPWR VPWR sky130_fd_sc_hd__diode_2
XANTENNA__6308__S _2983_ VGND VGND VPWR VPWR sky130_fd_sc_hd__diode_2
XANTENNA__5133__S0 _1690_ VGND VGND VPWR VPWR sky130_fd_sc_hd__diode_2
XFILLER_0_94_108 VGND VGND VPWR VPWR sky130_fd_sc_hd__fill_2
X_6983_ _3106_ registers\[14\]\[18\] _3372_ VGND VGND VPWR VPWR _3381_ sky130_fd_sc_hd__mux2_1
XTAP_TAPCELL_ROW_0_248 VGND VPWR sky130_fd_sc_hd__tapvpwrvgnd_1
XTAP_TAPCELL_ROW_0_259 VGND VPWR sky130_fd_sc_hd__tapvpwrvgnd_1
X_5934_ _2322_ _2654_ _2656_ VGND VGND VPWR VPWR _2657_ sky130_fd_sc_hd__a21o_1
X_8722_ clknet_leaf_67_clk _0843_ VGND VGND VPWR VPWR registers\[10\]\[18\] sky130_fd_sc_hd__dfxtp_1
X_8653_ clknet_leaf_52_clk _0774_ VGND VGND VPWR VPWR registers\[7\]\[13\] sky130_fd_sc_hd__dfxtp_1
X_5865_ _1819_ _2548_ _2575_ _1835_ VGND VGND VPWR VPWR _2591_ sky130_fd_sc_hd__o22a_1
XFILLER_0_8_611 VGND VGND VPWR VPWR sky130_fd_sc_hd__fill_2
X_7604_ _3726_ VGND VGND VPWR VPWR _0222_ sky130_fd_sc_hd__clkbuf_1
XANTENNA__7139__S _3456_ VGND VGND VPWR VPWR sky130_fd_sc_hd__diode_2
X_4816_ registers\[20\]\[30\] registers\[21\]\[30\] registers\[22\]\[30\] registers\[23\]\[30\]
+ _1390_ _1391_ VGND VGND VPWR VPWR _1586_ sky130_fd_sc_hd__mux4_1
XANTENNA__5436__S1 _1760_ VGND VGND VPWR VPWR sky130_fd_sc_hd__diode_2
X_5796_ _2505_ _2513_ _2422_ _2525_ VGND VGND VPWR VPWR net77 sky130_fd_sc_hd__o2bb2a_1
XFILLER_0_90_336 VGND VGND VPWR VPWR sky130_fd_sc_hd__fill_2
XFILLER_0_90_325 VGND VGND VPWR VPWR sky130_fd_sc_hd__fill_2
X_8584_ clknet_leaf_16_clk _0705_ VGND VGND VPWR VPWR registers\[3\]\[8\] sky130_fd_sc_hd__dfxtp_1
XFILLER_0_8_666 VGND VGND VPWR VPWR sky130_fd_sc_hd__fill_2
X_7535_ _3079_ registers\[22\]\[5\] _3684_ VGND VGND VPWR VPWR _3690_ sky130_fd_sc_hd__mux2_1
XFILLER_0_71_561 VGND VGND VPWR VPWR sky130_fd_sc_hd__fill_1
XFILLER_0_71_550 VGND VGND VPWR VPWR sky130_fd_sc_hd__fill_2
XFILLER_0_43_252 VGND VGND VPWR VPWR sky130_fd_sc_hd__decap_3
XFILLER_0_8_699 VGND VGND VPWR VPWR sky130_fd_sc_hd__fill_1
X_4747_ registers\[28\]\[26\] registers\[29\]\[26\] registers\[30\]\[26\] registers\[31\]\[26\]
+ _1347_ _1348_ VGND VGND VPWR VPWR _1521_ sky130_fd_sc_hd__mux4_1
X_7466_ _3653_ VGND VGND VPWR VPWR _0157_ sky130_fd_sc_hd__clkbuf_1
XFILLER_0_71_583 VGND VGND VPWR VPWR sky130_fd_sc_hd__fill_2
XFILLER_0_31_403 VGND VGND VPWR VPWR sky130_fd_sc_hd__fill_2
X_4678_ registers\[28\]\[22\] registers\[29\]\[22\] registers\[30\]\[22\] registers\[31\]\[22\]
+ _1382_ _1383_ VGND VGND VPWR VPWR _1456_ sky130_fd_sc_hd__mux4_1
X_7397_ registers\[20\]\[4\] _3443_ _3612_ VGND VGND VPWR VPWR _3617_ sky130_fd_sc_hd__mux2_1
XANTENNA__4947__S0 _1705_ VGND VGND VPWR VPWR sky130_fd_sc_hd__diode_2
X_6417_ registers\[3\]\[28\] _3020_ _3052_ VGND VGND VPWR VPWR _3061_ sky130_fd_sc_hd__mux2_1
X_9205_ clknet_leaf_79_clk _0302_ VGND VGND VPWR VPWR registers\[25\]\[21\] sky130_fd_sc_hd__dfxtp_1
XTAP_TAPCELL_ROW_112_1714 VGND VPWR sky130_fd_sc_hd__tapvpwrvgnd_1
Xoutput49 net49 VGND VGND VPWR VPWR alu_result[0] sky130_fd_sc_hd__buf_1
X_9136_ clknet_leaf_61_clk _0233_ VGND VGND VPWR VPWR registers\[23\]\[16\] sky130_fd_sc_hd__dfxtp_1
XFILLER_0_12_661 VGND VGND VPWR VPWR sky130_fd_sc_hd__fill_2
X_6348_ registers\[19\]\[29\] _3022_ _3004_ VGND VGND VPWR VPWR _3023_ sky130_fd_sc_hd__mux2_1
XFILLER_0_101_379 VGND VGND VPWR VPWR sky130_fd_sc_hd__fill_2
XANTENNA__7266__A1 _3449_ VGND VGND VPWR VPWR sky130_fd_sc_hd__diode_2
XTAP_TAPCELL_ROW_8_359 VGND VPWR sky130_fd_sc_hd__tapvpwrvgnd_1
XFILLER_0_11_160 VGND VGND VPWR VPWR sky130_fd_sc_hd__decap_6
XFILLER_0_12_694 VGND VGND VPWR VPWR sky130_fd_sc_hd__fill_2
X_9067_ clknet_leaf_59_clk _0164_ VGND VGND VPWR VPWR registers\[21\]\[11\] sky130_fd_sc_hd__dfxtp_1
X_6279_ net45 VGND VGND VPWR VPWR _2976_ sky130_fd_sc_hd__clkbuf_4
X_8018_ registers\[2\]\[8\] _3451_ _3937_ VGND VGND VPWR VPWR _3946_ sky130_fd_sc_hd__mux2_1
XANTENNA__5372__S0 _2020_ VGND VGND VPWR VPWR sky130_fd_sc_hd__diode_2
XFILLER_0_85_108 VGND VGND VPWR VPWR sky130_fd_sc_hd__fill_2
XTAP_TAPCELL_ROW_27_612 VGND VPWR sky130_fd_sc_hd__tapvpwrvgnd_1
XANTENNA__8433__S _4164_ VGND VGND VPWR VPWR sky130_fd_sc_hd__diode_2
XTAP_TAPCELL_ROW_55_976 VGND VPWR sky130_fd_sc_hd__tapvpwrvgnd_1
XFILLER_0_93_130 VGND VGND VPWR VPWR sky130_fd_sc_hd__fill_2
XFILLER_0_39_569 VGND VGND VPWR VPWR sky130_fd_sc_hd__fill_1
XANTENNA_clkbuf_leaf_40_clk_A clknet_4_7_0_clk VGND VGND VPWR VPWR sky130_fd_sc_hd__diode_2
XFILLER_0_94_686 VPWR VGND VPWR VGND sky130_ef_sc_hd__decap_12
XFILLER_0_93_174 VGND VGND VPWR VPWR sky130_fd_sc_hd__fill_1
XANTENNA__4262__A a2[1] VGND VGND VPWR VPWR sky130_fd_sc_hd__diode_2
XFILLER_0_93_185 VPWR VGND VPWR VGND sky130_ef_sc_hd__decap_12
XFILLER_0_50_701 VPWR VGND VPWR VGND sky130_ef_sc_hd__decap_12
XFILLER_0_34_274 VGND VGND VPWR VPWR sky130_fd_sc_hd__decap_3
XANTENNA_clkbuf_leaf_55_clk_A clknet_4_13_0_clk VGND VGND VPWR VPWR sky130_fd_sc_hd__diode_2
XTAP_TAPCELL_ROW_74_1219 VGND VPWR sky130_fd_sc_hd__tapvpwrvgnd_1
XFILLER_0_30_480 VGND VGND VPWR VPWR sky130_fd_sc_hd__fill_2
XANTENNA__5821__A _1819_ VGND VGND VPWR VPWR sky130_fd_sc_hd__diode_2
XANTENNA__5363__S0 _1996_ VGND VGND VPWR VPWR sky130_fd_sc_hd__diode_2
XFILLER_0_27_13 VGND VGND VPWR VPWR sky130_fd_sc_hd__decap_4
XFILLER_0_89_469 VGND VGND VPWR VPWR sky130_fd_sc_hd__decap_8
XANTENNA__5115__S0 _1798_ VGND VGND VPWR VPWR sky130_fd_sc_hd__diode_2
XTAP_TAPCELL_ROW_85_1359 VGND VPWR sky130_fd_sc_hd__tapvpwrvgnd_1
XANTENNA__8509__A1 net22 VGND VGND VPWR VPWR sky130_fd_sc_hd__diode_2
XFILLER_0_57_311 VGND VGND VPWR VPWR sky130_fd_sc_hd__fill_1
XANTENNA__4871__S _1621_ VGND VGND VPWR VPWR sky130_fd_sc_hd__diode_2
XFILLER_0_85_642 VGND VGND VPWR VPWR sky130_fd_sc_hd__fill_2
XFILLER_0_85_697 VGND VGND VPWR VPWR sky130_fd_sc_hd__decap_8
XFILLER_0_84_141 VGND VGND VPWR VPWR sky130_fd_sc_hd__fill_2
X_5650_ _2240_ _2247_ _1050_ VGND VGND VPWR VPWR _2385_ sky130_fd_sc_hd__mux2_1
Xclkbuf_0_clk clk VGND VGND VPWR VPWR clknet_0_clk sky130_fd_sc_hd__clkbuf_16
XFILLER_0_57_388 VGND VGND VPWR VPWR sky130_fd_sc_hd__decap_4
XANTENNA__5418__S1 _2109_ VGND VGND VPWR VPWR sky130_fd_sc_hd__diode_2
X_4601_ _1324_ VGND VGND VPWR VPWR _1383_ sky130_fd_sc_hd__buf_4
X_5581_ _1145_ _2199_ VGND VGND VPWR VPWR _2317_ sky130_fd_sc_hd__nand2_4
XANTENNA__5743__A1 _1049_ VGND VGND VPWR VPWR sky130_fd_sc_hd__diode_2
XFILLER_0_72_358 VGND VGND VPWR VPWR sky130_fd_sc_hd__fill_1
XFILLER_0_5_647 VGND VGND VPWR VPWR sky130_fd_sc_hd__decap_3
X_4532_ _1153_ _1317_ _1142_ VGND VGND VPWR VPWR _1318_ sky130_fd_sc_hd__a21oi_1
XFILLER_0_53_572 VGND VGND VPWR VPWR sky130_fd_sc_hd__fill_2
X_7320_ registers\[1\]\[0\] _3433_ _3575_ VGND VGND VPWR VPWR _3576_ sky130_fd_sc_hd__mux2_1
XFILLER_0_4_157 VGND VGND VPWR VPWR sky130_fd_sc_hd__decap_4
X_4463_ _1025_ _1252_ _1142_ VGND VGND VPWR VPWR _1253_ sky130_fd_sc_hd__a21o_1
X_7251_ _3538_ VGND VGND VPWR VPWR _3539_ sky130_fd_sc_hd__clkbuf_8
XFILLER_0_40_244 VGND VGND VPWR VPWR sky130_fd_sc_hd__decap_3
XFILLER_0_13_447 VGND VGND VPWR VPWR sky130_fd_sc_hd__fill_1
XFILLER_0_111_644 VGND VGND VPWR VPWR sky130_fd_sc_hd__decap_6
XFILLER_0_110_121 VGND VGND VPWR VPWR sky130_fd_sc_hd__fill_2
X_6202_ _2152_ _2908_ VGND VGND VPWR VPWR _2910_ sky130_fd_sc_hd__and2_1
X_4394_ _1185_ _1186_ _1117_ VGND VGND VPWR VPWR _1187_ sky130_fd_sc_hd__mux2_1
X_7182_ _2959_ _3501_ VGND VGND VPWR VPWR _3502_ sky130_fd_sc_hd__nor2_4
XPHY_EDGE_ROW_15_Right_15 VGND VGND VPWR VPWR sky130_fd_sc_hd__decap_3
X_6133_ _2490_ _2691_ _2841_ _2844_ VGND VGND VPWR VPWR _2845_ sky130_fd_sc_hd__o211ai_1
XANTENNA__7422__S _3623_ VGND VGND VPWR VPWR sky130_fd_sc_hd__diode_2
XTAP_TAPCELL_ROW_5_318 VGND VPWR sky130_fd_sc_hd__tapvpwrvgnd_1
X_6064_ _2011_ _2771_ VGND VGND VPWR VPWR _2779_ sky130_fd_sc_hd__or2_1
XTAP_TAPCELL_ROW_5_329 VGND VPWR sky130_fd_sc_hd__tapvpwrvgnd_1
X_5015_ _1772_ _1776_ _1768_ VGND VGND VPWR VPWR _1777_ sky130_fd_sc_hd__mux2_1
XANTENNA__4347__A _1142_ VGND VGND VPWR VPWR sky130_fd_sc_hd__diode_2
XFILLER_0_23_3 VGND VGND VPWR VPWR sky130_fd_sc_hd__decap_4
XANTENNA__5106__S0 _1773_ VGND VGND VPWR VPWR sky130_fd_sc_hd__diode_2
XFILLER_0_17_90 VGND VGND VPWR VPWR sky130_fd_sc_hd__decap_4
XANTENNA__7420__A1 _3466_ VGND VGND VPWR VPWR sky130_fd_sc_hd__diode_2
X_6966_ _3360_ VGND VGND VPWR VPWR _3372_ sky130_fd_sc_hd__clkbuf_8
XPHY_EDGE_ROW_24_Right_24 VGND VGND VPWR VPWR sky130_fd_sc_hd__decap_3
X_5917_ _2461_ _2587_ _2640_ VGND VGND VPWR VPWR _2641_ sky130_fd_sc_hd__o21ai_1
XFILLER_0_76_642 VGND VGND VPWR VPWR sky130_fd_sc_hd__fill_2
XTAP_TAPCELL_ROW_52_935 VGND VPWR sky130_fd_sc_hd__tapvpwrvgnd_1
X_8705_ clknet_leaf_5_clk _0826_ VGND VGND VPWR VPWR registers\[10\]\[1\] sky130_fd_sc_hd__dfxtp_1
XFILLER_0_76_686 VGND VGND VPWR VPWR sky130_fd_sc_hd__decap_6
X_6897_ _3323_ VGND VGND VPWR VPWR _3335_ sky130_fd_sc_hd__clkbuf_8
XANTENNA__5409__S1 _2073_ VGND VGND VPWR VPWR sky130_fd_sc_hd__diode_2
X_5848_ net144 _2574_ VGND VGND VPWR VPWR _2575_ sky130_fd_sc_hd__xor2_2
X_8636_ clknet_leaf_88_clk _0757_ VGND VGND VPWR VPWR registers\[29\]\[28\] sky130_fd_sc_hd__dfxtp_1
X_5779_ _2419_ _2508_ _2403_ VGND VGND VPWR VPWR _2509_ sky130_fd_sc_hd__mux2_1
X_8567_ clknet_leaf_70_clk _0688_ VGND VGND VPWR VPWR registers\[19\]\[23\] sky130_fd_sc_hd__dfxtp_1
XANTENNA__6931__A0 _3123_ VGND VGND VPWR VPWR sky130_fd_sc_hd__diode_2
XTAP_TAPCELL_ROW_32_670 VGND VPWR sky130_fd_sc_hd__tapvpwrvgnd_1
XFILLER_0_32_701 VGND VGND VPWR VPWR sky130_fd_sc_hd__fill_2
XTAP_TAPCELL_ROW_32_681 VGND VPWR sky130_fd_sc_hd__tapvpwrvgnd_1
XFILLER_0_44_583 VGND VGND VPWR VPWR sky130_fd_sc_hd__decap_3
XFILLER_0_44_561 VGND VGND VPWR VPWR sky130_fd_sc_hd__fill_2
X_7518_ _3680_ VGND VGND VPWR VPWR _0182_ sky130_fd_sc_hd__clkbuf_1
XANTENNA__6501__S _3111_ VGND VGND VPWR VPWR sky130_fd_sc_hd__diode_2
XFILLER_0_114_460 VGND VGND VPWR VPWR sky130_fd_sc_hd__fill_1
X_8498_ _4188_ VGND VGND VPWR VPWR _4200_ sky130_fd_sc_hd__clkbuf_8
XANTENNA__5117__S _1714_ VGND VGND VPWR VPWR sky130_fd_sc_hd__diode_2
X_7449_ registers\[20\]\[29\] _3495_ _3634_ VGND VGND VPWR VPWR _3644_ sky130_fd_sc_hd__mux2_1
XFILLER_0_31_277 VGND VGND VPWR VPWR sky130_fd_sc_hd__fill_1
XPHY_EDGE_ROW_33_Right_33 VGND VGND VPWR VPWR sky130_fd_sc_hd__decap_3
XFILLER_0_101_165 VGND VGND VPWR VPWR sky130_fd_sc_hd__decap_3
XANTENNA__4396__S1 _1127_ VGND VGND VPWR VPWR sky130_fd_sc_hd__diode_2
XANTENNA__8428__S _4153_ VGND VGND VPWR VPWR sky130_fd_sc_hd__diode_2
X_9119_ clknet_leaf_2_clk _0216_ VGND VGND VPWR VPWR registers\[22\]\[31\] sky130_fd_sc_hd__dfxtp_1
XANTENNA__7332__S _3575_ VGND VGND VPWR VPWR sky130_fd_sc_hd__diode_2
XANTENNA__5345__S0 _2027_ VGND VGND VPWR VPWR sky130_fd_sc_hd__diode_2
XFILLER_0_98_244 VGND VGND VPWR VPWR sky130_fd_sc_hd__fill_2
XPHY_EDGE_ROW_42_Right_42 VGND VGND VPWR VPWR sky130_fd_sc_hd__decap_3
XANTENNA__6472__A net21 VGND VGND VPWR VPWR sky130_fd_sc_hd__diode_2
XANTENNA__8163__S _4020_ VGND VGND VPWR VPWR sky130_fd_sc_hd__diode_2
XFILLER_0_58_108 VGND VGND VPWR VPWR sky130_fd_sc_hd__fill_1
XFILLER_0_67_653 VGND VGND VPWR VPWR sky130_fd_sc_hd__fill_2
XFILLER_0_67_642 VGND VGND VPWR VPWR sky130_fd_sc_hd__fill_2
XANTENNA__5088__A _1756_ VGND VGND VPWR VPWR sky130_fd_sc_hd__diode_2
XFILLER_0_54_303 VGND VGND VPWR VPWR sky130_fd_sc_hd__decap_3
XFILLER_0_39_355 VGND VGND VPWR VPWR sky130_fd_sc_hd__decap_8
XPHY_EDGE_ROW_17_Left_137 VGND VGND VPWR VPWR sky130_fd_sc_hd__decap_3
XFILLER_0_54_369 VGND VGND VPWR VPWR sky130_fd_sc_hd__fill_2
XPHY_EDGE_ROW_51_Right_51 VGND VGND VPWR VPWR sky130_fd_sc_hd__decap_3
XANTENNA__7507__S _3670_ VGND VGND VPWR VPWR sky130_fd_sc_hd__diode_2
XANTENNA__6411__S _3052_ VGND VGND VPWR VPWR sky130_fd_sc_hd__diode_2
XFILLER_0_112_419 VGND VGND VPWR VPWR sky130_fd_sc_hd__fill_1
XANTENNA__4415__A1_N _1073_ VGND VGND VPWR VPWR sky130_fd_sc_hd__diode_2
XFILLER_0_1_105 VGND VGND VPWR VPWR sky130_fd_sc_hd__decap_6
XTAP_TAPCELL_ROW_10_386 VGND VPWR sky130_fd_sc_hd__tapvpwrvgnd_1
XFILLER_0_22_211 VGND VGND VPWR VPWR sky130_fd_sc_hd__fill_1
XFILLER_0_105_493 VGND VGND VPWR VPWR sky130_fd_sc_hd__fill_2
XFILLER_0_1_149 VGND VGND VPWR VPWR sky130_fd_sc_hd__decap_3
XANTENNA__4387__S1 _1137_ VGND VGND VPWR VPWR sky130_fd_sc_hd__diode_2
XPHY_EDGE_ROW_26_Left_146 VGND VGND VPWR VPWR sky130_fd_sc_hd__decap_3
XFILLER_0_38_34 VGND VGND VPWR VPWR sky130_fd_sc_hd__fill_2
XFILLER_0_38_23 VGND VGND VPWR VPWR sky130_fd_sc_hd__decap_3
XANTENNA__8338__S _4080_ VGND VGND VPWR VPWR sky130_fd_sc_hd__diode_2
XANTENNA__5551__A _1851_ VGND VGND VPWR VPWR sky130_fd_sc_hd__diode_2
XANTENNA__7242__S _3525_ VGND VGND VPWR VPWR sky130_fd_sc_hd__diode_2
XANTENNA__5336__S0 _2072_ VGND VGND VPWR VPWR sky130_fd_sc_hd__diode_2
XANTENNA__4464__A1 _1073_ VGND VGND VPWR VPWR sky130_fd_sc_hd__diode_2
XPHY_EDGE_ROW_60_Right_60 VGND VGND VPWR VPWR sky130_fd_sc_hd__decap_3
X_6820_ _3294_ VGND VGND VPWR VPWR _0894_ sky130_fd_sc_hd__clkbuf_1
XFILLER_0_89_277 VGND VGND VPWR VPWR sky130_fd_sc_hd__fill_1
XPHY_EDGE_ROW_35_Left_155 VGND VGND VPWR VPWR sky130_fd_sc_hd__decap_3
X_6751_ registers\[11\]\[6\] _2974_ _3250_ VGND VGND VPWR VPWR _3257_ sky130_fd_sc_hd__mux2_1
XFILLER_0_92_409 VGND VGND VPWR VPWR sky130_fd_sc_hd__fill_2
XFILLER_0_85_461 VGND VGND VPWR VPWR sky130_fd_sc_hd__fill_2
XFILLER_0_73_612 VGND VGND VPWR VPWR sky130_fd_sc_hd__fill_2
XTAP_TAPCELL_ROW_18_497 VGND VPWR sky130_fd_sc_hd__tapvpwrvgnd_1
X_6682_ _3220_ VGND VGND VPWR VPWR _0830_ sky130_fd_sc_hd__clkbuf_1
X_5702_ _1676_ _2424_ VGND VGND VPWR VPWR _2435_ sky130_fd_sc_hd__nor2_1
X_9470_ clknet_leaf_98_clk _0567_ VGND VGND VPWR VPWR registers\[31\]\[30\] sky130_fd_sc_hd__dfxtp_1
XFILLER_0_116_725 VGND VGND VPWR VPWR sky130_fd_sc_hd__decap_8
X_8421_ _4159_ VGND VGND VPWR VPWR _0606_ sky130_fd_sc_hd__clkbuf_1
XTAP_TAPCELL_ROW_98_1528 VGND VPWR sky130_fd_sc_hd__tapvpwrvgnd_1
XANTENNA__5716__A1 net124 VGND VGND VPWR VPWR sky130_fd_sc_hd__diode_2
X_5633_ _2011_ _2234_ _1050_ VGND VGND VPWR VPWR _2368_ sky130_fd_sc_hd__o21ai_1
XFILLER_0_70_98 VGND VGND VPWR VPWR sky130_fd_sc_hd__decap_3
X_8352_ registers\[5\]\[5\] _3445_ _4117_ VGND VGND VPWR VPWR _4123_ sky130_fd_sc_hd__mux2_1
XFILLER_0_115_235 VGND VGND VPWR VPWR sky130_fd_sc_hd__fill_2
XTAP_TAPCELL_ROW_98_1539 VGND VPWR sky130_fd_sc_hd__tapvpwrvgnd_1
X_5564_ _1796_ _2213_ VGND VGND VPWR VPWR _2300_ sky130_fd_sc_hd__or2_1
XANTENNA__6321__S _3004_ VGND VGND VPWR VPWR sky130_fd_sc_hd__diode_2
XFILLER_0_115_279 VGND VGND VPWR VPWR sky130_fd_sc_hd__fill_1
XFILLER_0_103_419 VGND VGND VPWR VPWR sky130_fd_sc_hd__fill_2
X_4515_ _1073_ _1293_ _1297_ _1301_ VGND VGND VPWR VPWR _1302_ sky130_fd_sc_hd__a2bb2o_2
XFILLER_0_5_499 VGND VGND VPWR VPWR sky130_fd_sc_hd__fill_2
X_7303_ _3566_ VGND VGND VPWR VPWR _0081_ sky130_fd_sc_hd__clkbuf_1
XFILLER_0_110_60 VGND VGND VPWR VPWR sky130_fd_sc_hd__decap_3
XPHY_EDGE_ROW_103_Right_103 VGND VGND VPWR VPWR sky130_fd_sc_hd__decap_3
X_8283_ _4086_ VGND VGND VPWR VPWR _0541_ sky130_fd_sc_hd__clkbuf_1
XFILLER_0_79_96 VGND VGND VPWR VPWR sky130_fd_sc_hd__fill_2
XFILLER_0_79_74 VGND VGND VPWR VPWR sky130_fd_sc_hd__fill_1
X_5495_ net96 VGND VGND VPWR VPWR _2231_ sky130_fd_sc_hd__inv_2
XPHY_EDGE_ROW_44_Left_164 VGND VGND VPWR VPWR sky130_fd_sc_hd__decap_3
XANTENNA__4378__S1 _1168_ VGND VGND VPWR VPWR sky130_fd_sc_hd__diode_2
X_4446_ registers\[0\]\[9\] registers\[1\]\[9\] registers\[2\]\[9\] registers\[3\]\[9\]
+ _1196_ _1202_ VGND VGND VPWR VPWR _1237_ sky130_fd_sc_hd__mux4_1
X_7234_ registers\[17\]\[24\] _3485_ _3525_ VGND VGND VPWR VPWR _3530_ sky130_fd_sc_hd__mux2_1
X_4377_ _1169_ _1170_ _1117_ VGND VGND VPWR VPWR _1171_ sky130_fd_sc_hd__mux2_1
X_7165_ _3490_ VGND VGND VPWR VPWR _0019_ sky130_fd_sc_hd__clkbuf_1
XANTENNA__8248__S _4067_ VGND VGND VPWR VPWR sky130_fd_sc_hd__diode_2
XANTENNA__5461__A net14 VGND VGND VPWR VPWR sky130_fd_sc_hd__diode_2
X_6116_ net97 _2827_ VGND VGND VPWR VPWR _2828_ sky130_fd_sc_hd__xnor2_1
XANTENNA__7152__S _3477_ VGND VGND VPWR VPWR sky130_fd_sc_hd__diode_2
X_7096_ registers\[16\]\[4\] _3443_ _3435_ VGND VGND VPWR VPWR _3444_ sky130_fd_sc_hd__mux2_1
X_6047_ _2732_ _2762_ _2352_ VGND VGND VPWR VPWR _2763_ sky130_fd_sc_hd__mux2_1
XTAP_TAPCELL_ROW_107_1646 VGND VPWR sky130_fd_sc_hd__tapvpwrvgnd_1
XANTENNA__6292__A net18 VGND VGND VPWR VPWR sky130_fd_sc_hd__diode_2
XFILLER_0_68_428 VGND VGND VPWR VPWR sky130_fd_sc_hd__fill_2
XPHY_EDGE_ROW_53_Left_173 VGND VGND VPWR VPWR sky130_fd_sc_hd__decap_3
XANTENNA__7388__A _3611_ VGND VGND VPWR VPWR sky130_fd_sc_hd__diode_2
XTAP_TAPCELL_ROW_37_740 VGND VPWR sky130_fd_sc_hd__tapvpwrvgnd_1
XFILLER_0_95_225 VGND VGND VPWR VPWR sky130_fd_sc_hd__fill_2
X_7998_ _3026_ registers\[28\]\[31\] _3900_ VGND VGND VPWR VPWR _3935_ sky130_fd_sc_hd__mux2_1
XFILLER_0_76_461 VGND VGND VPWR VPWR sky130_fd_sc_hd__fill_1
XFILLER_0_48_141 VGND VGND VPWR VPWR sky130_fd_sc_hd__decap_3
X_6949_ _3363_ VGND VGND VPWR VPWR _0954_ sky130_fd_sc_hd__clkbuf_1
XFILLER_0_119_552 VGND VGND VPWR VPWR sky130_fd_sc_hd__fill_2
XFILLER_0_64_623 VGND VGND VPWR VPWR sky130_fd_sc_hd__fill_2
X_8619_ clknet_leaf_59_clk _0740_ VGND VGND VPWR VPWR registers\[29\]\[11\] sky130_fd_sc_hd__dfxtp_1
XFILLER_0_107_714 VGND VGND VPWR VPWR sky130_fd_sc_hd__fill_2
XFILLER_0_63_155 VGND VGND VPWR VPWR sky130_fd_sc_hd__fill_1
XFILLER_0_8_271 VGND VGND VPWR VPWR sky130_fd_sc_hd__fill_2
XFILLER_0_63_177 VGND VGND VPWR VPWR sky130_fd_sc_hd__fill_2
XFILLER_0_106_268 VGND VGND VPWR VPWR sky130_fd_sc_hd__fill_2
XPHY_EDGE_ROW_62_Left_182 VGND VGND VPWR VPWR sky130_fd_sc_hd__decap_3
XFILLER_0_32_520 VGND VGND VPWR VPWR sky130_fd_sc_hd__fill_2
XFILLER_0_32_531 VGND VGND VPWR VPWR sky130_fd_sc_hd__fill_1
XTAP_TAPCELL_ROW_118_1797 VGND VPWR sky130_fd_sc_hd__tapvpwrvgnd_1
XFILLER_0_102_430 VGND VGND VPWR VPWR sky130_fd_sc_hd__fill_2
XANTENNA__6132__A1 _2321_ VGND VGND VPWR VPWR sky130_fd_sc_hd__diode_2
XFILLER_0_32_586 VGND VGND VPWR VPWR sky130_fd_sc_hd__fill_2
XFILLER_0_102_474 VGND VGND VPWR VPWR sky130_fd_sc_hd__fill_2
XANTENNA__6186__B _2317_ VGND VGND VPWR VPWR sky130_fd_sc_hd__diode_2
XFILLER_0_87_704 VPWR VGND VPWR VGND sky130_ef_sc_hd__decap_12
XPHY_EDGE_ROW_71_Left_191 VGND VGND VPWR VPWR sky130_fd_sc_hd__decap_3
XANTENNA__4541__S1 _1321_ VGND VGND VPWR VPWR sky130_fd_sc_hd__diode_2
XANTENNA_output113_A net113 VGND VGND VPWR VPWR sky130_fd_sc_hd__diode_2
XFILLER_0_24_14 VGND VGND VPWR VPWR sky130_fd_sc_hd__fill_2
XTAP_TAPCELL_ROW_82_1329 VGND VPWR sky130_fd_sc_hd__tapvpwrvgnd_1
XANTENNA__5310__S _1687_ VGND VGND VPWR VPWR sky130_fd_sc_hd__diode_2
XFILLER_0_86_269 VGND VGND VPWR VPWR sky130_fd_sc_hd__fill_2
XTAP_TAPCELL_ROW_15_456 VGND VPWR sky130_fd_sc_hd__tapvpwrvgnd_1
XFILLER_0_82_464 VGND VGND VPWR VPWR sky130_fd_sc_hd__fill_2
XFILLER_0_55_656 VPWR VGND VPWR VGND sky130_ef_sc_hd__decap_12
XFILLER_0_54_133 VGND VGND VPWR VPWR sky130_fd_sc_hd__fill_2
XANTENNA__7699__A1 _3472_ VGND VGND VPWR VPWR sky130_fd_sc_hd__diode_2
XFILLER_0_82_475 VGND VGND VPWR VPWR sky130_fd_sc_hd__fill_1
XFILLER_0_70_637 VGND VGND VPWR VPWR sky130_fd_sc_hd__decap_4
XANTENNA__4450__A _1240_ VGND VGND VPWR VPWR sky130_fd_sc_hd__diode_2
XFILLER_0_40_57 VGND VGND VPWR VPWR sky130_fd_sc_hd__fill_2
XFILLER_0_112_238 VGND VGND VPWR VPWR sky130_fd_sc_hd__fill_2
XFILLER_0_2_447 VGND VGND VPWR VPWR sky130_fd_sc_hd__fill_2
XFILLER_0_2_425 VGND VGND VPWR VPWR sky130_fd_sc_hd__decap_3
X_4300_ _1093_ _1096_ _1034_ VGND VGND VPWR VPWR _1097_ sky130_fd_sc_hd__mux2_1
XFILLER_0_50_394 VGND VGND VPWR VPWR sky130_fd_sc_hd__decap_6
X_5280_ _1820_ VGND VGND VPWR VPWR _2027_ sky130_fd_sc_hd__buf_4
XFILLER_0_2_458 VGND VGND VPWR VPWR sky130_fd_sc_hd__fill_2
XFILLER_0_11_726 VGND VGND VPWR VPWR sky130_fd_sc_hd__fill_2
XTAP_TAPCELL_ROW_93_1469 VGND VPWR sky130_fd_sc_hd__tapvpwrvgnd_1
X_4231_ _1030_ VGND VGND VPWR VPWR _1031_ sky130_fd_sc_hd__buf_4
XANTENNA__4596__S _1344_ VGND VGND VPWR VPWR sky130_fd_sc_hd__diode_2
XANTENNA__4685__A1 _1362_ VGND VGND VPWR VPWR sky130_fd_sc_hd__diode_2
XANTENNA__5281__A _1775_ VGND VGND VPWR VPWR sky130_fd_sc_hd__diode_2
XFILLER_0_4_24 VGND VGND VPWR VPWR sky130_fd_sc_hd__fill_2
XFILLER_0_4_57 VGND VGND VPWR VPWR sky130_fd_sc_hd__decap_8
XFILLER_0_4_46 VGND VGND VPWR VPWR sky130_fd_sc_hd__fill_2
XFILLER_0_4_35 VGND VGND VPWR VPWR sky130_fd_sc_hd__decap_4
X_8970_ clknet_leaf_37_clk _0067_ VGND VGND VPWR VPWR registers\[18\]\[10\] sky130_fd_sc_hd__dfxtp_1
XFILLER_0_4_68 VPWR VGND VPWR VGND sky130_ef_sc_hd__decap_12
X_7921_ _3894_ VGND VGND VPWR VPWR _0371_ sky130_fd_sc_hd__clkbuf_1
XFILLER_0_81_31 VGND VGND VPWR VPWR sky130_fd_sc_hd__fill_2
XFILLER_0_77_236 VGND VGND VPWR VPWR sky130_fd_sc_hd__fill_2
XFILLER_0_77_225 VGND VGND VPWR VPWR sky130_fd_sc_hd__fill_2
X_7852_ _3123_ registers\[26\]\[26\] _3851_ VGND VGND VPWR VPWR _3858_ sky130_fd_sc_hd__mux2_1
XFILLER_0_93_729 VGND VGND VPWR VPWR sky130_fd_sc_hd__fill_1
X_4995_ _1731_ VGND VGND VPWR VPWR _1757_ sky130_fd_sc_hd__buf_4
X_6803_ registers\[11\]\[31\] _3026_ _3249_ VGND VGND VPWR VPWR _3284_ sky130_fd_sc_hd__mux2_1
X_7783_ _3821_ VGND VGND VPWR VPWR _0306_ sky130_fd_sc_hd__clkbuf_1
XFILLER_0_92_228 VGND VGND VPWR VPWR sky130_fd_sc_hd__fill_2
X_9522_ clknet_leaf_67_clk _0619_ VGND VGND VPWR VPWR registers\[8\]\[18\] sky130_fd_sc_hd__dfxtp_1
X_6734_ _3247_ VGND VGND VPWR VPWR _0855_ sky130_fd_sc_hd__clkbuf_1
XFILLER_0_46_623 VGND VGND VPWR VPWR sky130_fd_sc_hd__decap_8
XFILLER_0_18_303 VGND VGND VPWR VPWR sky130_fd_sc_hd__decap_3
X_9453_ clknet_leaf_55_clk _0550_ VGND VGND VPWR VPWR registers\[31\]\[13\] sky130_fd_sc_hd__dfxtp_1
XTAP_TAPCELL_ROW_102_1587 VGND VPWR sky130_fd_sc_hd__tapvpwrvgnd_1
XFILLER_0_73_453 VGND VGND VPWR VPWR sky130_fd_sc_hd__fill_2
XFILLER_0_73_431 VGND VGND VPWR VPWR sky130_fd_sc_hd__fill_2
XFILLER_0_46_645 VGND VGND VPWR VPWR sky130_fd_sc_hd__fill_1
XFILLER_0_73_475 VGND VGND VPWR VPWR sky130_fd_sc_hd__fill_2
XFILLER_0_45_166 VGND VGND VPWR VPWR sky130_fd_sc_hd__fill_2
X_8404_ registers\[5\]\[30\] _3497_ _4116_ VGND VGND VPWR VPWR _4150_ sky130_fd_sc_hd__mux2_1
X_6665_ _3209_ VGND VGND VPWR VPWR _0824_ sky130_fd_sc_hd__clkbuf_1
XFILLER_0_104_717 VGND VGND VPWR VPWR sky130_fd_sc_hd__fill_1
X_5616_ _2349_ _2350_ VGND VGND VPWR VPWR _2351_ sky130_fd_sc_hd__nand2_1
X_9384_ clknet_leaf_17_clk _0481_ VGND VGND VPWR VPWR registers\[9\]\[8\] sky130_fd_sc_hd__dfxtp_1
XFILLER_0_61_659 VGND VGND VPWR VPWR sky130_fd_sc_hd__fill_2
X_6596_ net10 net9 net48 VGND VGND VPWR VPWR _3172_ sky130_fd_sc_hd__or3b_1
XFILLER_0_5_241 VGND VGND VPWR VPWR sky130_fd_sc_hd__fill_2
X_5547_ _1929_ _2216_ _2217_ VGND VGND VPWR VPWR _2283_ sky130_fd_sc_hd__o21ai_1
XFILLER_0_60_169 VGND VGND VPWR VPWR sky130_fd_sc_hd__decap_3
XTAP_TAPCELL_ROW_57_1000 VGND VPWR sky130_fd_sc_hd__tapvpwrvgnd_1
X_8335_ _4113_ VGND VGND VPWR VPWR _0566_ sky130_fd_sc_hd__clkbuf_1
X_5478_ _2213_ VGND VGND VPWR VPWR _2214_ sky130_fd_sc_hd__clkbuf_2
X_8266_ registers\[6\]\[29\] _3495_ _4067_ VGND VGND VPWR VPWR _4077_ sky130_fd_sc_hd__mux2_1
XFILLER_0_111_271 VGND VGND VPWR VPWR sky130_fd_sc_hd__fill_2
X_4429_ registers\[12\]\[8\] registers\[13\]\[8\] registers\[14\]\[8\] registers\[15\]\[8\]
+ _1196_ _1202_ VGND VGND VPWR VPWR _1221_ sky130_fd_sc_hd__mux4_1
X_7217_ registers\[17\]\[16\] _3468_ _3514_ VGND VGND VPWR VPWR _3521_ sky130_fd_sc_hd__mux2_1
X_8197_ _4040_ VGND VGND VPWR VPWR _0501_ sky130_fd_sc_hd__clkbuf_1
X_7148_ net29 VGND VGND VPWR VPWR _3479_ sky130_fd_sc_hd__buf_2
X_7079_ _3133_ registers\[15\]\[31\] _3397_ VGND VGND VPWR VPWR _3432_ sky130_fd_sc_hd__mux2_1
XFILLER_0_69_715 VGND VGND VPWR VPWR sky130_fd_sc_hd__fill_2
XTAP_TAPCELL_ROW_68_1140 VGND VPWR sky130_fd_sc_hd__tapvpwrvgnd_1
XANTENNA__6226__S _2460_ VGND VGND VPWR VPWR sky130_fd_sc_hd__diode_2
XFILLER_0_96_545 VGND VGND VPWR VPWR sky130_fd_sc_hd__fill_2
XANTENNA__4535__A _1201_ VGND VGND VPWR VPWR sky130_fd_sc_hd__diode_2
XFILLER_0_96_589 VGND VGND VPWR VPWR sky130_fd_sc_hd__fill_2
XFILLER_0_96_578 VGND VGND VPWR VPWR sky130_fd_sc_hd__fill_2
XFILLER_0_84_729 VGND VGND VPWR VPWR sky130_fd_sc_hd__fill_1
XFILLER_0_84_707 VGND VGND VPWR VPWR sky130_fd_sc_hd__decap_4
XFILLER_0_83_217 VGND VGND VPWR VPWR sky130_fd_sc_hd__fill_2
XANTENNA__8441__S _4164_ VGND VGND VPWR VPWR sky130_fd_sc_hd__diode_2
XFILLER_0_49_494 VGND VGND VPWR VPWR sky130_fd_sc_hd__fill_2
XANTENNA__4287__S0 _1026_ VGND VGND VPWR VPWR sky130_fd_sc_hd__diode_2
XFILLER_0_36_111 VGND VGND VPWR VPWR sky130_fd_sc_hd__fill_1
XFILLER_0_107_500 VGND VGND VPWR VPWR sky130_fd_sc_hd__fill_2
XFILLER_0_37_667 VGND VGND VPWR VPWR sky130_fd_sc_hd__fill_2
XFILLER_0_9_580 VGND VGND VPWR VPWR sky130_fd_sc_hd__fill_2
XTAP_TAPCELL_ROW_12_415 VGND VPWR sky130_fd_sc_hd__tapvpwrvgnd_1
XFILLER_0_119_393 VGND VGND VPWR VPWR sky130_fd_sc_hd__decap_6
XFILLER_0_64_475 VGND VGND VPWR VPWR sky130_fd_sc_hd__fill_1
XFILLER_0_52_626 VGND VGND VPWR VPWR sky130_fd_sc_hd__fill_2
XANTENNA__7057__S _3420_ VGND VGND VPWR VPWR sky130_fd_sc_hd__diode_2
XTAP_TAPCELL_ROW_40_779 VGND VPWR sky130_fd_sc_hd__tapvpwrvgnd_1
XFILLER_0_110_709 VGND VGND VPWR VPWR sky130_fd_sc_hd__fill_2
XTAP_TAPCELL_ROW_79_1291 VGND VPWR sky130_fd_sc_hd__tapvpwrvgnd_1
XTAP_TAPCELL_ROW_79_1280 VGND VPWR sky130_fd_sc_hd__tapvpwrvgnd_1
XFILLER_0_20_556 VGND VGND VPWR VPWR sky130_fd_sc_hd__decap_3
XANTENNA__4762__S1 _1405_ VGND VGND VPWR VPWR sky130_fd_sc_hd__diode_2
XFILLER_0_35_13 VGND VGND VPWR VPWR sky130_fd_sc_hd__fill_2
XANTENNA__5092__A1 _1771_ VGND VGND VPWR VPWR sky130_fd_sc_hd__diode_2
XTAP_TAPCELL_ROW_48_879 VGND VPWR sky130_fd_sc_hd__tapvpwrvgnd_1
XFILLER_0_35_57 VGND VGND VPWR VPWR sky130_fd_sc_hd__fill_2
XFILLER_0_87_523 VGND VGND VPWR VPWR sky130_fd_sc_hd__fill_2
XFILLER_0_59_225 VGND VGND VPWR VPWR sky130_fd_sc_hd__decap_4
XANTENNA__5919__A1 _2429_ VGND VGND VPWR VPWR sky130_fd_sc_hd__diode_2
XFILLER_0_75_729 VGND VGND VPWR VPWR sky130_fd_sc_hd__fill_1
XFILLER_0_75_707 VGND VGND VPWR VPWR sky130_fd_sc_hd__fill_2
X_4780_ registers\[20\]\[28\] registers\[21\]\[28\] registers\[22\]\[28\] registers\[23\]\[28\]
+ _1550_ _1551_ VGND VGND VPWR VPWR _1552_ sky130_fd_sc_hd__mux4_1
XFILLER_0_51_78 VGND VGND VPWR VPWR sky130_fd_sc_hd__decap_4
XFILLER_0_27_133 VGND VGND VPWR VPWR sky130_fd_sc_hd__fill_2
XFILLER_0_27_144 VGND VGND VPWR VPWR sky130_fd_sc_hd__fill_1
XFILLER_0_28_645 VGND VGND VPWR VPWR sky130_fd_sc_hd__fill_2
XFILLER_0_55_464 VGND VGND VPWR VPWR sky130_fd_sc_hd__decap_3
XFILLER_0_43_626 VGND VGND VPWR VPWR sky130_fd_sc_hd__fill_2
X_6450_ net45 VGND VGND VPWR VPWR _3083_ sky130_fd_sc_hd__buf_2
XANTENNA__7541__A0 _3085_ VGND VGND VPWR VPWR sky130_fd_sc_hd__diode_2
Xclkload10 clknet_4_11_0_clk VGND VGND VPWR VPWR clkload10/X sky130_fd_sc_hd__clkbuf_8
X_6381_ _3042_ VGND VGND VPWR VPWR _0707_ sky130_fd_sc_hd__clkbuf_1
Xclkload43 clknet_leaf_27_clk VGND VGND VPWR VPWR clkload43/Y sky130_fd_sc_hd__clkinv_4
XFILLER_0_42_147 VGND VGND VPWR VPWR sky130_fd_sc_hd__fill_2
XFILLER_0_3_723 VGND VGND VPWR VPWR sky130_fd_sc_hd__decap_4
X_5401_ registers\[24\]\[28\] registers\[25\]\[28\] registers\[26\]\[28\] registers\[27\]\[28\]
+ _2097_ _2109_ VGND VGND VPWR VPWR _2141_ sky130_fd_sc_hd__mux4_1
Xclkload21 clknet_leaf_111_clk VGND VGND VPWR VPWR clkload21/Y sky130_fd_sc_hd__clkinv_1
Xclkload32 clknet_leaf_106_clk VGND VGND VPWR VPWR clkload32/Y sky130_fd_sc_hd__clkinv_1
XFILLER_0_30_309 VGND VGND VPWR VPWR sky130_fd_sc_hd__decap_4
Xclkload54 clknet_leaf_45_clk VGND VGND VPWR VPWR clkload54/X sky130_fd_sc_hd__clkbuf_4
Xclkload76 clknet_leaf_80_clk VGND VGND VPWR VPWR clkload76/Y sky130_fd_sc_hd__clkinvlp_2
X_8120_ _3012_ registers\[30\]\[24\] _3995_ VGND VGND VPWR VPWR _4000_ sky130_fd_sc_hd__mux2_1
XFILLER_0_11_501 VGND VGND VPWR VPWR sky130_fd_sc_hd__decap_3
Xclkload65 clknet_leaf_91_clk VGND VGND VPWR VPWR clkload65/Y sky130_fd_sc_hd__clkinv_4
X_5332_ _1856_ VGND VGND VPWR VPWR _2076_ sky130_fd_sc_hd__buf_4
Xclkload87 clknet_leaf_76_clk VGND VGND VPWR VPWR clkload87/Y sky130_fd_sc_hd__clkinv_4
XFILLER_0_100_208 VGND VGND VPWR VPWR sky130_fd_sc_hd__fill_1
Xclkload98 clknet_leaf_62_clk VGND VGND VPWR VPWR clkload98/Y sky130_fd_sc_hd__clkinv_4
X_8051_ _3963_ VGND VGND VPWR VPWR _0432_ sky130_fd_sc_hd__clkbuf_1
X_5263_ _1960_ _2002_ _2010_ VGND VGND VPWR VPWR _2011_ sky130_fd_sc_hd__o21ai_4
X_5194_ registers\[16\]\[17\] registers\[17\]\[17\] registers\[18\]\[17\] registers\[19\]\[17\]
+ _1757_ _1814_ VGND VGND VPWR VPWR _1945_ sky130_fd_sc_hd__mux4_1
XFILLER_0_76_75 VGND VGND VPWR VPWR sky130_fd_sc_hd__decap_3
X_7002_ _3125_ registers\[14\]\[27\] _3383_ VGND VGND VPWR VPWR _3391_ sky130_fd_sc_hd__mux2_1
XANTENNA__8526__S _4211_ VGND VGND VPWR VPWR sky130_fd_sc_hd__diode_2
X_8953_ clknet_leaf_79_clk _0050_ VGND VGND VPWR VPWR registers\[17\]\[25\] sky130_fd_sc_hd__dfxtp_1
XTAP_TAPCELL_ROW_104_1616 VGND VPWR sky130_fd_sc_hd__tapvpwrvgnd_1
XTAP_TAPCELL_ROW_104_1605 VGND VPWR sky130_fd_sc_hd__tapvpwrvgnd_1
XFILLER_0_92_85 VGND VGND VPWR VPWR sky130_fd_sc_hd__fill_2
XFILLER_0_78_545 VGND VGND VPWR VPWR sky130_fd_sc_hd__fill_1
X_7904_ _3885_ VGND VGND VPWR VPWR _0363_ sky130_fd_sc_hd__clkbuf_1
XANTENNA__4830__A1 _1381_ VGND VGND VPWR VPWR sky130_fd_sc_hd__diode_2
X_8884_ clknet_leaf_76_clk _1005_ VGND VGND VPWR VPWR registers\[15\]\[20\] sky130_fd_sc_hd__dfxtp_1
XFILLER_0_78_589 VGND VGND VPWR VPWR sky130_fd_sc_hd__fill_2
XFILLER_0_78_567 VGND VGND VPWR VPWR sky130_fd_sc_hd__fill_2
X_7835_ _3106_ registers\[26\]\[18\] _3840_ VGND VGND VPWR VPWR _3849_ sky130_fd_sc_hd__mux2_1
XFILLER_0_93_537 VGND VGND VPWR VPWR sky130_fd_sc_hd__fill_1
XANTENNA__6032__B1 _1414_ VGND VGND VPWR VPWR sky130_fd_sc_hd__diode_2
XFILLER_0_19_612 VGND VGND VPWR VPWR sky130_fd_sc_hd__fill_2
X_7766_ _3812_ VGND VGND VPWR VPWR _0298_ sky130_fd_sc_hd__clkbuf_1
X_4978_ _1740_ VGND VGND VPWR VPWR net108 sky130_fd_sc_hd__inv_2
X_9505_ clknet_leaf_6_clk _0602_ VGND VGND VPWR VPWR registers\[8\]\[1\] sky130_fd_sc_hd__dfxtp_1
XFILLER_0_116_330 VGND VGND VPWR VPWR sky130_fd_sc_hd__fill_2
X_7697_ registers\[24\]\[17\] _3470_ _3768_ VGND VGND VPWR VPWR _3776_ sky130_fd_sc_hd__mux2_1
Xclkload4 clknet_4_5_0_clk VGND VGND VPWR VPWR clkload4/X sky130_fd_sc_hd__clkbuf_8
XTAP_TAPCELL_ROW_63_1081 VGND VPWR sky130_fd_sc_hd__tapvpwrvgnd_1
XFILLER_0_61_401 VGND VGND VPWR VPWR sky130_fd_sc_hd__fill_2
XFILLER_0_46_475 VGND VGND VPWR VPWR sky130_fd_sc_hd__fill_1
X_6717_ registers\[10\]\[22\] _3008_ _3236_ VGND VGND VPWR VPWR _3239_ sky130_fd_sc_hd__mux2_1
XFILLER_0_19_689 VGND VGND VPWR VPWR sky130_fd_sc_hd__fill_2
X_6648_ registers\[0\]\[23\] _3010_ _3197_ VGND VGND VPWR VPWR _3201_ sky130_fd_sc_hd__mux2_1
X_9436_ clknet_leaf_109_clk _0533_ VGND VGND VPWR VPWR registers\[6\]\[28\] sky130_fd_sc_hd__dfxtp_1
XFILLER_0_104_525 VGND VGND VPWR VPWR sky130_fd_sc_hd__fill_2
X_9367_ clknet_leaf_69_clk _0464_ VGND VGND VPWR VPWR registers\[30\]\[23\] sky130_fd_sc_hd__dfxtp_1
XFILLER_0_33_169 VGND VGND VPWR VPWR sky130_fd_sc_hd__fill_2
XANTENNA__7605__S _3720_ VGND VGND VPWR VPWR sky130_fd_sc_hd__diode_2
XANTENNA__4441__S0 _1197_ VGND VGND VPWR VPWR sky130_fd_sc_hd__diode_2
X_6579_ _3163_ VGND VGND VPWR VPWR _0784_ sky130_fd_sc_hd__clkbuf_1
XFILLER_0_14_372 VGND VGND VPWR VPWR sky130_fd_sc_hd__decap_4
X_8318_ _3006_ registers\[31\]\[21\] _4103_ VGND VGND VPWR VPWR _4105_ sky130_fd_sc_hd__mux2_1
XANTENNA__4814__A1_N _1438_ VGND VGND VPWR VPWR sky130_fd_sc_hd__diode_2
XTAP_TAPCELL_ROW_115_1756 VGND VPWR sky130_fd_sc_hd__tapvpwrvgnd_1
X_9298_ clknet_leaf_68_clk _0395_ VGND VGND VPWR VPWR registers\[28\]\[18\] sky130_fd_sc_hd__dfxtp_1
X_8249_ _4068_ VGND VGND VPWR VPWR _0525_ sky130_fd_sc_hd__clkbuf_1
XANTENNA__4744__S1 _1348_ VGND VGND VPWR VPWR sky130_fd_sc_hd__diode_2
XANTENNA__8260__A1 _3489_ VGND VGND VPWR VPWR sky130_fd_sc_hd__diode_2
XFILLER_0_88_309 VGND VGND VPWR VPWR sky130_fd_sc_hd__decap_3
XANTENNA__8012__A1 _3445_ VGND VGND VPWR VPWR sky130_fd_sc_hd__diode_2
XFILLER_0_69_556 VGND VGND VPWR VPWR sky130_fd_sc_hd__fill_1
XFILLER_0_57_729 VGND VGND VPWR VPWR sky130_fd_sc_hd__fill_1
XTAP_TAPCELL_ROW_45_849 VGND VPWR sky130_fd_sc_hd__tapvpwrvgnd_1
XTAP_TAPCELL_ROW_45_838 VGND VPWR sky130_fd_sc_hd__tapvpwrvgnd_1
XFILLER_0_29_409 VGND VGND VPWR VPWR sky130_fd_sc_hd__fill_2
XFILLER_0_84_537 VGND VGND VPWR VPWR sky130_fd_sc_hd__fill_2
XANTENNA__8171__S _4020_ VGND VGND VPWR VPWR sky130_fd_sc_hd__diode_2
XFILLER_0_84_559 VGND VGND VPWR VPWR sky130_fd_sc_hd__fill_2
XFILLER_0_37_442 VGND VGND VPWR VPWR sky130_fd_sc_hd__fill_2
XFILLER_0_37_420 VGND VGND VPWR VPWR sky130_fd_sc_hd__fill_1
XTAP_TAPCELL_ROW_25_584 VGND VPWR sky130_fd_sc_hd__tapvpwrvgnd_1
XANTENNA__5782__C1 _2317_ VGND VGND VPWR VPWR sky130_fd_sc_hd__diode_2
XFILLER_0_80_721 VGND VGND VPWR VPWR sky130_fd_sc_hd__fill_2
XFILLER_0_21_48 VGND VGND VPWR VPWR sky130_fd_sc_hd__fill_2
XANTENNA__4680__S0 _1433_ VGND VGND VPWR VPWR sky130_fd_sc_hd__diode_2
XANTENNA__7515__S _3670_ VGND VGND VPWR VPWR sky130_fd_sc_hd__diode_2
XANTENNA__4983__S1 _1743_ VGND VGND VPWR VPWR sky130_fd_sc_hd__diode_2
XTAP_TAPCELL_ROW_90_1428 VGND VPWR sky130_fd_sc_hd__tapvpwrvgnd_1
XANTENNA__8346__S _4117_ VGND VGND VPWR VPWR sky130_fd_sc_hd__diode_2
X_5950_ _2503_ _2510_ _2490_ VGND VGND VPWR VPWR _2672_ sky130_fd_sc_hd__mux2_1
XFILLER_0_87_320 VGND VGND VPWR VPWR sky130_fd_sc_hd__fill_2
XPHY_EDGE_ROW_9_Left_129 VGND VGND VPWR VPWR sky130_fd_sc_hd__decap_3
XFILLER_0_87_353 VGND VGND VPWR VPWR sky130_fd_sc_hd__fill_2
XFILLER_0_87_342 VGND VGND VPWR VPWR sky130_fd_sc_hd__fill_2
XFILLER_0_1_69 VPWR VGND VPWR VGND sky130_ef_sc_hd__decap_12
X_4901_ _1663_ _1666_ _1634_ VGND VGND VPWR VPWR _1667_ sky130_fd_sc_hd__mux2_1
X_7620_ _3096_ registers\[23\]\[13\] _3731_ VGND VGND VPWR VPWR _3735_ sky130_fd_sc_hd__mux2_1
X_5881_ _2508_ _2606_ _2344_ VGND VGND VPWR VPWR _2607_ sky130_fd_sc_hd__mux2_1
XFILLER_0_75_526 VGND VGND VPWR VPWR sky130_fd_sc_hd__fill_2
XANTENNA__6565__A1 _2997_ VGND VGND VPWR VPWR sky130_fd_sc_hd__diode_2
X_4832_ _1601_ VGND VGND VPWR VPWR net136 sky130_fd_sc_hd__dlymetal6s2s_1
XFILLER_0_28_431 VGND VGND VPWR VPWR sky130_fd_sc_hd__decap_4
XANTENNA__4903__A _1621_ VGND VGND VPWR VPWR sky130_fd_sc_hd__diode_2
X_7551_ _3698_ VGND VGND VPWR VPWR _0197_ sky130_fd_sc_hd__clkbuf_1
XFILLER_0_62_209 VGND VGND VPWR VPWR sky130_fd_sc_hd__fill_1
XFILLER_0_55_261 VGND VGND VPWR VPWR sky130_fd_sc_hd__fill_1
X_4763_ _1534_ _1535_ _1346_ VGND VGND VPWR VPWR _1536_ sky130_fd_sc_hd__mux2_1
X_7482_ _3094_ registers\[21\]\[12\] _3659_ VGND VGND VPWR VPWR _3662_ sky130_fd_sc_hd__mux2_1
XFILLER_0_71_732 VGND VGND VPWR VPWR sky130_fd_sc_hd__fill_1
XFILLER_0_71_721 VGND VGND VPWR VPWR sky130_fd_sc_hd__fill_2
X_4694_ _1469_ _1470_ _1344_ VGND VGND VPWR VPWR _1471_ sky130_fd_sc_hd__mux2_1
XFILLER_0_7_358 VGND VGND VPWR VPWR sky130_fd_sc_hd__decap_3
XANTENNA__4671__S0 _1382_ VGND VGND VPWR VPWR sky130_fd_sc_hd__diode_2
X_6502_ _3118_ VGND VGND VPWR VPWR _0752_ sky130_fd_sc_hd__clkbuf_1
X_9221_ clknet_leaf_26_clk _0318_ VGND VGND VPWR VPWR registers\[26\]\[5\] sky130_fd_sc_hd__dfxtp_1
XFILLER_0_70_253 VGND VGND VPWR VPWR sky130_fd_sc_hd__decap_4
X_6433_ _3071_ registers\[29\]\[1\] _3069_ VGND VGND VPWR VPWR _3072_ sky130_fd_sc_hd__mux2_1
XFILLER_0_102_94 VGND VGND VPWR VPWR sky130_fd_sc_hd__fill_2
XFILLER_0_11_81 VGND VGND VPWR VPWR sky130_fd_sc_hd__fill_2
XANTENNA__4974__S1 _1691_ VGND VGND VPWR VPWR sky130_fd_sc_hd__diode_2
X_6364_ _3033_ VGND VGND VPWR VPWR _0699_ sky130_fd_sc_hd__clkbuf_1
XFILLER_0_11_331 VGND VGND VPWR VPWR sky130_fd_sc_hd__decap_3
XFILLER_0_11_342 VGND VGND VPWR VPWR sky130_fd_sc_hd__fill_2
X_9152_ clknet_leaf_111_clk _0249_ VGND VGND VPWR VPWR registers\[24\]\[0\] sky130_fd_sc_hd__dfxtp_1
XFILLER_0_30_139 VGND VGND VPWR VPWR sky130_fd_sc_hd__fill_1
X_6295_ net19 VGND VGND VPWR VPWR _2987_ sky130_fd_sc_hd__buf_2
X_8103_ _2995_ registers\[30\]\[16\] _3984_ VGND VGND VPWR VPWR _3991_ sky130_fd_sc_hd__mux2_1
X_5315_ registers\[4\]\[23\] registers\[5\]\[23\] registers\[6\]\[23\] registers\[7\]\[23\]
+ _1798_ _1799_ VGND VGND VPWR VPWR _2060_ sky130_fd_sc_hd__mux4_1
XFILLER_0_11_364 VGND VGND VPWR VPWR sky130_fd_sc_hd__decap_3
X_9083_ clknet_leaf_102_clk _0180_ VGND VGND VPWR VPWR registers\[21\]\[27\] sky130_fd_sc_hd__dfxtp_1
XANTENNA__8490__A1 net44 VGND VGND VPWR VPWR sky130_fd_sc_hd__diode_2
X_8034_ _3954_ VGND VGND VPWR VPWR _0424_ sky130_fd_sc_hd__clkbuf_1
X_5246_ _1677_ _1986_ _1994_ VGND VGND VPWR VPWR _1995_ sky130_fd_sc_hd__o21ai_4
XPHY_EDGE_ROW_89_Right_89 VGND VGND VPWR VPWR sky130_fd_sc_hd__decap_3
XANTENNA__4726__S1 _1416_ VGND VGND VPWR VPWR sky130_fd_sc_hd__diode_2
XTAP_TAPCELL_ROW_110_1686 VGND VPWR sky130_fd_sc_hd__tapvpwrvgnd_1
X_5177_ _1929_ VGND VGND VPWR VPWR net87 sky130_fd_sc_hd__inv_2
XANTENNA__8256__S _4067_ VGND VGND VPWR VPWR sky130_fd_sc_hd__diode_2
X_8936_ clknet_leaf_12_clk _0033_ VGND VGND VPWR VPWR registers\[17\]\[8\] sky130_fd_sc_hd__dfxtp_1
XANTENNA__5151__S1 _1720_ VGND VGND VPWR VPWR sky130_fd_sc_hd__diode_2
XTAP_TAPCELL_ROW_65_1110 VGND VPWR sky130_fd_sc_hd__tapvpwrvgnd_1
XFILLER_0_78_386 VGND VGND VPWR VPWR sky130_fd_sc_hd__fill_1
XFILLER_0_66_537 VGND VGND VPWR VPWR sky130_fd_sc_hd__fill_2
X_8867_ clknet_leaf_21_clk _0988_ VGND VGND VPWR VPWR registers\[15\]\[3\] sky130_fd_sc_hd__dfxtp_1
XTAP_TAPCELL_ROW_42_808 VGND VPWR sky130_fd_sc_hd__tapvpwrvgnd_1
XFILLER_0_39_729 VGND VGND VPWR VPWR sky130_fd_sc_hd__fill_1
XFILLER_0_38_228 VGND VGND VPWR VPWR sky130_fd_sc_hd__fill_2
XANTENNA__7753__A0 _3092_ VGND VGND VPWR VPWR sky130_fd_sc_hd__diode_2
XPHY_EDGE_ROW_98_Right_98 VGND VGND VPWR VPWR sky130_fd_sc_hd__decap_3
XFILLER_0_93_334 VGND VGND VPWR VPWR sky130_fd_sc_hd__fill_2
X_8798_ clknet_leaf_13_clk _0919_ VGND VGND VPWR VPWR registers\[12\]\[30\] sky130_fd_sc_hd__dfxtp_1
X_7818_ _3828_ VGND VGND VPWR VPWR _3840_ sky130_fd_sc_hd__clkbuf_8
XANTENNA__6504__S _3111_ VGND VGND VPWR VPWR sky130_fd_sc_hd__diode_2
XFILLER_0_81_529 VGND VGND VPWR VPWR sky130_fd_sc_hd__fill_2
XFILLER_0_46_250 VGND VGND VPWR VPWR sky130_fd_sc_hd__fill_2
X_7749_ _3803_ VGND VGND VPWR VPWR _0290_ sky130_fd_sc_hd__clkbuf_1
XFILLER_0_19_453 VGND VGND VPWR VPWR sky130_fd_sc_hd__fill_2
XTAP_TAPCELL_ROW_22_543 VGND VPWR sky130_fd_sc_hd__tapvpwrvgnd_1
XFILLER_0_62_721 VGND VGND VPWR VPWR sky130_fd_sc_hd__fill_2
XANTENNA__4662__S0 _1427_ VGND VGND VPWR VPWR sky130_fd_sc_hd__diode_2
X_9419_ clknet_leaf_51_clk _0516_ VGND VGND VPWR VPWR registers\[6\]\[11\] sky130_fd_sc_hd__dfxtp_1
XFILLER_0_61_242 VPWR VGND VPWR VGND sky130_ef_sc_hd__decap_12
XANTENNA__4959__S _1682_ VGND VGND VPWR VPWR sky130_fd_sc_hd__diode_2
XANTENNA__4965__S1 _1720_ VGND VGND VPWR VPWR sky130_fd_sc_hd__diode_2
XTAP_TAPCELL_ROW_76_1250 VGND VPWR sky130_fd_sc_hd__tapvpwrvgnd_1
XFILLER_0_21_139 VGND VGND VPWR VPWR sky130_fd_sc_hd__decap_4
XFILLER_0_100_550 VPWR VGND VPWR VGND sky130_ef_sc_hd__decap_12
XANTENNA_input37_A wd3[29] VGND VGND VPWR VPWR sky130_fd_sc_hd__diode_2
XANTENNA__4694__S _1344_ VGND VGND VPWR VPWR sky130_fd_sc_hd__diode_2
XANTENNA__4717__S1 _1434_ VGND VGND VPWR VPWR sky130_fd_sc_hd__diode_2
XANTENNA__6492__A0 _3110_ VGND VGND VPWR VPWR sky130_fd_sc_hd__diode_2
XANTENNA__6475__A net22 VGND VGND VPWR VPWR sky130_fd_sc_hd__diode_2
XFILLER_0_89_629 VGND VGND VPWR VPWR sky130_fd_sc_hd__fill_1
XANTENNA__8233__A1 _3462_ VGND VGND VPWR VPWR sky130_fd_sc_hd__diode_2
XTAP_TAPCELL_ROW_87_1390 VGND VPWR sky130_fd_sc_hd__tapvpwrvgnd_1
XANTENNA__5598__A2 _2216_ VGND VGND VPWR VPWR sky130_fd_sc_hd__diode_2
XTAP_TAPCELL_ROW_2_290 VGND VPWR sky130_fd_sc_hd__tapvpwrvgnd_1
XANTENNA__7992__A0 _3020_ VGND VGND VPWR VPWR sky130_fd_sc_hd__diode_2
XANTENNA__6795__A1 _3018_ VGND VGND VPWR VPWR sky130_fd_sc_hd__diode_2
XFILLER_0_97_684 VGND VGND VPWR VPWR sky130_fd_sc_hd__fill_2
XFILLER_0_97_673 VGND VGND VPWR VPWR sky130_fd_sc_hd__decap_8
XFILLER_0_69_386 VGND VGND VPWR VPWR sky130_fd_sc_hd__fill_2
XFILLER_0_69_375 VGND VGND VPWR VPWR sky130_fd_sc_hd__decap_8
XFILLER_0_29_228 VGND VGND VPWR VPWR sky130_fd_sc_hd__fill_1
XFILLER_0_96_183 VGND VGND VPWR VPWR sky130_fd_sc_hd__decap_4
XANTENNA__7744__A0 _3083_ VGND VGND VPWR VPWR sky130_fd_sc_hd__diode_2
XANTENNA__5538__B net81 VGND VGND VPWR VPWR sky130_fd_sc_hd__diode_2
XFILLER_0_53_721 VGND VGND VPWR VPWR sky130_fd_sc_hd__decap_6
XFILLER_0_52_220 VGND VGND VPWR VPWR sky130_fd_sc_hd__decap_4
XFILLER_0_113_6 VGND VGND VPWR VPWR sky130_fd_sc_hd__fill_2
XFILLER_0_4_317 VGND VGND VPWR VPWR sky130_fd_sc_hd__fill_1
XFILLER_0_25_456 VGND VGND VPWR VPWR sky130_fd_sc_hd__fill_2
XANTENNA__5554__A _1819_ VGND VGND VPWR VPWR sky130_fd_sc_hd__diode_2
XFILLER_0_12_117 VGND VGND VPWR VPWR sky130_fd_sc_hd__fill_2
XFILLER_0_25_478 VGND VGND VPWR VPWR sky130_fd_sc_hd__fill_2
XFILLER_0_110_303 VGND VGND VPWR VPWR sky130_fd_sc_hd__fill_2
XFILLER_0_40_437 VGND VGND VPWR VPWR sky130_fd_sc_hd__fill_1
XFILLER_0_110_336 VGND VGND VPWR VPWR sky130_fd_sc_hd__fill_2
XFILLER_0_0_556 VGND VGND VPWR VPWR sky130_fd_sc_hd__fill_2
X_5100_ _1852_ _1853_ _1854_ _1855_ _1856_ _1701_ VGND VGND VPWR VPWR _1857_ sky130_fd_sc_hd__mux4_1
X_6080_ _2762_ _2793_ _2307_ VGND VGND VPWR VPWR _2794_ sky130_fd_sc_hd__mux2_1
XANTENNA__8472__A1 net39 VGND VGND VPWR VPWR sky130_fd_sc_hd__diode_2
X_5031_ registers\[4\]\[7\] registers\[5\]\[7\] registers\[6\]\[7\] registers\[7\]\[7\]
+ _1705_ _1706_ VGND VGND VPWR VPWR _1792_ sky130_fd_sc_hd__mux4_1
XFILLER_0_57_66 VGND VGND VPWR VPWR sky130_fd_sc_hd__decap_4
XANTENNA__5286__A1 _2026_ VGND VGND VPWR VPWR sky130_fd_sc_hd__diode_2
XANTENNA__8076__S _3973_ VGND VGND VPWR VPWR sky130_fd_sc_hd__diode_2
XFILLER_0_57_99 VGND VGND VPWR VPWR sky130_fd_sc_hd__fill_2
XANTENNA__5381__S1 _2120_ VGND VGND VPWR VPWR sky130_fd_sc_hd__diode_2
XANTENNA__8224__A1 _3453_ VGND VGND VPWR VPWR sky130_fd_sc_hd__diode_2
XANTENNA__5133__S1 _1692_ VGND VGND VPWR VPWR sky130_fd_sc_hd__diode_2
X_6982_ _3380_ VGND VGND VPWR VPWR _0970_ sky130_fd_sc_hd__clkbuf_1
X_8721_ clknet_leaf_63_clk _0842_ VGND VGND VPWR VPWR registers\[10\]\[17\] sky130_fd_sc_hd__dfxtp_1
XTAP_TAPCELL_ROW_0_249 VGND VPWR sky130_fd_sc_hd__tapvpwrvgnd_1
X_5933_ _2491_ _2586_ _2655_ VGND VGND VPWR VPWR _2656_ sky130_fd_sc_hd__a21bo_1
X_8652_ clknet_leaf_43_clk _0773_ VGND VGND VPWR VPWR registers\[7\]\[12\] sky130_fd_sc_hd__dfxtp_1
X_5864_ _2429_ _2577_ _2578_ _2590_ VGND VGND VPWR VPWR net80 sky130_fd_sc_hd__a31o_1
XFILLER_0_75_334 VGND VGND VPWR VPWR sky130_fd_sc_hd__fill_2
XANTENNA__6324__S _3004_ VGND VGND VPWR VPWR sky130_fd_sc_hd__diode_2
X_7603_ _3079_ registers\[23\]\[5\] _3720_ VGND VGND VPWR VPWR _3726_ sky130_fd_sc_hd__mux2_1
XFILLER_0_90_304 VGND VGND VPWR VPWR sky130_fd_sc_hd__fill_2
X_8583_ clknet_leaf_25_clk _0704_ VGND VGND VPWR VPWR registers\[3\]\[7\] sky130_fd_sc_hd__dfxtp_1
XFILLER_0_75_378 VGND VGND VPWR VPWR sky130_fd_sc_hd__fill_2
X_4815_ _1585_ VGND VGND VPWR VPWR net134 sky130_fd_sc_hd__inv_2
XFILLER_0_8_645 VGND VGND VPWR VPWR sky130_fd_sc_hd__decap_4
XFILLER_0_7_111 VGND VGND VPWR VPWR sky130_fd_sc_hd__fill_1
XFILLER_0_35_209 VGND VGND VPWR VPWR sky130_fd_sc_hd__fill_1
X_7534_ _3689_ VGND VGND VPWR VPWR _0189_ sky130_fd_sc_hd__clkbuf_1
XFILLER_0_90_348 VGND VGND VPWR VPWR sky130_fd_sc_hd__fill_2
X_5795_ _2520_ _2524_ VGND VGND VPWR VPWR _2525_ sky130_fd_sc_hd__xnor2_1
XTAP_TAPCELL_ROW_60_1040 VGND VPWR sky130_fd_sc_hd__tapvpwrvgnd_1
XFILLER_0_44_732 VGND VGND VPWR VPWR sky130_fd_sc_hd__fill_1
XFILLER_0_28_272 VGND VGND VPWR VPWR sky130_fd_sc_hd__decap_4
XFILLER_0_28_283 VGND VGND VPWR VPWR sky130_fd_sc_hd__fill_2
XANTENNA__4644__S0 _1418_ VGND VGND VPWR VPWR sky130_fd_sc_hd__diode_2
X_4746_ _1518_ _1519_ _1421_ VGND VGND VPWR VPWR _1520_ sky130_fd_sc_hd__mux2_1
X_7465_ _3077_ registers\[21\]\[4\] _3648_ VGND VGND VPWR VPWR _3653_ sky130_fd_sc_hd__mux2_1
XANTENNA__5464__A net139 VGND VGND VPWR VPWR sky130_fd_sc_hd__diode_2
XFILLER_0_71_595 VGND VGND VPWR VPWR sky130_fd_sc_hd__fill_1
XANTENNA__7155__S _3477_ VGND VGND VPWR VPWR sky130_fd_sc_hd__diode_2
X_4677_ registers\[24\]\[22\] registers\[25\]\[22\] registers\[26\]\[22\] registers\[27\]\[22\]
+ _1433_ _1434_ VGND VGND VPWR VPWR _1455_ sky130_fd_sc_hd__mux4_1
XANTENNA__4947__S1 _1691_ VGND VGND VPWR VPWR sky130_fd_sc_hd__diode_2
X_7396_ _3616_ VGND VGND VPWR VPWR _0124_ sky130_fd_sc_hd__clkbuf_1
X_6416_ _3060_ VGND VGND VPWR VPWR _0724_ sky130_fd_sc_hd__clkbuf_1
X_9204_ clknet_leaf_74_clk _0301_ VGND VGND VPWR VPWR registers\[25\]\[20\] sky130_fd_sc_hd__dfxtp_1
XTAP_TAPCELL_ROW_112_1715 VGND VPWR sky130_fd_sc_hd__tapvpwrvgnd_1
X_9135_ clknet_leaf_46_clk _0232_ VGND VGND VPWR VPWR registers\[23\]\[15\] sky130_fd_sc_hd__dfxtp_1
XANTENNA__6994__S _3383_ VGND VGND VPWR VPWR sky130_fd_sc_hd__diode_2
X_6347_ net37 VGND VGND VPWR VPWR _3022_ sky130_fd_sc_hd__buf_2
XFILLER_0_101_358 VGND VGND VPWR VPWR sky130_fd_sc_hd__fill_1
X_9066_ clknet_leaf_37_clk _0163_ VGND VGND VPWR VPWR registers\[21\]\[10\] sky130_fd_sc_hd__dfxtp_1
X_6278_ _2975_ VGND VGND VPWR VPWR _0671_ sky130_fd_sc_hd__clkbuf_1
X_8017_ _3945_ VGND VGND VPWR VPWR _0416_ sky130_fd_sc_hd__clkbuf_1
XANTENNA__6295__A net19 VGND VGND VPWR VPWR sky130_fd_sc_hd__diode_2
XTAP_TAPCELL_ROW_71_1180 VGND VPWR sky130_fd_sc_hd__tapvpwrvgnd_1
X_5229_ _1960_ _1967_ _1973_ _1978_ VGND VGND VPWR VPWR _1979_ sky130_fd_sc_hd__a2bb2o_4
XANTENNA__5403__S _2019_ VGND VGND VPWR VPWR sky130_fd_sc_hd__diode_2
XANTENNA__5372__S1 _2021_ VGND VGND VPWR VPWR sky130_fd_sc_hd__diode_2
XTAP_TAPCELL_ROW_27_613 VGND VPWR sky130_fd_sc_hd__tapvpwrvgnd_1
XFILLER_0_94_610 VPWR VGND VPWR VGND sky130_ef_sc_hd__decap_12
XFILLER_0_79_673 VGND VGND VPWR VPWR sky130_fd_sc_hd__fill_2
XTAP_TAPCELL_ROW_55_977 VGND VPWR sky130_fd_sc_hd__tapvpwrvgnd_1
X_8919_ clknet_leaf_75_clk _0016_ VGND VGND VPWR VPWR registers\[16\]\[23\] sky130_fd_sc_hd__dfxtp_1
XFILLER_0_39_526 VGND VGND VPWR VPWR sky130_fd_sc_hd__fill_2
XFILLER_0_94_643 VGND VGND VPWR VPWR sky130_fd_sc_hd__fill_1
XANTENNA__5639__A _2267_ VGND VGND VPWR VPWR sky130_fd_sc_hd__diode_2
XFILLER_0_78_194 VGND VGND VPWR VPWR sky130_fd_sc_hd__fill_2
XFILLER_0_66_334 VGND VGND VPWR VPWR sky130_fd_sc_hd__decap_3
XFILLER_0_94_698 VGND VGND VPWR VPWR sky130_fd_sc_hd__fill_2
XFILLER_0_94_676 VGND VGND VPWR VPWR sky130_fd_sc_hd__fill_1
XFILLER_0_93_164 VGND VGND VPWR VPWR sky130_fd_sc_hd__fill_2
XPHY_EDGE_ROW_117_Right_117 VGND VGND VPWR VPWR sky130_fd_sc_hd__decap_3
XFILLER_0_81_337 VGND VGND VPWR VPWR sky130_fd_sc_hd__fill_1
XFILLER_0_47_570 VGND VGND VPWR VPWR sky130_fd_sc_hd__fill_2
XFILLER_0_35_721 VGND VGND VPWR VPWR sky130_fd_sc_hd__fill_2
XFILLER_0_105_631 VGND VGND VPWR VPWR sky130_fd_sc_hd__fill_2
XANTENNA__4960__B1 _1702_ VGND VGND VPWR VPWR sky130_fd_sc_hd__diode_2
XFILLER_0_50_713 VGND VGND VPWR VPWR sky130_fd_sc_hd__decap_6
XANTENNA__7065__S _3420_ VGND VGND VPWR VPWR sky130_fd_sc_hd__diode_2
XFILLER_0_34_253 VGND VGND VPWR VPWR sky130_fd_sc_hd__fill_2
XFILLER_0_34_286 VGND VGND VPWR VPWR sky130_fd_sc_hd__decap_3
XFILLER_0_104_163 VGND VGND VPWR VPWR sky130_fd_sc_hd__decap_4
XFILLER_0_104_152 VGND VGND VPWR VPWR sky130_fd_sc_hd__fill_2
XFILLER_0_22_437 VGND VGND VPWR VPWR sky130_fd_sc_hd__fill_2
XANTENNA__8454__A1 net29 VGND VGND VPWR VPWR sky130_fd_sc_hd__diode_2
XFILLER_0_118_27 VGND VGND VPWR VPWR sky130_fd_sc_hd__fill_1
XANTENNA__6409__S _3052_ VGND VGND VPWR VPWR sky130_fd_sc_hd__diode_2
XANTENNA__5363__S1 _1997_ VGND VGND VPWR VPWR sky130_fd_sc_hd__diode_2
XANTENNA__8206__A1 _3433_ VGND VGND VPWR VPWR sky130_fd_sc_hd__diode_2
XFILLER_0_89_437 VGND VGND VPWR VPWR sky130_fd_sc_hd__fill_2
XANTENNA__6768__A1 _2991_ VGND VGND VPWR VPWR sky130_fd_sc_hd__diode_2
XFILLER_0_89_459 VGND VGND VPWR VPWR sky130_fd_sc_hd__fill_1
XANTENNA__5115__S1 _1799_ VGND VGND VPWR VPWR sky130_fd_sc_hd__diode_2
XANTENNA_clkload2_A clknet_4_3_0_clk VGND VGND VPWR VPWR sky130_fd_sc_hd__diode_2
XFILLER_0_85_621 VGND VGND VPWR VPWR sky130_fd_sc_hd__fill_1
XFILLER_0_76_109 VGND VGND VPWR VPWR sky130_fd_sc_hd__fill_2
XFILLER_0_85_654 VGND VGND VPWR VPWR sky130_fd_sc_hd__fill_2
XFILLER_0_43_68 VGND VGND VPWR VPWR sky130_fd_sc_hd__decap_3
XPHY_EDGE_ROW_99_Left_219 VGND VGND VPWR VPWR sky130_fd_sc_hd__decap_3
XFILLER_0_85_687 VGND VGND VPWR VPWR sky130_fd_sc_hd__fill_2
XFILLER_0_72_304 VGND VGND VPWR VPWR sky130_fd_sc_hd__fill_2
XFILLER_0_45_518 VGND VGND VPWR VPWR sky130_fd_sc_hd__fill_2
XANTENNA__4626__S0 _1404_ VGND VGND VPWR VPWR sky130_fd_sc_hd__diode_2
XFILLER_0_26_710 VGND VGND VPWR VPWR sky130_fd_sc_hd__fill_1
X_4600_ _1323_ VGND VGND VPWR VPWR _1382_ sky130_fd_sc_hd__clkbuf_8
XFILLER_0_115_439 VGND VGND VPWR VPWR sky130_fd_sc_hd__fill_2
XFILLER_0_111_3 VGND VGND VPWR VPWR sky130_fd_sc_hd__fill_2
X_5580_ _2313_ _2315_ _2307_ VGND VGND VPWR VPWR _2316_ sky130_fd_sc_hd__mux2_1
XANTENNA__5743__A2 _1070_ VGND VGND VPWR VPWR sky130_fd_sc_hd__diode_2
XFILLER_0_4_114 VGND VGND VPWR VPWR sky130_fd_sc_hd__fill_1
XFILLER_0_25_220 VGND VGND VPWR VPWR sky130_fd_sc_hd__fill_2
X_4531_ _1315_ _1316_ _1132_ VGND VGND VPWR VPWR _1317_ sky130_fd_sc_hd__mux2_1
XFILLER_0_4_136 VGND VGND VPWR VPWR sky130_fd_sc_hd__fill_2
X_4462_ _1250_ _1251_ _1031_ VGND VGND VPWR VPWR _1252_ sky130_fd_sc_hd__mux2_1
XANTENNA__5284__A _1746_ VGND VGND VPWR VPWR sky130_fd_sc_hd__diode_2
X_7250_ _2959_ _3212_ VGND VGND VPWR VPWR _3538_ sky130_fd_sc_hd__nor2_4
XFILLER_0_7_35 VGND VGND VPWR VPWR sky130_fd_sc_hd__fill_2
XFILLER_0_7_13 VGND VGND VPWR VPWR sky130_fd_sc_hd__decap_4
XFILLER_0_13_437 VGND VGND VPWR VPWR sky130_fd_sc_hd__fill_1
X_6201_ _2152_ _2908_ VGND VGND VPWR VPWR _2909_ sky130_fd_sc_hd__nor2_1
XFILLER_0_7_57 VGND VGND VPWR VPWR sky130_fd_sc_hd__fill_2
XFILLER_0_111_689 VGND VGND VPWR VPWR sky130_fd_sc_hd__decap_3
X_4393_ registers\[16\]\[7\] registers\[17\]\[7\] registers\[18\]\[7\] registers\[19\]\[7\]
+ _1125_ _1127_ VGND VGND VPWR VPWR _1186_ sky130_fd_sc_hd__mux4_1
X_7181_ net10 net9 net48 VGND VGND VPWR VPWR _3501_ sky130_fd_sc_hd__nand3b_4
XFILLER_0_21_481 VGND VGND VPWR VPWR sky130_fd_sc_hd__decap_3
X_6132_ _2321_ _2843_ _2467_ VGND VGND VPWR VPWR _2844_ sky130_fd_sc_hd__a21oi_1
XANTENNA__8445__A1 net24 VGND VGND VPWR VPWR sky130_fd_sc_hd__diode_2
XTAP_TAPCELL_ROW_5_319 VGND VPWR sky130_fd_sc_hd__tapvpwrvgnd_1
XFILLER_0_0_375 VGND VGND VPWR VPWR sky130_fd_sc_hd__fill_2
XFILLER_0_0_397 VGND VGND VPWR VPWR sky130_fd_sc_hd__fill_1
X_6063_ _2769_ _2770_ _2778_ _2422_ VGND VGND VPWR VPWR net61 sky130_fd_sc_hd__o22a_1
XANTENNA__4628__A _1381_ VGND VGND VPWR VPWR sky130_fd_sc_hd__diode_2
X_5014_ registers\[0\]\[6\] registers\[1\]\[6\] registers\[2\]\[6\] registers\[3\]\[6\]
+ _1773_ _1775_ VGND VGND VPWR VPWR _1776_ sky130_fd_sc_hd__mux4_1
XANTENNA__5106__S1 _1775_ VGND VGND VPWR VPWR sky130_fd_sc_hd__diode_2
XFILLER_0_16_3 VGND VGND VPWR VPWR sky130_fd_sc_hd__decap_3
XANTENNA__8534__S _4211_ VGND VGND VPWR VPWR sky130_fd_sc_hd__diode_2
X_6965_ _3371_ VGND VGND VPWR VPWR _0962_ sky130_fd_sc_hd__clkbuf_1
XFILLER_0_119_701 VPWR VGND VPWR VGND sky130_ef_sc_hd__decap_12
XANTENNA__4363__A _1124_ VGND VGND VPWR VPWR sky130_fd_sc_hd__diode_2
X_5916_ _2464_ _2570_ _2639_ _2262_ _2276_ VGND VGND VPWR VPWR _2640_ sky130_fd_sc_hd__o221a_1
XFILLER_0_76_654 VGND VGND VPWR VPWR sky130_fd_sc_hd__fill_2
XTAP_TAPCELL_ROW_52_936 VGND VPWR sky130_fd_sc_hd__tapvpwrvgnd_1
XFILLER_0_48_312 VGND VGND VPWR VPWR sky130_fd_sc_hd__fill_2
X_8704_ clknet_leaf_5_clk _0825_ VGND VGND VPWR VPWR registers\[10\]\[0\] sky130_fd_sc_hd__dfxtp_1
XFILLER_0_75_164 VGND VGND VPWR VPWR sky130_fd_sc_hd__fill_2
XFILLER_0_75_153 VGND VGND VPWR VPWR sky130_fd_sc_hd__fill_2
X_6896_ _3334_ VGND VGND VPWR VPWR _0930_ sky130_fd_sc_hd__clkbuf_1
X_8635_ clknet_leaf_89_clk _0756_ VGND VGND VPWR VPWR registers\[29\]\[27\] sky130_fd_sc_hd__dfxtp_1
XFILLER_0_91_635 VGND VGND VPWR VPWR sky130_fd_sc_hd__fill_2
XFILLER_0_75_175 VGND VGND VPWR VPWR sky130_fd_sc_hd__decap_3
X_5847_ net143 _2208_ _2483_ _2514_ _2515_ VGND VGND VPWR VPWR _2574_ sky130_fd_sc_hd__o41a_1
XANTENNA__4617__S0 _1338_ VGND VGND VPWR VPWR sky130_fd_sc_hd__diode_2
XFILLER_0_63_337 VGND VGND VPWR VPWR sky130_fd_sc_hd__fill_1
XANTENNA__7184__A1 _3433_ VGND VGND VPWR VPWR sky130_fd_sc_hd__diode_2
XFILLER_0_29_570 VGND VGND VPWR VPWR sky130_fd_sc_hd__fill_2
XFILLER_0_36_529 VGND VGND VPWR VPWR sky130_fd_sc_hd__decap_3
X_5778_ _2506_ _2507_ _2352_ VGND VGND VPWR VPWR _2508_ sky130_fd_sc_hd__mux2_1
XFILLER_0_106_417 VGND VGND VPWR VPWR sky130_fd_sc_hd__fill_1
XFILLER_0_91_668 VGND VGND VPWR VPWR sky130_fd_sc_hd__decap_4
X_8566_ clknet_leaf_94_clk _0687_ VGND VGND VPWR VPWR registers\[19\]\[22\] sky130_fd_sc_hd__dfxtp_1
XFILLER_0_8_486 VGND VGND VPWR VPWR sky130_fd_sc_hd__fill_2
XTAP_TAPCELL_ROW_32_671 VGND VPWR sky130_fd_sc_hd__tapvpwrvgnd_1
XFILLER_0_90_178 VGND VGND VPWR VPWR sky130_fd_sc_hd__fill_2
X_8497_ _4199_ VGND VGND VPWR VPWR _0642_ sky130_fd_sc_hd__clkbuf_1
X_7517_ _3129_ registers\[21\]\[29\] _3670_ VGND VGND VPWR VPWR _3680_ sky130_fd_sc_hd__mux2_1
X_4729_ registers\[28\]\[25\] registers\[29\]\[25\] registers\[30\]\[25\] registers\[31\]\[25\]
+ _1415_ _1416_ VGND VGND VPWR VPWR _1504_ sky130_fd_sc_hd__mux4_1
XFILLER_0_16_253 VGND VGND VPWR VPWR sky130_fd_sc_hd__fill_2
XFILLER_0_16_264 VGND VGND VPWR VPWR sky130_fd_sc_hd__decap_4
XFILLER_0_31_201 VPWR VGND VPWR VGND sky130_ef_sc_hd__decap_12
XANTENNA__5290__S0 _1810_ VGND VGND VPWR VPWR sky130_fd_sc_hd__diode_2
XANTENNA__6144__C1 _2420_ VGND VGND VPWR VPWR sky130_fd_sc_hd__diode_2
Xclkbuf_leaf_110_clk clknet_4_0_0_clk VGND VGND VPWR VPWR clknet_leaf_110_clk sky130_fd_sc_hd__clkbuf_8
X_7448_ _3643_ VGND VGND VPWR VPWR _0149_ sky130_fd_sc_hd__clkbuf_1
XANTENNA__5042__S0 _1798_ VGND VGND VPWR VPWR sky130_fd_sc_hd__diode_2
XFILLER_0_31_256 VGND VGND VPWR VPWR sky130_fd_sc_hd__fill_1
X_7379_ _3606_ VGND VGND VPWR VPWR _0117_ sky130_fd_sc_hd__clkbuf_1
X_9118_ clknet_leaf_97_clk _0215_ VGND VGND VPWR VPWR registers\[22\]\[30\] sky130_fd_sc_hd__dfxtp_1
XANTENNA__4538__A _1125_ VGND VGND VPWR VPWR sky130_fd_sc_hd__diode_2
X_9049_ clknet_leaf_80_clk _0146_ VGND VGND VPWR VPWR registers\[20\]\[25\] sky130_fd_sc_hd__dfxtp_1
XANTENNA__5345__S1 _2028_ VGND VGND VPWR VPWR sky130_fd_sc_hd__diode_2
XFILLER_0_67_610 VGND VGND VPWR VPWR sky130_fd_sc_hd__fill_2
XANTENNA__5369__A _2076_ VGND VGND VPWR VPWR sky130_fd_sc_hd__diode_2
XFILLER_0_109_222 VGND VGND VPWR VPWR sky130_fd_sc_hd__fill_2
XFILLER_0_104_29 VGND VGND VPWR VPWR sky130_fd_sc_hd__fill_2
XFILLER_0_66_197 VGND VGND VPWR VPWR sky130_fd_sc_hd__fill_2
XFILLER_0_66_175 VGND VGND VPWR VPWR sky130_fd_sc_hd__fill_2
XFILLER_0_39_389 VGND VGND VPWR VPWR sky130_fd_sc_hd__fill_1
XFILLER_0_81_156 VGND VGND VPWR VPWR sky130_fd_sc_hd__fill_2
XFILLER_0_81_134 VGND VGND VPWR VPWR sky130_fd_sc_hd__decap_3
XANTENNA__5186__B1 _1687_ VGND VGND VPWR VPWR sky130_fd_sc_hd__diode_2
XANTENNA__8124__A0 _3016_ VGND VGND VPWR VPWR sky130_fd_sc_hd__diode_2
XFILLER_0_2_618 VGND VGND VPWR VPWR sky130_fd_sc_hd__fill_2
Xclkbuf_leaf_101_clk clknet_4_2_0_clk VGND VGND VPWR VPWR clknet_leaf_101_clk sky130_fd_sc_hd__clkbuf_8
XTAP_TAPCELL_ROW_10_387 VGND VPWR sky130_fd_sc_hd__tapvpwrvgnd_1
XFILLER_0_50_587 VGND VGND VPWR VPWR sky130_fd_sc_hd__fill_1
XANTENNA__5336__S1 _2073_ VGND VGND VPWR VPWR sky130_fd_sc_hd__diode_2
XANTENNA__8354__S _4117_ VGND VGND VPWR VPWR sky130_fd_sc_hd__diode_2
XFILLER_0_89_234 VGND VGND VPWR VPWR sky130_fd_sc_hd__fill_2
XANTENNA__4882__S _1621_ VGND VGND VPWR VPWR sky130_fd_sc_hd__diode_2
XANTENNA__7938__A0 _2966_ VGND VGND VPWR VPWR sky130_fd_sc_hd__diode_2
XFILLER_0_77_429 VGND VGND VPWR VPWR sky130_fd_sc_hd__decap_3
XFILLER_0_58_610 VGND VGND VPWR VPWR sky130_fd_sc_hd__fill_1
XFILLER_0_54_89 VGND VGND VPWR VPWR sky130_fd_sc_hd__fill_1
X_6750_ _3256_ VGND VGND VPWR VPWR _0862_ sky130_fd_sc_hd__clkbuf_1
XANTENNA__5279__A _1771_ VGND VGND VPWR VPWR sky130_fd_sc_hd__diode_2
X_5701_ _2432_ _2433_ VGND VGND VPWR VPWR _2434_ sky130_fd_sc_hd__nor2_1
XTAP_TAPCELL_ROW_18_487 VGND VPWR sky130_fd_sc_hd__tapvpwrvgnd_1
XFILLER_0_18_518 VGND VGND VPWR VPWR sky130_fd_sc_hd__fill_2
XTAP_TAPCELL_ROW_18_498 VGND VPWR sky130_fd_sc_hd__tapvpwrvgnd_1
X_6681_ registers\[10\]\[5\] _2972_ _3214_ VGND VGND VPWR VPWR _3220_ sky130_fd_sc_hd__mux2_1
XFILLER_0_73_646 VGND VGND VPWR VPWR sky130_fd_sc_hd__decap_3
XFILLER_0_57_164 VGND VGND VPWR VPWR sky130_fd_sc_hd__fill_2
XFILLER_0_18_529 VGND VGND VPWR VPWR sky130_fd_sc_hd__decap_3
X_8420_ registers\[8\]\[5\] net43 _4153_ VGND VGND VPWR VPWR _4159_ sky130_fd_sc_hd__mux2_1
XTAP_TAPCELL_ROW_98_1529 VGND VPWR sky130_fd_sc_hd__tapvpwrvgnd_1
X_5632_ _2365_ _2366_ VGND VGND VPWR VPWR _2367_ sky130_fd_sc_hd__nand2_1
XANTENNA__6602__S _3175_ VGND VGND VPWR VPWR sky130_fd_sc_hd__diode_2
XANTENNA__4911__A _1676_ VGND VGND VPWR VPWR sky130_fd_sc_hd__diode_2
X_8351_ _4122_ VGND VGND VPWR VPWR _0573_ sky130_fd_sc_hd__clkbuf_1
XFILLER_0_115_225 VGND VGND VPWR VPWR sky130_fd_sc_hd__decap_3
X_5563_ _1780_ _2213_ VGND VGND VPWR VPWR _2299_ sky130_fd_sc_hd__or2_1
XFILLER_0_72_178 VGND VGND VPWR VPWR sky130_fd_sc_hd__fill_2
X_4514_ _1135_ _1300_ _1142_ VGND VGND VPWR VPWR _1301_ sky130_fd_sc_hd__a21oi_1
XFILLER_0_81_690 VGND VGND VPWR VPWR sky130_fd_sc_hd__decap_6
XFILLER_0_79_31 VGND VGND VPWR VPWR sky130_fd_sc_hd__fill_2
XFILLER_0_41_543 VGND VGND VPWR VPWR sky130_fd_sc_hd__fill_2
X_7302_ registers\[18\]\[24\] _3485_ _3561_ VGND VGND VPWR VPWR _3566_ sky130_fd_sc_hd__mux2_1
XFILLER_0_111_420 VGND VGND VPWR VPWR sky130_fd_sc_hd__decap_3
X_8282_ _2970_ registers\[31\]\[4\] _4081_ VGND VGND VPWR VPWR _4086_ sky130_fd_sc_hd__mux2_1
X_5494_ _2228_ _2229_ VGND VGND VPWR VPWR _2230_ sky130_fd_sc_hd__nand2_1
XANTENNA__5024__S0 _1628_ VGND VGND VPWR VPWR sky130_fd_sc_hd__diode_2
X_4445_ registers\[4\]\[9\] registers\[5\]\[9\] registers\[6\]\[9\] registers\[7\]\[9\]
+ _1110_ _1112_ VGND VGND VPWR VPWR _1236_ sky130_fd_sc_hd__mux4_1
X_7233_ _3529_ VGND VGND VPWR VPWR _0048_ sky130_fd_sc_hd__clkbuf_1
XANTENNA__7433__S _3634_ VGND VGND VPWR VPWR sky130_fd_sc_hd__diode_2
XFILLER_0_111_486 VGND VGND VPWR VPWR sky130_fd_sc_hd__fill_2
X_4376_ registers\[16\]\[6\] registers\[17\]\[6\] registers\[18\]\[6\] registers\[19\]\[6\]
+ _1167_ _1168_ VGND VGND VPWR VPWR _1170_ sky130_fd_sc_hd__mux4_1
X_7164_ registers\[16\]\[26\] _3489_ _3477_ VGND VGND VPWR VPWR _3490_ sky130_fd_sc_hd__mux2_1
XANTENNA__6049__S _2460_ VGND VGND VPWR VPWR sky130_fd_sc_hd__diode_2
XFILLER_0_95_74 VGND VGND VPWR VPWR sky130_fd_sc_hd__fill_2
XANTENNA__4358__A _1122_ VGND VGND VPWR VPWR sky130_fd_sc_hd__diode_2
X_6115_ _1500_ _2826_ VGND VGND VPWR VPWR _2827_ sky130_fd_sc_hd__xnor2_2
XFILLER_0_119_81 VGND VGND VPWR VPWR sky130_fd_sc_hd__decap_3
X_7095_ net42 VGND VGND VPWR VPWR _3443_ sky130_fd_sc_hd__buf_2
X_6046_ _2223_ _2229_ VGND VGND VPWR VPWR _2762_ sky130_fd_sc_hd__nand2_1
XANTENNA__8264__S _4067_ VGND VGND VPWR VPWR sky130_fd_sc_hd__diode_2
XTAP_TAPCELL_ROW_107_1647 VGND VPWR sky130_fd_sc_hd__tapvpwrvgnd_1
XFILLER_0_68_418 VGND VGND VPWR VPWR sky130_fd_sc_hd__fill_2
XTAP_TAPCELL_ROW_37_741 VGND VPWR sky130_fd_sc_hd__tapvpwrvgnd_1
XANTENNA_clkbuf_leaf_54_clk_A clknet_4_13_0_clk VGND VGND VPWR VPWR sky130_fd_sc_hd__diode_2
XFILLER_0_49_621 VGND VGND VPWR VPWR sky130_fd_sc_hd__fill_2
X_7997_ _3934_ VGND VGND VPWR VPWR _0407_ sky130_fd_sc_hd__clkbuf_1
XANTENNA__4838__S0 _1433_ VGND VGND VPWR VPWR sky130_fd_sc_hd__diode_2
X_6948_ _3071_ registers\[14\]\[1\] _3361_ VGND VGND VPWR VPWR _3363_ sky130_fd_sc_hd__mux2_1
X_6879_ _3071_ registers\[13\]\[1\] _3324_ VGND VGND VPWR VPWR _3326_ sky130_fd_sc_hd__mux2_1
XFILLER_0_119_597 VGND VGND VPWR VPWR sky130_fd_sc_hd__fill_2
X_8618_ clknet_leaf_38_clk _0739_ VGND VGND VPWR VPWR registers\[29\]\[10\] sky130_fd_sc_hd__dfxtp_1
XFILLER_0_91_443 VGND VGND VPWR VPWR sky130_fd_sc_hd__fill_2
XFILLER_0_48_197 VGND VGND VPWR VPWR sky130_fd_sc_hd__fill_2
XANTENNA_clkbuf_leaf_69_clk_A clknet_4_11_0_clk VGND VGND VPWR VPWR sky130_fd_sc_hd__diode_2
XFILLER_0_17_540 VGND VGND VPWR VPWR sky130_fd_sc_hd__fill_1
XFILLER_0_106_247 VGND VGND VPWR VPWR sky130_fd_sc_hd__decap_3
X_8549_ clknet_leaf_33_clk _0670_ VGND VGND VPWR VPWR registers\[19\]\[5\] sky130_fd_sc_hd__dfxtp_1
XFILLER_0_91_487 VGND VGND VPWR VPWR sky130_fd_sc_hd__fill_1
XFILLER_0_63_167 VGND VGND VPWR VPWR sky130_fd_sc_hd__fill_1
XFILLER_0_51_318 VGND VGND VPWR VPWR sky130_fd_sc_hd__fill_2
XANTENNA_clkbuf_leaf_112_clk_A clknet_4_0_0_clk VGND VGND VPWR VPWR sky130_fd_sc_hd__diode_2
XTAP_TAPCELL_ROW_118_1787 VGND VPWR sky130_fd_sc_hd__tapvpwrvgnd_1
XTAP_TAPCELL_ROW_118_1798 VGND VPWR sky130_fd_sc_hd__tapvpwrvgnd_1
XANTENNA__8439__S _4164_ VGND VGND VPWR VPWR sky130_fd_sc_hd__diode_2
XANTENNA__7343__S _3586_ VGND VGND VPWR VPWR sky130_fd_sc_hd__diode_2
XFILLER_0_102_486 VGND VGND VPWR VPWR sky130_fd_sc_hd__fill_2
XFILLER_0_87_716 VGND VGND VPWR VPWR sky130_fd_sc_hd__decap_6
XANTENNA__5099__A _1689_ VGND VGND VPWR VPWR sky130_fd_sc_hd__diode_2
XTAP_TAPCELL_ROW_82_1319 VGND VPWR sky130_fd_sc_hd__tapvpwrvgnd_1
XFILLER_0_24_26 VGND VGND VPWR VPWR sky130_fd_sc_hd__fill_2
XFILLER_0_82_421 VGND VGND VPWR VPWR sky130_fd_sc_hd__fill_2
XTAP_TAPCELL_ROW_15_457 VGND VPWR sky130_fd_sc_hd__tapvpwrvgnd_1
XFILLER_0_94_292 VGND VGND VPWR VPWR sky130_fd_sc_hd__fill_2
XFILLER_0_55_668 VGND VGND VPWR VPWR sky130_fd_sc_hd__fill_2
XFILLER_0_40_25 VGND VGND VPWR VPWR sky130_fd_sc_hd__fill_1
XFILLER_0_70_605 VGND VGND VPWR VPWR sky130_fd_sc_hd__fill_2
XFILLER_0_54_178 VGND VGND VPWR VPWR sky130_fd_sc_hd__decap_4
XANTENNA__5254__S0 _1856_ VGND VGND VPWR VPWR sky130_fd_sc_hd__diode_2
XFILLER_0_113_729 VGND VGND VPWR VPWR sky130_fd_sc_hd__decap_4
XFILLER_0_70_649 VGND VGND VPWR VPWR sky130_fd_sc_hd__fill_2
XFILLER_0_54_189 VGND VGND VPWR VPWR sky130_fd_sc_hd__fill_2
XFILLER_0_23_521 VGND VGND VPWR VPWR sky130_fd_sc_hd__decap_4
XFILLER_0_35_381 VGND VGND VPWR VPWR sky130_fd_sc_hd__decap_8
XFILLER_0_112_217 VGND VGND VPWR VPWR sky130_fd_sc_hd__decap_8
XFILLER_0_23_565 VGND VGND VPWR VPWR sky130_fd_sc_hd__fill_1
XFILLER_0_23_576 VGND VGND VPWR VPWR sky130_fd_sc_hd__fill_2
XANTENNA__7320__A1 _3433_ VGND VGND VPWR VPWR sky130_fd_sc_hd__diode_2
X_4230_ net6 VGND VGND VPWR VPWR _1030_ sky130_fd_sc_hd__inv_2
XFILLER_0_4_14 VGND VGND VPWR VPWR sky130_fd_sc_hd__decap_3
XANTENNA__5634__A1 _1995_ VGND VGND VPWR VPWR sky130_fd_sc_hd__diode_2
XANTENNA__8084__S _3973_ VGND VGND VPWR VPWR sky130_fd_sc_hd__diode_2
X_7920_ _3123_ registers\[27\]\[26\] _3887_ VGND VGND VPWR VPWR _3894_ sky130_fd_sc_hd__mux2_1
X_7851_ _3857_ VGND VGND VPWR VPWR _0338_ sky130_fd_sc_hd__clkbuf_1
XFILLER_0_81_43 VGND VGND VPWR VPWR sky130_fd_sc_hd__fill_2
X_6802_ _3283_ VGND VGND VPWR VPWR _0887_ sky130_fd_sc_hd__clkbuf_1
XTAP_TAPCELL_ROW_34_700 VGND VPWR sky130_fd_sc_hd__tapvpwrvgnd_1
X_4994_ _1714_ VGND VGND VPWR VPWR _1756_ sky130_fd_sc_hd__clkbuf_8
X_7782_ _3121_ registers\[25\]\[25\] _3815_ VGND VGND VPWR VPWR _3821_ sky130_fd_sc_hd__mux2_1
XFILLER_0_81_98 VGND VGND VPWR VPWR sky130_fd_sc_hd__fill_1
X_9521_ clknet_leaf_63_clk _0618_ VGND VGND VPWR VPWR registers\[8\]\[17\] sky130_fd_sc_hd__dfxtp_1
XANTENNA__7139__A1 _3472_ VGND VGND VPWR VPWR sky130_fd_sc_hd__diode_2
X_6733_ registers\[10\]\[30\] _3024_ _3213_ VGND VGND VPWR VPWR _3247_ sky130_fd_sc_hd__mux2_1
XFILLER_0_18_326 VGND VGND VPWR VPWR sky130_fd_sc_hd__fill_2
XTAP_TAPCELL_ROW_102_1588 VGND VPWR sky130_fd_sc_hd__tapvpwrvgnd_1
X_9452_ clknet_leaf_44_clk _0549_ VGND VGND VPWR VPWR registers\[31\]\[12\] sky130_fd_sc_hd__dfxtp_1
XANTENNA__7428__S _3623_ VGND VGND VPWR VPWR sky130_fd_sc_hd__diode_2
XFILLER_0_45_123 VGND VGND VPWR VPWR sky130_fd_sc_hd__fill_2
XFILLER_0_14_92 VGND VGND VPWR VPWR sky130_fd_sc_hd__fill_1
XANTENNA__4641__A _1140_ VGND VGND VPWR VPWR sky130_fd_sc_hd__diode_2
X_6664_ registers\[0\]\[31\] _3026_ _3174_ VGND VGND VPWR VPWR _3209_ sky130_fd_sc_hd__mux2_1
X_5615_ _2219_ _2304_ VGND VGND VPWR VPWR _2350_ sky130_fd_sc_hd__nand2_1
XFILLER_0_73_465 VGND VGND VPWR VPWR sky130_fd_sc_hd__decap_4
X_8403_ _4149_ VGND VGND VPWR VPWR _0598_ sky130_fd_sc_hd__clkbuf_1
X_9383_ clknet_leaf_29_clk _0480_ VGND VGND VPWR VPWR registers\[9\]\[7\] sky130_fd_sc_hd__dfxtp_1
XFILLER_0_104_729 VGND VGND VPWR VPWR sky130_fd_sc_hd__fill_1
X_6595_ _3171_ VGND VGND VPWR VPWR _0792_ sky130_fd_sc_hd__clkbuf_1
XFILLER_0_14_521 VGND VGND VPWR VPWR sky130_fd_sc_hd__fill_2
X_5546_ _2280_ _2281_ VGND VGND VPWR VPWR _2282_ sky130_fd_sc_hd__nand2_1
XTAP_TAPCELL_ROW_57_1001 VGND VPWR sky130_fd_sc_hd__tapvpwrvgnd_1
X_8334_ _3022_ registers\[31\]\[29\] _4103_ VGND VGND VPWR VPWR _4113_ sky130_fd_sc_hd__mux2_1
X_5477_ _2202_ _2203_ _2204_ _2212_ VGND VGND VPWR VPWR _2213_ sky130_fd_sc_hd__or4_4
XANTENNA__4787__S _1513_ VGND VGND VPWR VPWR sky130_fd_sc_hd__diode_2
X_8265_ _4076_ VGND VGND VPWR VPWR _0533_ sky130_fd_sc_hd__clkbuf_1
X_4428_ registers\[8\]\[8\] registers\[9\]\[8\] registers\[10\]\[8\] registers\[11\]\[8\]
+ _1196_ _1202_ VGND VGND VPWR VPWR _1220_ sky130_fd_sc_hd__mux4_1
XANTENNA__5472__A _1184_ VGND VGND VPWR VPWR sky130_fd_sc_hd__diode_2
X_7216_ _3520_ VGND VGND VPWR VPWR _0040_ sky130_fd_sc_hd__clkbuf_1
X_8196_ registers\[9\]\[28\] _3493_ _4031_ VGND VGND VPWR VPWR _4040_ sky130_fd_sc_hd__mux2_1
XFILLER_0_1_481 VGND VGND VPWR VPWR sky130_fd_sc_hd__fill_1
X_4359_ _1149_ _1152_ _1153_ VGND VGND VPWR VPWR _1154_ sky130_fd_sc_hd__mux2_1
X_7147_ _3478_ VGND VGND VPWR VPWR _0013_ sky130_fd_sc_hd__clkbuf_1
X_7078_ _3431_ VGND VGND VPWR VPWR _1015_ sky130_fd_sc_hd__clkbuf_1
XANTENNA__5625__A1 _2353_ VGND VGND VPWR VPWR sky130_fd_sc_hd__diode_2
X_6029_ _2741_ _2745_ VGND VGND VPWR VPWR _2747_ sky130_fd_sc_hd__or2_1
XANTENNA__6507__S _3111_ VGND VGND VPWR VPWR sky130_fd_sc_hd__diode_2
XFILLER_0_96_502 VGND VGND VPWR VPWR sky130_fd_sc_hd__fill_2
XTAP_TAPCELL_ROW_68_1141 VGND VPWR sky130_fd_sc_hd__tapvpwrvgnd_1
XANTENNA__7378__A1 _3493_ VGND VGND VPWR VPWR sky130_fd_sc_hd__diode_2
XFILLER_0_83_207 VGND VGND VPWR VPWR sky130_fd_sc_hd__fill_1
XFILLER_0_83_229 VGND VGND VPWR VPWR sky130_fd_sc_hd__fill_1
XFILLER_0_49_473 VGND VGND VPWR VPWR sky130_fd_sc_hd__fill_1
XANTENNA__4287__S1 _1027_ VGND VGND VPWR VPWR sky130_fd_sc_hd__diode_2
XFILLER_0_119_361 VGND VGND VPWR VPWR sky130_fd_sc_hd__decap_3
XFILLER_0_76_292 VGND VGND VPWR VPWR sky130_fd_sc_hd__fill_2
XANTENNA__7338__S _3575_ VGND VGND VPWR VPWR sky130_fd_sc_hd__diode_2
XFILLER_0_64_421 VGND VGND VPWR VPWR sky130_fd_sc_hd__fill_2
XFILLER_0_9_570 VGND VGND VPWR VPWR sky130_fd_sc_hd__fill_1
XTAP_TAPCELL_ROW_12_416 VGND VPWR sky130_fd_sc_hd__tapvpwrvgnd_1
XFILLER_0_37_679 VGND VGND VPWR VPWR sky130_fd_sc_hd__fill_2
XFILLER_0_9_592 VGND VGND VPWR VPWR sky130_fd_sc_hd__fill_2
XFILLER_0_64_498 VGND VGND VPWR VPWR sky130_fd_sc_hd__decap_3
XFILLER_0_52_638 VGND VGND VPWR VPWR sky130_fd_sc_hd__fill_2
XFILLER_0_24_329 VGND VGND VPWR VPWR sky130_fd_sc_hd__decap_3
XFILLER_0_36_189 VGND VGND VPWR VPWR sky130_fd_sc_hd__fill_1
XTAP_TAPCELL_ROW_79_1292 VGND VPWR sky130_fd_sc_hd__tapvpwrvgnd_1
XANTENNA__8169__S _4020_ VGND VGND VPWR VPWR sky130_fd_sc_hd__diode_2
XTAP_TAPCELL_ROW_79_1281 VGND VPWR sky130_fd_sc_hd__tapvpwrvgnd_1
XANTENNA__6478__A net23 VGND VGND VPWR VPWR sky130_fd_sc_hd__diode_2
XANTENNA__4697__S _1344_ VGND VGND VPWR VPWR sky130_fd_sc_hd__diode_2
XANTENNA__7302__A1 _3485_ VGND VGND VPWR VPWR sky130_fd_sc_hd__diode_2
XANTENNA__7073__S _3420_ VGND VGND VPWR VPWR sky130_fd_sc_hd__diode_2
XANTENNA__5864__A1 _2429_ VGND VGND VPWR VPWR sky130_fd_sc_hd__diode_2
XANTENNA__6417__S _3052_ VGND VGND VPWR VPWR sky130_fd_sc_hd__diode_2
XFILLER_0_87_513 VGND VGND VPWR VPWR sky130_fd_sc_hd__fill_1
XFILLER_0_59_204 VGND VGND VPWR VPWR sky130_fd_sc_hd__fill_2
XFILLER_0_35_69 VGND VGND VPWR VPWR sky130_fd_sc_hd__fill_2
XANTENNA__5919__A2 _2632_ VGND VGND VPWR VPWR sky130_fd_sc_hd__diode_2
XFILLER_0_87_579 VGND VGND VPWR VPWR sky130_fd_sc_hd__fill_2
XFILLER_0_59_248 VGND VGND VPWR VPWR sky130_fd_sc_hd__fill_1
XFILLER_0_74_218 VGND VGND VPWR VPWR sky130_fd_sc_hd__decap_4
XANTENNA__5557__A _1070_ VGND VGND VPWR VPWR sky130_fd_sc_hd__diode_2
XANTENNA__7248__S _3502_ VGND VGND VPWR VPWR sky130_fd_sc_hd__diode_2
XFILLER_0_82_251 VGND VGND VPWR VPWR sky130_fd_sc_hd__fill_1
XFILLER_0_82_273 VGND VGND VPWR VPWR sky130_fd_sc_hd__decap_3
XFILLER_0_70_424 VGND VGND VPWR VPWR sky130_fd_sc_hd__decap_4
X_6380_ registers\[3\]\[10\] _2982_ _3041_ VGND VGND VPWR VPWR _3042_ sky130_fd_sc_hd__mux2_1
Xclkload44 clknet_leaf_28_clk VGND VGND VPWR VPWR clkload44/Y sky130_fd_sc_hd__clkinv_4
Xclkload11 clknet_4_12_0_clk VGND VGND VPWR VPWR clkload11/Y sky130_fd_sc_hd__inv_8
XFILLER_0_70_468 VGND VGND VPWR VPWR sky130_fd_sc_hd__fill_2
X_5400_ registers\[28\]\[28\] registers\[29\]\[28\] registers\[30\]\[28\] registers\[31\]\[28\]
+ _2097_ _2109_ VGND VGND VPWR VPWR _2140_ sky130_fd_sc_hd__mux4_1
Xclkload22 clknet_leaf_112_clk VGND VGND VPWR VPWR clkload22/Y sky130_fd_sc_hd__inv_6
Xclkload33 clknet_leaf_107_clk VGND VGND VPWR VPWR clkload33/Y sky130_fd_sc_hd__clkinvlp_2
XFILLER_0_113_559 VGND VGND VPWR VPWR sky130_fd_sc_hd__fill_1
Xclkload55 clknet_leaf_35_clk VGND VGND VPWR VPWR clkload55/Y sky130_fd_sc_hd__clkinv_4
Xclkload77 clknet_leaf_81_clk VGND VGND VPWR VPWR clkload77/Y sky130_fd_sc_hd__clkinvlp_2
Xclkload66 clknet_leaf_103_clk VGND VGND VPWR VPWR clkload66/Y sky130_fd_sc_hd__clkinv_1
X_5331_ registers\[12\]\[24\] registers\[13\]\[24\] registers\[14\]\[24\] registers\[15\]\[24\]
+ _2072_ _2073_ VGND VGND VPWR VPWR _2075_ sky130_fd_sc_hd__mux4_1
Xclkload88 clknet_leaf_46_clk VGND VGND VPWR VPWR clkload88/Y sky130_fd_sc_hd__clkinvlp_4
Xclkload99 clknet_leaf_64_clk VGND VGND VPWR VPWR clkload99/Y sky130_fd_sc_hd__clkinvlp_4
X_8050_ registers\[2\]\[23\] _3483_ _3959_ VGND VGND VPWR VPWR _3963_ sky130_fd_sc_hd__mux2_1
XFILLER_0_55_7 VGND VGND VPWR VPWR sky130_fd_sc_hd__fill_1
X_7001_ _3390_ VGND VGND VPWR VPWR _0979_ sky130_fd_sc_hd__clkbuf_1
X_5262_ _2004_ _2006_ _2009_ _1756_ _1778_ VGND VGND VPWR VPWR _2010_ sky130_fd_sc_hd__a221o_1
X_5193_ registers\[20\]\[17\] registers\[21\]\[17\] registers\[22\]\[17\] registers\[23\]\[17\]
+ _1806_ _1814_ VGND VGND VPWR VPWR _1944_ sky130_fd_sc_hd__mux4_1
XFILLER_0_76_54 VGND VGND VPWR VPWR sky130_fd_sc_hd__decap_3
XANTENNA__7057__A0 _3110_ VGND VGND VPWR VPWR sky130_fd_sc_hd__diode_2
XANTENNA__6327__S _3004_ VGND VGND VPWR VPWR sky130_fd_sc_hd__diode_2
XANTENNA__6280__A1 _2976_ VGND VGND VPWR VPWR sky130_fd_sc_hd__diode_2
XANTENNA__4636__A _1128_ VGND VGND VPWR VPWR sky130_fd_sc_hd__diode_2
X_8952_ clknet_leaf_85_clk _0049_ VGND VGND VPWR VPWR registers\[17\]\[24\] sky130_fd_sc_hd__dfxtp_1
XTAP_TAPCELL_ROW_104_1606 VGND VPWR sky130_fd_sc_hd__tapvpwrvgnd_1
X_8883_ clknet_leaf_12_clk _1004_ VGND VGND VPWR VPWR registers\[15\]\[19\] sky130_fd_sc_hd__dfxtp_1
X_7903_ _3106_ registers\[27\]\[18\] _3876_ VGND VGND VPWR VPWR _3885_ sky130_fd_sc_hd__mux2_1
X_7834_ _3848_ VGND VGND VPWR VPWR _0330_ sky130_fd_sc_hd__clkbuf_1
XTAP_TAPCELL_ROW_104_1617 VGND VPWR sky130_fd_sc_hd__tapvpwrvgnd_1
XANTENNA__5144__A1_N _1677_ VGND VGND VPWR VPWR sky130_fd_sc_hd__diode_2
XFILLER_0_93_505 VGND VGND VPWR VPWR sky130_fd_sc_hd__fill_1
Xclkbuf_leaf_90_clk clknet_4_9_0_clk VGND VGND VPWR VPWR clknet_leaf_90_clk sky130_fd_sc_hd__clkbuf_8
X_7765_ _3104_ registers\[25\]\[17\] _3804_ VGND VGND VPWR VPWR _3812_ sky130_fd_sc_hd__mux2_1
XANTENNA__8309__A0 _2997_ VGND VGND VPWR VPWR sky130_fd_sc_hd__diode_2
XFILLER_0_93_527 VGND VGND VPWR VPWR sky130_fd_sc_hd__fill_1
XFILLER_0_108_309 VGND VGND VPWR VPWR sky130_fd_sc_hd__fill_2
XFILLER_0_93_549 VGND VGND VPWR VPWR sky130_fd_sc_hd__fill_2
X_4977_ _1677_ _1730_ _1739_ VGND VGND VPWR VPWR _1740_ sky130_fd_sc_hd__o21ai_4
XFILLER_0_46_421 VGND VGND VPWR VPWR sky130_fd_sc_hd__fill_2
X_9504_ clknet_leaf_5_clk _0601_ VGND VGND VPWR VPWR registers\[8\]\[0\] sky130_fd_sc_hd__dfxtp_1
XANTENNA__7158__S _3477_ VGND VGND VPWR VPWR sky130_fd_sc_hd__diode_2
X_6716_ _3238_ VGND VGND VPWR VPWR _0846_ sky130_fd_sc_hd__clkbuf_1
Xclkload5 clknet_4_6_0_clk VGND VGND VPWR VPWR clkload5/X sky130_fd_sc_hd__clkbuf_8
X_7696_ _3775_ VGND VGND VPWR VPWR _0265_ sky130_fd_sc_hd__clkbuf_1
XTAP_TAPCELL_ROW_63_1082 VGND VPWR sky130_fd_sc_hd__tapvpwrvgnd_1
XFILLER_0_46_487 VGND VGND VPWR VPWR sky130_fd_sc_hd__fill_2
X_6647_ _3200_ VGND VGND VPWR VPWR _0815_ sky130_fd_sc_hd__clkbuf_1
X_9435_ clknet_leaf_106_clk _0532_ VGND VGND VPWR VPWR registers\[6\]\[27\] sky130_fd_sc_hd__dfxtp_1
XFILLER_0_34_638 VGND VGND VPWR VPWR sky130_fd_sc_hd__fill_2
XANTENNA__7682__A _3756_ VGND VGND VPWR VPWR sky130_fd_sc_hd__diode_2
X_6578_ registers\[7\]\[23\] _3010_ _3159_ VGND VGND VPWR VPWR _3163_ sky130_fd_sc_hd__mux2_1
X_9366_ clknet_leaf_94_clk _0463_ VGND VGND VPWR VPWR registers\[30\]\[22\] sky130_fd_sc_hd__dfxtp_1
XFILLER_0_33_159 VGND VGND VPWR VPWR sky130_fd_sc_hd__decap_4
X_5529_ _2200_ _2264_ VGND VGND VPWR VPWR _2265_ sky130_fd_sc_hd__nor2_1
XFILLER_0_104_559 VGND VGND VPWR VPWR sky130_fd_sc_hd__decap_8
XANTENNA__4441__S1 _1203_ VGND VGND VPWR VPWR sky130_fd_sc_hd__diode_2
XFILLER_0_14_351 VGND VGND VPWR VPWR sky130_fd_sc_hd__fill_2
XFILLER_0_14_384 VGND VGND VPWR VPWR sky130_fd_sc_hd__fill_2
X_8317_ _4104_ VGND VGND VPWR VPWR _0557_ sky130_fd_sc_hd__clkbuf_1
XTAP_TAPCELL_ROW_115_1757 VGND VPWR sky130_fd_sc_hd__tapvpwrvgnd_1
X_9297_ clknet_leaf_55_clk _0394_ VGND VGND VPWR VPWR registers\[28\]\[17\] sky130_fd_sc_hd__dfxtp_1
XANTENNA__6298__A net20 VGND VGND VPWR VPWR sky130_fd_sc_hd__diode_2
XANTENNA__5406__S _2081_ VGND VGND VPWR VPWR sky130_fd_sc_hd__diode_2
XFILLER_0_112_581 VGND VGND VPWR VPWR sky130_fd_sc_hd__decap_6
XANTENNA__5846__A1 _2429_ VGND VGND VPWR VPWR sky130_fd_sc_hd__diode_2
X_8248_ registers\[6\]\[20\] _3476_ _4067_ VGND VGND VPWR VPWR _4068_ sky130_fd_sc_hd__mux2_1
X_8179_ _4008_ VGND VGND VPWR VPWR _4031_ sky130_fd_sc_hd__clkbuf_8
XFILLER_0_96_365 VGND VGND VPWR VPWR sky130_fd_sc_hd__decap_4
XFILLER_0_57_708 VGND VGND VPWR VPWR sky130_fd_sc_hd__fill_1
XTAP_TAPCELL_ROW_45_839 VGND VPWR sky130_fd_sc_hd__tapvpwrvgnd_1
XANTENNA__8452__S _4175_ VGND VGND VPWR VPWR sky130_fd_sc_hd__diode_2
XFILLER_0_96_376 VGND VGND VPWR VPWR sky130_fd_sc_hd__fill_2
Xclkbuf_leaf_81_clk clknet_4_10_0_clk VGND VGND VPWR VPWR clknet_leaf_81_clk sky130_fd_sc_hd__clkbuf_8
XFILLER_0_84_549 VGND VGND VPWR VPWR sky130_fd_sc_hd__decap_3
XFILLER_0_77_590 VGND VGND VPWR VPWR sky130_fd_sc_hd__fill_2
XFILLER_0_49_281 VGND VGND VPWR VPWR sky130_fd_sc_hd__decap_4
XTAP_TAPCELL_ROW_25_585 VGND VPWR sky130_fd_sc_hd__tapvpwrvgnd_1
XANTENNA__5377__A _2118_ VGND VGND VPWR VPWR sky130_fd_sc_hd__diode_2
XFILLER_0_92_582 VGND VGND VPWR VPWR sky130_fd_sc_hd__decap_6
XANTENNA__4680__S1 _1434_ VGND VGND VPWR VPWR sky130_fd_sc_hd__diode_2
XFILLER_0_107_386 VGND VGND VPWR VPWR sky130_fd_sc_hd__fill_2
XANTENNA__6700__S _3225_ VGND VGND VPWR VPWR sky130_fd_sc_hd__diode_2
XANTENNA__7592__A _3719_ VGND VGND VPWR VPWR sky130_fd_sc_hd__diode_2
XFILLER_0_24_137 VGND VGND VPWR VPWR sky130_fd_sc_hd__decap_3
XFILLER_0_103_570 VGND VGND VPWR VPWR sky130_fd_sc_hd__fill_1
XANTENNA__5837__A1 _2460_ VGND VGND VPWR VPWR sky130_fd_sc_hd__diode_2
XTAP_TAPCELL_ROW_90_1429 VGND VPWR sky130_fd_sc_hd__tapvpwrvgnd_1
XANTENNA__6001__A _2328_ VGND VGND VPWR VPWR sky130_fd_sc_hd__diode_2
XANTENNA__7531__S _3684_ VGND VGND VPWR VPWR sky130_fd_sc_hd__diode_2
XFILLER_0_46_24 VGND VGND VPWR VPWR sky130_fd_sc_hd__fill_2
XANTENNA__6262__A1 _2964_ VGND VGND VPWR VPWR sky130_fd_sc_hd__diode_2
XFILLER_0_1_15 VPWR VGND VPWR VGND sky130_ef_sc_hd__decap_12
X_5880_ _2287_ _2290_ _2291_ _2300_ _1072_ net113 VGND VGND VPWR VPWR _2606_ sky130_fd_sc_hd__mux4_1
XFILLER_0_75_505 VGND VGND VPWR VPWR sky130_fd_sc_hd__fill_2
XFILLER_0_62_23 VGND VGND VPWR VPWR sky130_fd_sc_hd__decap_4
X_4900_ _1664_ _1665_ _1621_ VGND VGND VPWR VPWR _1666_ sky130_fd_sc_hd__mux2_1
XFILLER_0_87_387 VGND VGND VPWR VPWR sky130_fd_sc_hd__decap_3
Xclkbuf_leaf_72_clk clknet_4_14_0_clk VGND VGND VPWR VPWR clknet_leaf_72_clk sky130_fd_sc_hd__clkbuf_8
X_4831_ _1438_ _1592_ _1596_ _1600_ VGND VGND VPWR VPWR _1601_ sky130_fd_sc_hd__a22o_1
XANTENNA__5448__S0 _2119_ VGND VGND VPWR VPWR sky130_fd_sc_hd__diode_2
XFILLER_0_28_421 VGND VGND VPWR VPWR sky130_fd_sc_hd__fill_2
XFILLER_0_90_519 VGND VGND VPWR VPWR sky130_fd_sc_hd__fill_2
X_7550_ _3094_ registers\[22\]\[12\] _3695_ VGND VGND VPWR VPWR _3698_ sky130_fd_sc_hd__mux2_1
XFILLER_0_7_337 VGND VGND VPWR VPWR sky130_fd_sc_hd__decap_3
XFILLER_0_16_616 VGND VGND VPWR VPWR sky130_fd_sc_hd__fill_2
X_4762_ registers\[16\]\[27\] registers\[17\]\[27\] registers\[18\]\[27\] registers\[19\]\[27\]
+ _1404_ _1405_ VGND VGND VPWR VPWR _1535_ sky130_fd_sc_hd__mux4_1
X_7481_ _3661_ VGND VGND VPWR VPWR _0164_ sky130_fd_sc_hd__clkbuf_1
XFILLER_0_70_221 VGND VGND VPWR VPWR sky130_fd_sc_hd__fill_1
X_4693_ registers\[16\]\[23\] registers\[17\]\[23\] registers\[18\]\[23\] registers\[19\]\[23\]
+ _1320_ _1321_ VGND VGND VPWR VPWR _1470_ sky130_fd_sc_hd__mux4_1
XFILLER_0_16_649 VGND VGND VPWR VPWR sky130_fd_sc_hd__fill_2
XANTENNA__4671__S1 _1383_ VGND VGND VPWR VPWR sky130_fd_sc_hd__diode_2
XFILLER_0_28_487 VGND VGND VPWR VPWR sky130_fd_sc_hd__decap_4
X_6501_ _3117_ registers\[29\]\[23\] _3111_ VGND VGND VPWR VPWR _3118_ sky130_fd_sc_hd__mux2_1
XANTENNA__6610__S _3175_ VGND VGND VPWR VPWR sky130_fd_sc_hd__diode_2
X_9220_ clknet_leaf_28_clk _0317_ VGND VGND VPWR VPWR registers\[26\]\[4\] sky130_fd_sc_hd__dfxtp_1
Xclkload100 clknet_leaf_67_clk VGND VGND VPWR VPWR clkload100/Y sky130_fd_sc_hd__clkinvlp_2
X_6432_ net27 VGND VGND VPWR VPWR _3071_ sky130_fd_sc_hd__buf_2
XFILLER_0_43_457 VGND VGND VPWR VPWR sky130_fd_sc_hd__fill_1
XANTENNA__7706__S _3779_ VGND VGND VPWR VPWR sky130_fd_sc_hd__diode_2
XFILLER_0_11_93 VGND VGND VPWR VPWR sky130_fd_sc_hd__fill_1
X_9151_ clknet_leaf_2_clk _0248_ VGND VGND VPWR VPWR registers\[23\]\[31\] sky130_fd_sc_hd__dfxtp_1
XFILLER_0_101_529 VGND VGND VPWR VPWR sky130_fd_sc_hd__fill_2
X_8102_ _3990_ VGND VGND VPWR VPWR _0456_ sky130_fd_sc_hd__clkbuf_1
XANTENNA__5226__S _1768_ VGND VGND VPWR VPWR sky130_fd_sc_hd__diode_2
X_6363_ registers\[3\]\[2\] _2966_ _3030_ VGND VGND VPWR VPWR _3033_ sky130_fd_sc_hd__mux2_1
X_6294_ _2986_ VGND VGND VPWR VPWR _0676_ sky130_fd_sc_hd__clkbuf_1
X_5314_ _1689_ _2058_ _1687_ VGND VGND VPWR VPWR _2059_ sky130_fd_sc_hd__o21a_1
XFILLER_0_11_354 VGND VGND VPWR VPWR sky130_fd_sc_hd__fill_1
X_9082_ clknet_leaf_78_clk _0179_ VGND VGND VPWR VPWR registers\[21\]\[26\] sky130_fd_sc_hd__dfxtp_1
X_8033_ registers\[2\]\[15\] _3466_ _3948_ VGND VGND VPWR VPWR _3954_ sky130_fd_sc_hd__mux2_1
X_5245_ _1988_ _1990_ _1993_ _1714_ _1702_ VGND VGND VPWR VPWR _1994_ sky130_fd_sc_hd__a221o_1
XFILLER_0_11_398 VGND VGND VPWR VPWR sky130_fd_sc_hd__decap_4
XFILLER_0_46_3 VGND VGND VPWR VPWR sky130_fd_sc_hd__decap_3
XANTENNA__7441__S _3634_ VGND VGND VPWR VPWR sky130_fd_sc_hd__diode_2
XTAP_TAPCELL_ROW_110_1687 VGND VPWR sky130_fd_sc_hd__tapvpwrvgnd_1
X_5176_ _1741_ _1920_ _1928_ VGND VGND VPWR VPWR _1929_ sky130_fd_sc_hd__o21ai_4
XANTENNA__4366__A _1127_ VGND VGND VPWR VPWR sky130_fd_sc_hd__diode_2
XANTENNA__6253__A1 _2399_ VGND VGND VPWR VPWR sky130_fd_sc_hd__diode_2
XPHY_EDGE_ROW_119_Left_239 VGND VGND VPWR VPWR sky130_fd_sc_hd__decap_3
X_8935_ clknet_leaf_23_clk _0032_ VGND VGND VPWR VPWR registers\[17\]\[7\] sky130_fd_sc_hd__dfxtp_1
XTAP_TAPCELL_ROW_65_1100 VGND VPWR sky130_fd_sc_hd__tapvpwrvgnd_1
XFILLER_0_39_719 VGND VGND VPWR VPWR sky130_fd_sc_hd__decap_4
Xclkbuf_leaf_63_clk clknet_4_14_0_clk VGND VGND VPWR VPWR clknet_leaf_63_clk sky130_fd_sc_hd__clkbuf_8
XTAP_TAPCELL_ROW_42_809 VGND VPWR sky130_fd_sc_hd__tapvpwrvgnd_1
XFILLER_0_38_218 VGND VGND VPWR VPWR sky130_fd_sc_hd__fill_1
X_8866_ clknet_leaf_4_clk _0987_ VGND VGND VPWR VPWR registers\[15\]\[2\] sky130_fd_sc_hd__dfxtp_1
XFILLER_0_93_357 VGND VGND VPWR VPWR sky130_fd_sc_hd__fill_2
XFILLER_0_93_346 VGND VGND VPWR VPWR sky130_fd_sc_hd__fill_2
X_7817_ _3839_ VGND VGND VPWR VPWR _0322_ sky130_fd_sc_hd__clkbuf_1
X_8797_ clknet_leaf_105_clk _0918_ VGND VGND VPWR VPWR registers\[12\]\[29\] sky130_fd_sc_hd__dfxtp_1
XFILLER_0_108_128 VGND VGND VPWR VPWR sky130_fd_sc_hd__fill_2
XANTENNA__5764__B1 _2216_ VGND VGND VPWR VPWR sky130_fd_sc_hd__diode_2
X_7748_ _3087_ registers\[25\]\[9\] _3793_ VGND VGND VPWR VPWR _3803_ sky130_fd_sc_hd__mux2_1
XFILLER_0_74_582 VGND VGND VPWR VPWR sky130_fd_sc_hd__fill_2
X_7679_ _3766_ VGND VGND VPWR VPWR _0257_ sky130_fd_sc_hd__clkbuf_1
XANTENNA__4662__S1 _1428_ VGND VGND VPWR VPWR sky130_fd_sc_hd__diode_2
XFILLER_0_19_498 VGND VGND VPWR VPWR sky130_fd_sc_hd__fill_1
XTAP_TAPCELL_ROW_22_544 VGND VPWR sky130_fd_sc_hd__tapvpwrvgnd_1
XANTENNA__7616__S _3731_ VGND VGND VPWR VPWR sky130_fd_sc_hd__diode_2
XFILLER_0_117_673 VPWR VGND VPWR VGND sky130_ef_sc_hd__decap_12
XFILLER_0_116_161 VGND VGND VPWR VPWR sky130_fd_sc_hd__decap_3
XFILLER_0_104_312 VGND VGND VPWR VPWR sky130_fd_sc_hd__fill_2
X_9418_ clknet_leaf_41_clk _0515_ VGND VGND VPWR VPWR registers\[6\]\[10\] sky130_fd_sc_hd__dfxtp_1
XFILLER_0_61_254 VGND VGND VPWR VPWR sky130_fd_sc_hd__fill_2
XFILLER_0_104_334 VGND VGND VPWR VPWR sky130_fd_sc_hd__fill_2
XFILLER_0_15_660 VGND VGND VPWR VPWR sky130_fd_sc_hd__fill_2
XFILLER_0_104_389 VGND VGND VPWR VPWR sky130_fd_sc_hd__decap_3
X_9349_ clknet_leaf_26_clk _0446_ VGND VGND VPWR VPWR registers\[30\]\[5\] sky130_fd_sc_hd__dfxtp_1
XTAP_TAPCELL_ROW_76_1251 VGND VPWR sky130_fd_sc_hd__tapvpwrvgnd_1
XANTENNA__4975__S _1627_ VGND VGND VPWR VPWR sky130_fd_sc_hd__diode_2
XFILLER_0_100_562 VGND VGND VPWR VPWR sky130_fd_sc_hd__fill_1
XANTENNA__8447__S _4164_ VGND VGND VPWR VPWR sky130_fd_sc_hd__diode_2
XFILLER_0_100_573 VGND VGND VPWR VPWR sky130_fd_sc_hd__decap_3
XANTENNA__7351__S _3586_ VGND VGND VPWR VPWR sky130_fd_sc_hd__diode_2
XFILLER_0_88_107 VGND VGND VPWR VPWR sky130_fd_sc_hd__fill_2
XFILLER_0_69_321 VGND VGND VPWR VPWR sky130_fd_sc_hd__decap_8
XFILLER_0_69_332 VGND VGND VPWR VPWR sky130_fd_sc_hd__fill_2
XTAP_TAPCELL_ROW_2_291 VGND VPWR sky130_fd_sc_hd__tapvpwrvgnd_1
XTAP_TAPCELL_ROW_2_280 VGND VPWR sky130_fd_sc_hd__tapvpwrvgnd_1
XANTENNA__8182__S _4031_ VGND VGND VPWR VPWR sky130_fd_sc_hd__diode_2
XANTENNA__6491__A _3068_ VGND VGND VPWR VPWR sky130_fd_sc_hd__diode_2
Xclkbuf_leaf_54_clk clknet_4_13_0_clk VGND VGND VPWR VPWR clknet_leaf_54_clk sky130_fd_sc_hd__clkbuf_8
XTAP_TAPCELL_ROW_87_1391 VGND VPWR sky130_fd_sc_hd__tapvpwrvgnd_1
XFILLER_0_37_240 VGND VGND VPWR VPWR sky130_fd_sc_hd__fill_1
XFILLER_0_108_684 VGND VGND VPWR VPWR sky130_fd_sc_hd__fill_2
XFILLER_0_52_243 VGND VGND VPWR VPWR sky130_fd_sc_hd__decap_3
XANTENNA__6430__S _3069_ VGND VGND VPWR VPWR sky130_fd_sc_hd__diode_2
XFILLER_0_25_446 VGND VGND VPWR VPWR sky130_fd_sc_hd__fill_2
XANTENNA__5554__B _2213_ VGND VGND VPWR VPWR sky130_fd_sc_hd__diode_2
XFILLER_0_52_287 VGND VGND VPWR VPWR sky130_fd_sc_hd__fill_1
XFILLER_0_40_405 VPWR VGND VPWR VGND sky130_ef_sc_hd__decap_12
XFILLER_0_110_348 VGND VGND VPWR VPWR sky130_fd_sc_hd__fill_1
XFILLER_0_110_326 VGND VGND VPWR VPWR sky130_fd_sc_hd__fill_1
XFILLER_0_57_23 VGND VGND VPWR VPWR sky130_fd_sc_hd__fill_1
XFILLER_0_20_162 VGND VGND VPWR VPWR sky130_fd_sc_hd__fill_1
XFILLER_0_21_696 VGND VGND VPWR VPWR sky130_fd_sc_hd__fill_2
X_5030_ _1687_ _1790_ VGND VGND VPWR VPWR _1791_ sky130_fd_sc_hd__nand2_1
XANTENNA__6666__A net13 VGND VGND VPWR VPWR sky130_fd_sc_hd__diode_2
X_6981_ _3104_ registers\[14\]\[17\] _3372_ VGND VGND VPWR VPWR _3380_ sky130_fd_sc_hd__mux2_1
XFILLER_0_88_663 VPWR VGND VPWR VGND sky130_ef_sc_hd__decap_12
XFILLER_0_88_641 VGND VGND VPWR VPWR sky130_fd_sc_hd__decap_3
X_5932_ _2499_ _2587_ _2639_ _2384_ net15 VGND VGND VPWR VPWR _2655_ sky130_fd_sc_hd__o221a_1
X_8720_ clknet_leaf_63_clk _0841_ VGND VGND VPWR VPWR registers\[10\]\[16\] sky130_fd_sc_hd__dfxtp_1
XANTENNA__5443__C1 _1741_ VGND VGND VPWR VPWR sky130_fd_sc_hd__diode_2
XANTENNA__5994__B1 _2713_ VGND VGND VPWR VPWR sky130_fd_sc_hd__diode_2
XFILLER_0_88_696 VGND VGND VPWR VPWR sky130_fd_sc_hd__decap_4
XFILLER_0_87_140 VGND VGND VPWR VPWR sky130_fd_sc_hd__fill_2
XANTENNA__4914__A _1629_ VGND VGND VPWR VPWR sky130_fd_sc_hd__diode_2
Xclkbuf_leaf_45_clk clknet_4_6_0_clk VGND VGND VPWR VPWR clknet_leaf_45_clk sky130_fd_sc_hd__clkbuf_8
X_8651_ clknet_leaf_51_clk _0772_ VGND VGND VPWR VPWR registers\[7\]\[11\] sky130_fd_sc_hd__dfxtp_1
X_5863_ _2322_ _2584_ _2589_ VGND VGND VPWR VPWR _2590_ sky130_fd_sc_hd__a21o_1
X_8582_ clknet_leaf_35_clk _0703_ VGND VGND VPWR VPWR registers\[3\]\[6\] sky130_fd_sc_hd__dfxtp_1
X_7602_ _3725_ VGND VGND VPWR VPWR _0221_ sky130_fd_sc_hd__clkbuf_1
X_5794_ _2477_ _2521_ _2522_ _2480_ _2523_ VGND VGND VPWR VPWR _2524_ sky130_fd_sc_hd__a221oi_2
XFILLER_0_7_123 VGND VGND VPWR VPWR sky130_fd_sc_hd__fill_2
X_4814_ _1438_ _1576_ _1580_ _1584_ VGND VGND VPWR VPWR _1585_ sky130_fd_sc_hd__o2bb2a_2
X_7533_ _3077_ registers\[22\]\[4\] _3684_ VGND VGND VPWR VPWR _3689_ sky130_fd_sc_hd__mux2_1
XTAP_TAPCELL_ROW_60_1041 VGND VPWR sky130_fd_sc_hd__tapvpwrvgnd_1
XFILLER_0_8_679 VGND VGND VPWR VPWR sky130_fd_sc_hd__fill_2
X_4745_ registers\[16\]\[26\] registers\[17\]\[26\] registers\[18\]\[26\] registers\[19\]\[26\]
+ _1347_ _1348_ VGND VGND VPWR VPWR _1519_ sky130_fd_sc_hd__mux4_1
XANTENNA__4644__S1 _1419_ VGND VGND VPWR VPWR sky130_fd_sc_hd__diode_2
XFILLER_0_114_610 VGND VGND VPWR VPWR sky130_fd_sc_hd__fill_2
XANTENNA__5745__A _1725_ VGND VGND VPWR VPWR sky130_fd_sc_hd__diode_2
XFILLER_0_71_530 VGND VGND VPWR VPWR sky130_fd_sc_hd__fill_2
XFILLER_0_7_178 VGND VGND VPWR VPWR sky130_fd_sc_hd__fill_2
XANTENNA__7499__A0 _3110_ VGND VGND VPWR VPWR sky130_fd_sc_hd__diode_2
X_7464_ _3652_ VGND VGND VPWR VPWR _0156_ sky130_fd_sc_hd__clkbuf_1
X_4676_ _1454_ VGND VGND VPWR VPWR net126 sky130_fd_sc_hd__inv_2
XFILLER_0_31_416 VGND VGND VPWR VPWR sky130_fd_sc_hd__fill_2
XFILLER_0_113_164 VGND VGND VPWR VPWR sky130_fd_sc_hd__fill_2
XFILLER_0_98_85 VGND VGND VPWR VPWR sky130_fd_sc_hd__decap_3
X_7395_ registers\[20\]\[3\] _3441_ _3612_ VGND VGND VPWR VPWR _3616_ sky130_fd_sc_hd__mux2_1
X_9203_ clknet_leaf_66_clk _0300_ VGND VGND VPWR VPWR registers\[25\]\[19\] sky130_fd_sc_hd__dfxtp_1
XFILLER_0_3_362 VGND VGND VPWR VPWR sky130_fd_sc_hd__fill_1
X_6415_ registers\[3\]\[27\] _3018_ _3052_ VGND VGND VPWR VPWR _3060_ sky130_fd_sc_hd__mux2_1
XFILLER_0_31_449 VGND VGND VPWR VPWR sky130_fd_sc_hd__fill_2
X_9134_ clknet_leaf_54_clk _0231_ VGND VGND VPWR VPWR registers\[23\]\[14\] sky130_fd_sc_hd__dfxtp_1
XTAP_TAPCELL_ROW_112_1716 VGND VPWR sky130_fd_sc_hd__tapvpwrvgnd_1
X_6346_ _3021_ VGND VGND VPWR VPWR _0693_ sky130_fd_sc_hd__clkbuf_1
X_9065_ clknet_leaf_8_clk _0162_ VGND VGND VPWR VPWR registers\[21\]\[9\] sky130_fd_sc_hd__dfxtp_1
XANTENNA__4795__S _1513_ VGND VGND VPWR VPWR sky130_fd_sc_hd__diode_2
X_6277_ registers\[19\]\[6\] _2974_ _2962_ VGND VGND VPWR VPWR _2975_ sky130_fd_sc_hd__mux2_1
X_8016_ registers\[2\]\[7\] _3449_ _3937_ VGND VGND VPWR VPWR _3945_ sky130_fd_sc_hd__mux2_1
XTAP_TAPCELL_ROW_71_1181 VGND VPWR sky130_fd_sc_hd__tapvpwrvgnd_1
X_5228_ _1771_ _1976_ _1977_ VGND VGND VPWR VPWR _1978_ sky130_fd_sc_hd__a21oi_1
X_5159_ _1677_ _1904_ _1912_ VGND VGND VPWR VPWR _1913_ sky130_fd_sc_hd__o21ai_4
XANTENNA__4580__S0 _1323_ VGND VGND VPWR VPWR sky130_fd_sc_hd__diode_2
XFILLER_0_98_449 VGND VGND VPWR VPWR sky130_fd_sc_hd__fill_2
XTAP_TAPCELL_ROW_27_614 VGND VPWR sky130_fd_sc_hd__tapvpwrvgnd_1
Xclkbuf_leaf_36_clk clknet_4_7_0_clk VGND VGND VPWR VPWR clknet_leaf_36_clk sky130_fd_sc_hd__clkbuf_8
XFILLER_0_79_685 VGND VGND VPWR VPWR sky130_fd_sc_hd__fill_1
XTAP_TAPCELL_ROW_55_978 VGND VPWR sky130_fd_sc_hd__tapvpwrvgnd_1
XFILLER_0_39_505 VGND VGND VPWR VPWR sky130_fd_sc_hd__decap_8
X_8918_ clknet_leaf_95_clk _0015_ VGND VGND VPWR VPWR registers\[16\]\[22\] sky130_fd_sc_hd__dfxtp_1
XFILLER_0_94_655 VGND VGND VPWR VPWR sky130_fd_sc_hd__decap_8
XFILLER_0_94_622 VGND VGND VPWR VPWR sky130_fd_sc_hd__decap_6
X_8849_ clknet_leaf_48_clk _0970_ VGND VGND VPWR VPWR registers\[14\]\[17\] sky130_fd_sc_hd__dfxtp_1
XFILLER_0_66_346 VGND VGND VPWR VPWR sky130_fd_sc_hd__fill_2
XFILLER_0_39_549 VGND VGND VPWR VPWR sky130_fd_sc_hd__fill_2
XFILLER_0_109_437 VGND VGND VPWR VPWR sky130_fd_sc_hd__fill_2
XFILLER_0_109_459 VGND VGND VPWR VPWR sky130_fd_sc_hd__decap_4
XFILLER_0_81_349 VGND VGND VPWR VPWR sky130_fd_sc_hd__fill_2
XANTENNA__5655__A _2344_ VGND VGND VPWR VPWR sky130_fd_sc_hd__diode_2
XANTENNA__4960__A1 _1701_ VGND VGND VPWR VPWR sky130_fd_sc_hd__diode_2
XANTENNA__4399__S0 _1136_ VGND VGND VPWR VPWR sky130_fd_sc_hd__diode_2
XFILLER_0_105_665 VGND VGND VPWR VPWR sky130_fd_sc_hd__fill_2
XFILLER_0_104_197 VPWR VGND VPWR VGND sky130_ef_sc_hd__decap_12
XFILLER_0_100_370 VGND VGND VPWR VPWR sky130_fd_sc_hd__decap_3
XANTENNA__8177__S _4020_ VGND VGND VPWR VPWR sky130_fd_sc_hd__diode_2
XTAP_TAPCELL_ROW_7_350 VGND VPWR sky130_fd_sc_hd__tapvpwrvgnd_1
XANTENNA__4476__B1 _1122_ VGND VGND VPWR VPWR sky130_fd_sc_hd__diode_2
XTAP_TAPCELL_ROW_89_1420 VGND VPWR sky130_fd_sc_hd__tapvpwrvgnd_1
XANTENNA__6217__A1 _2267_ VGND VGND VPWR VPWR sky130_fd_sc_hd__diode_2
XFILLER_0_89_449 VGND VGND VPWR VPWR sky130_fd_sc_hd__fill_2
XANTENNA__5976__B1 _2328_ VGND VGND VPWR VPWR sky130_fd_sc_hd__diode_2
XANTENNA__4323__S0 _1111_ VGND VGND VPWR VPWR sky130_fd_sc_hd__diode_2
Xclkbuf_leaf_27_clk clknet_4_5_0_clk VGND VGND VPWR VPWR clknet_leaf_27_clk sky130_fd_sc_hd__clkbuf_8
XANTENNA__7110__A net47 VGND VGND VPWR VPWR sky130_fd_sc_hd__diode_2
XFILLER_0_57_335 VGND VGND VPWR VPWR sky130_fd_sc_hd__fill_1
XFILLER_0_72_327 VGND VGND VPWR VPWR sky130_fd_sc_hd__decap_6
XANTENNA__4626__S1 _1405_ VGND VGND VPWR VPWR sky130_fd_sc_hd__diode_2
XANTENNA__8390__A1 _3483_ VGND VGND VPWR VPWR sky130_fd_sc_hd__diode_2
XFILLER_0_26_722 VGND VGND VPWR VPWR sky130_fd_sc_hd__fill_2
XANTENNA__5743__A3 _1089_ VGND VGND VPWR VPWR sky130_fd_sc_hd__diode_2
XANTENNA__7256__S _3539_ VGND VGND VPWR VPWR sky130_fd_sc_hd__diode_2
XFILLER_0_25_243 VGND VGND VPWR VPWR sky130_fd_sc_hd__fill_2
X_4530_ registers\[12\]\[14\] registers\[13\]\[14\] registers\[14\]\[14\] registers\[15\]\[14\]
+ _1198_ _1199_ VGND VGND VPWR VPWR _1316_ sky130_fd_sc_hd__mux4_1
XFILLER_0_25_276 VGND VGND VPWR VPWR sky130_fd_sc_hd__fill_2
XANTENNA__8142__A1 _3439_ VGND VGND VPWR VPWR sky130_fd_sc_hd__diode_2
X_4461_ registers\[0\]\[10\] registers\[1\]\[10\] registers\[2\]\[10\] registers\[3\]\[10\]
+ _1110_ _1112_ VGND VGND VPWR VPWR _1251_ sky130_fd_sc_hd__mux4_1
XFILLER_0_13_449 VGND VGND VPWR VPWR sky130_fd_sc_hd__fill_2
XFILLER_0_68_22 VGND VGND VPWR VPWR sky130_fd_sc_hd__decap_3
X_6200_ net133 _2881_ VGND VGND VPWR VPWR _2908_ sky130_fd_sc_hd__xnor2_1
XFILLER_0_40_268 VGND VGND VPWR VPWR sky130_fd_sc_hd__fill_2
X_7180_ _3500_ VGND VGND VPWR VPWR _0024_ sky130_fd_sc_hd__clkbuf_1
XFILLER_0_111_657 VPWR VGND VPWR VGND sky130_ef_sc_hd__decap_12
X_4392_ registers\[20\]\[7\] registers\[21\]\[7\] registers\[22\]\[7\] registers\[23\]\[7\]
+ _1125_ _1127_ VGND VGND VPWR VPWR _1185_ sky130_fd_sc_hd__mux4_1
X_6131_ _2793_ _2842_ _2353_ VGND VGND VPWR VPWR _2843_ sky130_fd_sc_hd__mux2_1
XFILLER_0_68_66 VGND VGND VPWR VPWR sky130_fd_sc_hd__fill_2
XFILLER_0_0_332 VGND VGND VPWR VPWR sky130_fd_sc_hd__fill_2
XFILLER_0_110_189 VGND VGND VPWR VPWR sky130_fd_sc_hd__decap_4
XFILLER_0_0_365 VGND VGND VPWR VPWR sky130_fd_sc_hd__fill_1
X_6062_ _2772_ _2777_ VGND VGND VPWR VPWR _2778_ sky130_fd_sc_hd__xnor2_2
XFILLER_0_84_43 VGND VGND VPWR VPWR sky130_fd_sc_hd__fill_2
X_5013_ _1774_ VGND VGND VPWR VPWR _1775_ sky130_fd_sc_hd__buf_4
XANTENNA__6208__A1 _1569_ VGND VGND VPWR VPWR sky130_fd_sc_hd__diode_2
Xclkbuf_leaf_18_clk clknet_4_4_0_clk VGND VGND VPWR VPWR clknet_leaf_18_clk sky130_fd_sc_hd__clkbuf_8
X_6964_ _3087_ registers\[14\]\[9\] _3361_ VGND VGND VPWR VPWR _3371_ sky130_fd_sc_hd__mux2_1
XPHY_EDGE_ROW_5_Right_5 VGND VGND VPWR VPWR sky130_fd_sc_hd__decap_3
XFILLER_0_119_713 VPWR VGND VPWR VGND sky130_ef_sc_hd__decap_12
X_5915_ _2200_ _2359_ VGND VGND VPWR VPWR _2639_ sky130_fd_sc_hd__or2_1
X_6895_ _3087_ registers\[13\]\[9\] _3324_ VGND VGND VPWR VPWR _3334_ sky130_fd_sc_hd__mux2_1
X_8703_ clknet_leaf_98_clk _0824_ VGND VGND VPWR VPWR registers\[0\]\[31\] sky130_fd_sc_hd__dfxtp_1
XFILLER_0_118_201 VGND VGND VPWR VPWR sky130_fd_sc_hd__fill_1
X_5846_ _2429_ _2559_ _2573_ VGND VGND VPWR VPWR net79 sky130_fd_sc_hd__a21oi_1
XFILLER_0_76_666 VGND VGND VPWR VPWR sky130_fd_sc_hd__fill_2
XTAP_TAPCELL_ROW_52_937 VGND VPWR sky130_fd_sc_hd__tapvpwrvgnd_1
XFILLER_0_8_410 VGND VGND VPWR VPWR sky130_fd_sc_hd__fill_2
X_8634_ clknet_leaf_77_clk _0755_ VGND VGND VPWR VPWR registers\[29\]\[26\] sky130_fd_sc_hd__dfxtp_1
XFILLER_0_91_647 VGND VGND VPWR VPWR sky130_fd_sc_hd__decap_8
XFILLER_0_76_699 VGND VGND VPWR VPWR sky130_fd_sc_hd__fill_1
XFILLER_0_75_187 VGND VGND VPWR VPWR sky130_fd_sc_hd__fill_2
XANTENNA__4617__S1 _1339_ VGND VGND VPWR VPWR sky130_fd_sc_hd__diode_2
X_5777_ net113 _2299_ _2305_ VGND VGND VPWR VPWR _2507_ sky130_fd_sc_hd__o21a_1
XFILLER_0_44_541 VGND VGND VPWR VPWR sky130_fd_sc_hd__fill_2
XFILLER_0_8_498 VGND VGND VPWR VPWR sky130_fd_sc_hd__fill_2
X_8565_ clknet_leaf_83_clk _0686_ VGND VGND VPWR VPWR registers\[19\]\[21\] sky130_fd_sc_hd__dfxtp_1
XTAP_TAPCELL_ROW_32_672 VGND VPWR sky130_fd_sc_hd__tapvpwrvgnd_1
X_8496_ registers\[4\]\[9\] net47 _4189_ VGND VGND VPWR VPWR _4199_ sky130_fd_sc_hd__mux2_1
X_7516_ _3679_ VGND VGND VPWR VPWR _0181_ sky130_fd_sc_hd__clkbuf_1
X_4728_ _1501_ _1502_ _1421_ VGND VGND VPWR VPWR _1503_ sky130_fd_sc_hd__mux2_1
XFILLER_0_16_243 VGND VGND VPWR VPWR sky130_fd_sc_hd__fill_2
XANTENNA__5290__S1 _1811_ VGND VGND VPWR VPWR sky130_fd_sc_hd__diode_2
XFILLER_0_71_393 VGND VGND VPWR VPWR sky130_fd_sc_hd__decap_6
X_7447_ registers\[20\]\[28\] _3493_ _3634_ VGND VGND VPWR VPWR _3643_ sky130_fd_sc_hd__mux2_1
XFILLER_0_31_213 VGND VGND VPWR VPWR sky130_fd_sc_hd__fill_1
X_4659_ _1389_ _1437_ _1438_ VGND VGND VPWR VPWR _1439_ sky130_fd_sc_hd__a21oi_1
XANTENNA__5042__S1 _1799_ VGND VGND VPWR VPWR sky130_fd_sc_hd__diode_2
XFILLER_0_102_668 VGND VGND VPWR VPWR sky130_fd_sc_hd__fill_1
XFILLER_0_101_156 VGND VGND VPWR VPWR sky130_fd_sc_hd__decap_3
XTAP_TAPCELL_ROW_73_1210 VGND VPWR sky130_fd_sc_hd__tapvpwrvgnd_1
X_7378_ registers\[1\]\[28\] _3493_ _3597_ VGND VGND VPWR VPWR _3606_ sky130_fd_sc_hd__mux2_1
X_6329_ net31 VGND VGND VPWR VPWR _3010_ sky130_fd_sc_hd__buf_2
X_9117_ clknet_leaf_104_clk _0214_ VGND VGND VPWR VPWR registers\[22\]\[29\] sky130_fd_sc_hd__dfxtp_1
XFILLER_0_12_493 VGND VGND VPWR VPWR sky130_fd_sc_hd__fill_2
X_9048_ clknet_leaf_86_clk _0145_ VGND VGND VPWR VPWR registers\[20\]\[24\] sky130_fd_sc_hd__dfxtp_1
XFILLER_0_99_703 VGND VGND VPWR VPWR sky130_fd_sc_hd__decap_8
XFILLER_0_98_235 VGND VGND VPWR VPWR sky130_fd_sc_hd__fill_2
XFILLER_0_79_471 VGND VGND VPWR VPWR sky130_fd_sc_hd__fill_2
XANTENNA__4554__A _1201_ VGND VGND VPWR VPWR sky130_fd_sc_hd__diode_2
XANTENNA__4305__S0 _1039_ VGND VGND VPWR VPWR sky130_fd_sc_hd__diode_2
XTAP_TAPCELL_ROW_84_1350 VGND VPWR sky130_fd_sc_hd__tapvpwrvgnd_1
XFILLER_0_109_212 VGND VGND VPWR VPWR sky130_fd_sc_hd__fill_2
XFILLER_0_94_463 VGND VGND VPWR VPWR sky130_fd_sc_hd__fill_2
XFILLER_0_67_677 VGND VGND VPWR VPWR sky130_fd_sc_hd__decap_3
XFILLER_0_66_154 VGND VGND VPWR VPWR sky130_fd_sc_hd__decap_3
XFILLER_0_66_132 VGND VGND VPWR VPWR sky130_fd_sc_hd__decap_8
XFILLER_0_39_368 VPWR VGND VPWR VGND sky130_ef_sc_hd__decap_12
XANTENNA__7865__A _3864_ VGND VGND VPWR VPWR sky130_fd_sc_hd__diode_2
XANTENNA__8460__S _4175_ VGND VGND VPWR VPWR sky130_fd_sc_hd__diode_2
XFILLER_0_82_614 VPWR VGND VPWR VGND sky130_ef_sc_hd__decap_12
XANTENNA__5186__A1 _1746_ VGND VGND VPWR VPWR sky130_fd_sc_hd__diode_2
XANTENNA__5385__A _2020_ VGND VGND VPWR VPWR sky130_fd_sc_hd__diode_2
XFILLER_0_35_541 VGND VGND VPWR VPWR sky130_fd_sc_hd__decap_3
XFILLER_0_62_360 VGND VGND VPWR VPWR sky130_fd_sc_hd__fill_2
XANTENNA__7804__S _3829_ VGND VGND VPWR VPWR sky130_fd_sc_hd__diode_2
XFILLER_0_50_566 VGND VGND VPWR VPWR sky130_fd_sc_hd__fill_2
XTAP_TAPCELL_ROW_10_388 VGND VPWR sky130_fd_sc_hd__tapvpwrvgnd_1
XFILLER_0_22_257 VGND VGND VPWR VPWR sky130_fd_sc_hd__fill_1
XTAP_TAPCELL_ROW_95_1490 VGND VPWR sky130_fd_sc_hd__tapvpwrvgnd_1
XANTENNA__7635__A0 _3110_ VGND VGND VPWR VPWR sky130_fd_sc_hd__diode_2
XANTENNA__4544__S0 _1136_ VGND VGND VPWR VPWR sky130_fd_sc_hd__diode_2
XFILLER_0_89_213 VGND VGND VPWR VPWR sky130_fd_sc_hd__fill_1
XFILLER_0_54_68 VGND VGND VPWR VPWR sky130_fd_sc_hd__fill_2
XANTENNA__6610__A1 _2972_ VGND VGND VPWR VPWR sky130_fd_sc_hd__diode_2
XFILLER_0_97_290 VGND VGND VPWR VPWR sky130_fd_sc_hd__decap_4
X_5700_ _1704_ _2431_ VGND VGND VPWR VPWR _2433_ sky130_fd_sc_hd__nor2_1
XTAP_TAPCELL_ROW_18_488 VGND VPWR sky130_fd_sc_hd__tapvpwrvgnd_1
XTAP_TAPCELL_ROW_18_499 VGND VPWR sky130_fd_sc_hd__tapvpwrvgnd_1
X_6680_ _3219_ VGND VGND VPWR VPWR _0829_ sky130_fd_sc_hd__clkbuf_1
XANTENNA__8363__A1 _3455_ VGND VGND VPWR VPWR sky130_fd_sc_hd__diode_2
XFILLER_0_115_204 VGND VGND VPWR VPWR sky130_fd_sc_hd__fill_2
X_5631_ _1959_ _2234_ _2219_ VGND VGND VPWR VPWR _2366_ sky130_fd_sc_hd__o21ai_1
XFILLER_0_73_658 VPWR VGND VPWR VGND sky130_ef_sc_hd__decap_12
XFILLER_0_57_198 VGND VGND VPWR VPWR sky130_fd_sc_hd__decap_3
XFILLER_0_115_248 VGND VGND VPWR VPWR sky130_fd_sc_hd__decap_8
X_8350_ registers\[5\]\[4\] _3443_ _4117_ VGND VGND VPWR VPWR _4122_ sky130_fd_sc_hd__mux2_1
X_5562_ _2297_ VGND VGND VPWR VPWR _2298_ sky130_fd_sc_hd__buf_2
XFILLER_0_79_10 VGND VGND VPWR VPWR sky130_fd_sc_hd__decap_4
XFILLER_0_72_157 VGND VGND VPWR VPWR sky130_fd_sc_hd__fill_1
XFILLER_0_53_360 VGND VGND VPWR VPWR sky130_fd_sc_hd__decap_4
X_4513_ _1298_ _1299_ _1148_ VGND VGND VPWR VPWR _1300_ sky130_fd_sc_hd__mux2_1
X_8281_ _4085_ VGND VGND VPWR VPWR _0540_ sky130_fd_sc_hd__clkbuf_1
X_7301_ _3565_ VGND VGND VPWR VPWR _0080_ sky130_fd_sc_hd__clkbuf_1
XFILLER_0_13_202 VGND VGND VPWR VPWR sky130_fd_sc_hd__fill_1
XANTENNA__5024__S1 _1629_ VGND VGND VPWR VPWR sky130_fd_sc_hd__diode_2
X_5493_ _2011_ _2216_ _2220_ VGND VGND VPWR VPWR _2229_ sky130_fd_sc_hd__o21ai_1
X_7232_ registers\[17\]\[23\] _3483_ _3525_ VGND VGND VPWR VPWR _3529_ sky130_fd_sc_hd__mux2_1
XFILLER_0_41_555 VGND VGND VPWR VPWR sky130_fd_sc_hd__fill_2
XANTENNA__7714__S _3779_ VGND VGND VPWR VPWR sky130_fd_sc_hd__diode_2
X_4444_ _1131_ _1232_ _1234_ _1034_ VGND VGND VPWR VPWR _1235_ sky130_fd_sc_hd__o211a_1
Xclkbuf_leaf_7_clk clknet_4_1_0_clk VGND VGND VPWR VPWR clknet_leaf_7_clk sky130_fd_sc_hd__clkbuf_8
X_4375_ registers\[20\]\[6\] registers\[21\]\[6\] registers\[22\]\[6\] registers\[23\]\[6\]
+ _1167_ _1168_ VGND VGND VPWR VPWR _1169_ sky130_fd_sc_hd__mux4_1
XANTENNA__4639__A _1199_ VGND VGND VPWR VPWR sky130_fd_sc_hd__diode_2
X_7163_ net34 VGND VGND VPWR VPWR _3489_ sky130_fd_sc_hd__clkbuf_4
X_7094_ _3442_ VGND VGND VPWR VPWR _1020_ sky130_fd_sc_hd__clkbuf_1
X_6114_ _2707_ _2825_ VGND VGND VPWR VPWR _2826_ sky130_fd_sc_hd__nor2_1
X_6045_ _2399_ _2754_ _2761_ VGND VGND VPWR VPWR net59 sky130_fd_sc_hd__o21ai_1
XTAP_TAPCELL_ROW_107_1648 VGND VPWR sky130_fd_sc_hd__tapvpwrvgnd_1
XANTENNA__4374__A _1112_ VGND VGND VPWR VPWR sky130_fd_sc_hd__diode_2
XTAP_TAPCELL_ROW_37_742 VGND VPWR sky130_fd_sc_hd__tapvpwrvgnd_1
X_7996_ _3024_ registers\[28\]\[30\] _3900_ VGND VGND VPWR VPWR _3934_ sky130_fd_sc_hd__mux2_1
XANTENNA__7659__A_N net11 VGND VGND VPWR VPWR sky130_fd_sc_hd__diode_2
XANTENNA__4838__S1 _1434_ VGND VGND VPWR VPWR sky130_fd_sc_hd__diode_2
XANTENNA__8280__S _4081_ VGND VGND VPWR VPWR sky130_fd_sc_hd__diode_2
XFILLER_0_49_666 VGND VGND VPWR VPWR sky130_fd_sc_hd__decap_6
XFILLER_0_48_132 VGND VGND VPWR VPWR sky130_fd_sc_hd__fill_2
XFILLER_0_48_121 VGND VGND VPWR VPWR sky130_fd_sc_hd__fill_1
X_6947_ _3362_ VGND VGND VPWR VPWR _0953_ sky130_fd_sc_hd__clkbuf_1
XANTENNA__8354__A1 _3447_ VGND VGND VPWR VPWR sky130_fd_sc_hd__diode_2
XFILLER_0_76_485 VGND VGND VPWR VPWR sky130_fd_sc_hd__fill_1
XFILLER_0_76_474 VGND VGND VPWR VPWR sky130_fd_sc_hd__fill_2
XFILLER_0_64_636 VGND VGND VPWR VPWR sky130_fd_sc_hd__fill_2
XFILLER_0_49_699 VGND VGND VPWR VPWR sky130_fd_sc_hd__fill_2
X_6878_ _3325_ VGND VGND VPWR VPWR _0921_ sky130_fd_sc_hd__clkbuf_1
X_5829_ _2551_ _2556_ VGND VGND VPWR VPWR _2557_ sky130_fd_sc_hd__nor2_1
XFILLER_0_64_658 VGND VGND VPWR VPWR sky130_fd_sc_hd__fill_2
X_8617_ clknet_leaf_7_clk _0738_ VGND VGND VPWR VPWR registers\[29\]\[9\] sky130_fd_sc_hd__dfxtp_1
XFILLER_0_36_338 VGND VGND VPWR VPWR sky130_fd_sc_hd__decap_3
X_8548_ clknet_leaf_29_clk _0669_ VGND VGND VPWR VPWR registers\[19\]\[4\] sky130_fd_sc_hd__dfxtp_1
XFILLER_0_44_360 VGND VGND VPWR VPWR sky130_fd_sc_hd__fill_2
XFILLER_0_72_680 VGND VGND VPWR VPWR sky130_fd_sc_hd__decap_8
XFILLER_0_17_585 VGND VGND VPWR VPWR sky130_fd_sc_hd__fill_2
XTAP_TAPCELL_ROW_118_1788 VGND VPWR sky130_fd_sc_hd__tapvpwrvgnd_1
XANTENNA__7624__S _3731_ VGND VGND VPWR VPWR sky130_fd_sc_hd__diode_2
XFILLER_0_20_717 VGND VGND VPWR VPWR sky130_fd_sc_hd__decap_3
X_8479_ _4190_ VGND VGND VPWR VPWR _0633_ sky130_fd_sc_hd__clkbuf_1
XTAP_TAPCELL_ROW_118_1799 VGND VPWR sky130_fd_sc_hd__tapvpwrvgnd_1
XANTENNA__5628__C1 _2362_ VGND VGND VPWR VPWR sky130_fd_sc_hd__diode_2
XANTENNA__8290__A0 _2978_ VGND VGND VPWR VPWR sky130_fd_sc_hd__diode_2
XANTENNA__4526__S0 _1126_ VGND VGND VPWR VPWR sky130_fd_sc_hd__diode_2
XFILLER_0_99_577 VGND VGND VPWR VPWR sky130_fd_sc_hd__fill_2
XANTENNA_input12_A a3[3] VGND VGND VPWR VPWR sky130_fd_sc_hd__diode_2
XANTENNA__4284__A _1031_ VGND VGND VPWR VPWR sky130_fd_sc_hd__diode_2
XANTENNA__6053__C1 _2429_ VGND VGND VPWR VPWR sky130_fd_sc_hd__diode_2
XFILLER_0_24_38 VGND VGND VPWR VPWR sky130_fd_sc_hd__fill_2
XFILLER_0_94_271 VGND VGND VPWR VPWR sky130_fd_sc_hd__fill_2
XFILLER_0_67_474 VGND VGND VPWR VPWR sky130_fd_sc_hd__fill_2
XFILLER_0_67_463 VGND VGND VPWR VPWR sky130_fd_sc_hd__fill_2
XANTENNA__8190__S _4031_ VGND VGND VPWR VPWR sky130_fd_sc_hd__diode_2
XTAP_TAPCELL_ROW_15_458 VGND VPWR sky130_fd_sc_hd__tapvpwrvgnd_1
XANTENNA__5159__A1 _1677_ VGND VGND VPWR VPWR sky130_fd_sc_hd__diode_2
XFILLER_0_82_433 VGND VGND VPWR VPWR sky130_fd_sc_hd__fill_2
XFILLER_0_39_187 VGND VGND VPWR VPWR sky130_fd_sc_hd__fill_1
XFILLER_0_27_349 VGND VGND VPWR VPWR sky130_fd_sc_hd__fill_2
XFILLER_0_70_617 VGND VGND VPWR VPWR sky130_fd_sc_hd__decap_3
XFILLER_0_54_157 VGND VGND VPWR VPWR sky130_fd_sc_hd__fill_2
XANTENNA__5254__S1 _1771_ VGND VGND VPWR VPWR sky130_fd_sc_hd__diode_2
XFILLER_0_35_393 VGND VGND VPWR VPWR sky130_fd_sc_hd__fill_2
XFILLER_0_49_57 VGND VGND VPWR VPWR sky130_fd_sc_hd__decap_3
XANTENNA__4765__S0 _1390_ VGND VGND VPWR VPWR sky130_fd_sc_hd__diode_2
XANTENNA__7084__A1 _3433_ VGND VGND VPWR VPWR sky130_fd_sc_hd__diode_2
XANTENNA__4517__S0 _1198_ VGND VGND VPWR VPWR sky130_fd_sc_hd__diode_2
XANTENNA__8365__S _4128_ VGND VGND VPWR VPWR sky130_fd_sc_hd__diode_2
XFILLER_0_65_45 VGND VGND VPWR VPWR sky130_fd_sc_hd__decap_4
X_7850_ _3121_ registers\[26\]\[25\] _3851_ VGND VGND VPWR VPWR _3857_ sky130_fd_sc_hd__mux2_1
X_6801_ registers\[11\]\[30\] _3024_ _3249_ VGND VGND VPWR VPWR _3283_ sky130_fd_sc_hd__mux2_1
XTAP_TAPCELL_ROW_34_701 VGND VPWR sky130_fd_sc_hd__tapvpwrvgnd_1
XFILLER_0_105_51 VGND VGND VPWR VPWR sky130_fd_sc_hd__decap_3
X_4993_ _1747_ _1753_ _1754_ VGND VGND VPWR VPWR _1755_ sky130_fd_sc_hd__mux2_1
X_7781_ _3820_ VGND VGND VPWR VPWR _0305_ sky130_fd_sc_hd__clkbuf_1
XFILLER_0_105_73 VGND VGND VPWR VPWR sky130_fd_sc_hd__fill_1
X_9520_ clknet_leaf_63_clk _0617_ VGND VGND VPWR VPWR registers\[8\]\[16\] sky130_fd_sc_hd__dfxtp_1
XANTENNA__4922__A _1634_ VGND VGND VPWR VPWR sky130_fd_sc_hd__diode_2
X_6732_ _3246_ VGND VGND VPWR VPWR _0854_ sky130_fd_sc_hd__clkbuf_1
X_9451_ clknet_leaf_56_clk _0548_ VGND VGND VPWR VPWR registers\[31\]\[11\] sky130_fd_sc_hd__dfxtp_1
XFILLER_0_105_95 VGND VGND VPWR VPWR sky130_fd_sc_hd__fill_2
XTAP_TAPCELL_ROW_102_1589 VGND VPWR sky130_fd_sc_hd__tapvpwrvgnd_1
X_6663_ _3208_ VGND VGND VPWR VPWR _0823_ sky130_fd_sc_hd__clkbuf_1
XFILLER_0_46_658 VGND VGND VPWR VPWR sky130_fd_sc_hd__fill_2
XFILLER_0_45_135 VGND VGND VPWR VPWR sky130_fd_sc_hd__fill_2
XFILLER_0_45_113 VGND VGND VPWR VPWR sky130_fd_sc_hd__decap_4
X_5614_ _1051_ _2299_ VGND VGND VPWR VPWR _2349_ sky130_fd_sc_hd__nand2_1
XFILLER_0_61_617 VGND VGND VPWR VPWR sky130_fd_sc_hd__fill_1
X_8402_ registers\[5\]\[29\] _3495_ _4139_ VGND VGND VPWR VPWR _4149_ sky130_fd_sc_hd__mux2_1
XFILLER_0_33_319 VGND VGND VPWR VPWR sky130_fd_sc_hd__fill_2
X_9382_ clknet_leaf_36_clk _0479_ VGND VGND VPWR VPWR registers\[9\]\[6\] sky130_fd_sc_hd__dfxtp_1
XFILLER_0_60_127 VGND VGND VPWR VPWR sky130_fd_sc_hd__fill_2
XFILLER_0_54_691 VGND VGND VPWR VPWR sky130_fd_sc_hd__fill_1
XFILLER_0_5_254 VGND VGND VPWR VPWR sky130_fd_sc_hd__decap_3
XFILLER_0_14_533 VGND VGND VPWR VPWR sky130_fd_sc_hd__fill_1
X_6594_ registers\[7\]\[31\] _3026_ _3136_ VGND VGND VPWR VPWR _3171_ sky130_fd_sc_hd__mux2_1
X_5545_ _1882_ _2215_ _2220_ VGND VGND VPWR VPWR _2281_ sky130_fd_sc_hd__o21ai_1
XANTENNA__5753__A _2328_ VGND VGND VPWR VPWR sky130_fd_sc_hd__diode_2
XFILLER_0_60_149 VGND VGND VPWR VPWR sky130_fd_sc_hd__decap_6
XTAP_TAPCELL_ROW_57_1002 VGND VPWR sky130_fd_sc_hd__tapvpwrvgnd_1
XFILLER_0_53_190 VGND VGND VPWR VPWR sky130_fd_sc_hd__decap_4
X_8333_ _4112_ VGND VGND VPWR VPWR _0565_ sky130_fd_sc_hd__clkbuf_1
XFILLER_0_76_3 VGND VGND VPWR VPWR sky130_fd_sc_hd__fill_2
X_5476_ _2207_ _2211_ VGND VGND VPWR VPWR _2212_ sky130_fd_sc_hd__nand2_1
X_8264_ registers\[6\]\[28\] _3493_ _4067_ VGND VGND VPWR VPWR _4076_ sky130_fd_sc_hd__mux2_1
XANTENNA__5472__B _1208_ VGND VGND VPWR VPWR sky130_fd_sc_hd__diode_2
X_4427_ _1131_ _1218_ _1024_ VGND VGND VPWR VPWR _1219_ sky130_fd_sc_hd__o21a_1
X_7215_ registers\[17\]\[15\] _3466_ _3514_ VGND VGND VPWR VPWR _3520_ sky130_fd_sc_hd__mux2_1
X_8195_ _4039_ VGND VGND VPWR VPWR _0500_ sky130_fd_sc_hd__clkbuf_1
X_7146_ registers\[16\]\[20\] _3476_ _3477_ VGND VGND VPWR VPWR _3478_ sky130_fd_sc_hd__mux2_1
X_4358_ _1122_ VGND VGND VPWR VPWR _1153_ sky130_fd_sc_hd__buf_4
XANTENNA_input4_A a1[3] VGND VGND VPWR VPWR sky130_fd_sc_hd__diode_2
XANTENNA__4508__S0 _1160_ VGND VGND VPWR VPWR sky130_fd_sc_hd__diode_2
X_7077_ _3131_ registers\[15\]\[30\] _3397_ VGND VGND VPWR VPWR _3431_ sky130_fd_sc_hd__mux2_1
X_4289_ _1085_ _1086_ net6 VGND VGND VPWR VPWR _1087_ sky130_fd_sc_hd__mux2_1
XANTENNA__5181__S0 _1763_ VGND VGND VPWR VPWR sky130_fd_sc_hd__diode_2
X_6028_ _2741_ _2745_ VGND VGND VPWR VPWR _2746_ sky130_fd_sc_hd__nand2_1
XTAP_TAPCELL_ROW_68_1142 VGND VPWR sky130_fd_sc_hd__tapvpwrvgnd_1
XFILLER_0_68_249 VGND VGND VPWR VPWR sky130_fd_sc_hd__fill_1
X_7979_ _3925_ VGND VGND VPWR VPWR _0398_ sky130_fd_sc_hd__clkbuf_1
XANTENNA__4832__A _1601_ VGND VGND VPWR VPWR sky130_fd_sc_hd__diode_2
XTAP_TAPCELL_ROW_12_417 VGND VPWR sky130_fd_sc_hd__tapvpwrvgnd_1
XFILLER_0_91_263 VGND VGND VPWR VPWR sky130_fd_sc_hd__fill_1
XFILLER_0_64_477 VGND VGND VPWR VPWR sky130_fd_sc_hd__fill_2
XFILLER_0_51_127 VGND VGND VPWR VPWR sky130_fd_sc_hd__fill_2
XFILLER_0_17_360 VGND VGND VPWR VPWR sky130_fd_sc_hd__fill_2
XFILLER_0_10_29 VGND VGND VPWR VPWR sky130_fd_sc_hd__fill_2
XTAP_TAPCELL_ROW_79_1282 VGND VPWR sky130_fd_sc_hd__tapvpwrvgnd_1
XFILLER_0_20_503 VGND VGND VPWR VPWR sky130_fd_sc_hd__fill_2
XFILLER_0_102_240 VGND VGND VPWR VPWR sky130_fd_sc_hd__fill_2
XANTENNA__6510__A0 _3123_ VGND VGND VPWR VPWR sky130_fd_sc_hd__diode_2
XANTENNA__4747__S0 _1347_ VGND VGND VPWR VPWR sky130_fd_sc_hd__diode_2
XTAP_TAPCELL_ROW_92_1460 VGND VPWR sky130_fd_sc_hd__tapvpwrvgnd_1
XFILLER_0_20_569 VGND VGND VPWR VPWR sky130_fd_sc_hd__decap_3
XANTENNA__6494__A net29 VGND VGND VPWR VPWR sky130_fd_sc_hd__diode_2
XANTENNA__5172__S0 _1810_ VGND VGND VPWR VPWR sky130_fd_sc_hd__diode_2
XANTENNA__6813__A1 _2966_ VGND VGND VPWR VPWR sky130_fd_sc_hd__diode_2
XFILLER_0_87_503 VGND VGND VPWR VPWR sky130_fd_sc_hd__fill_1
XFILLER_0_35_26 VGND VGND VPWR VPWR sky130_fd_sc_hd__fill_2
XFILLER_0_59_216 VGND VGND VPWR VPWR sky130_fd_sc_hd__fill_2
XANTENNA__7529__S _3684_ VGND VGND VPWR VPWR sky130_fd_sc_hd__diode_2
XANTENNA__6433__S _3069_ VGND VGND VPWR VPWR sky130_fd_sc_hd__diode_2
XFILLER_0_28_636 VGND VGND VPWR VPWR sky130_fd_sc_hd__fill_2
XFILLER_0_70_403 VGND VGND VPWR VPWR sky130_fd_sc_hd__fill_1
XFILLER_0_43_606 VGND VGND VPWR VPWR sky130_fd_sc_hd__fill_2
XFILLER_0_15_308 VGND VGND VPWR VPWR sky130_fd_sc_hd__fill_1
XFILLER_0_113_505 VGND VGND VPWR VPWR sky130_fd_sc_hd__fill_1
XANTENNA__7264__S _3539_ VGND VGND VPWR VPWR sky130_fd_sc_hd__diode_2
XANTENNA__5552__A1 _1866_ VGND VGND VPWR VPWR sky130_fd_sc_hd__diode_2
Xclkload12 clknet_4_13_0_clk VGND VGND VPWR VPWR clkload12/Y sky130_fd_sc_hd__inv_6
Xclkload34 clknet_leaf_8_clk VGND VGND VPWR VPWR clkload34/X sky130_fd_sc_hd__clkbuf_4
Xclkload23 clknet_leaf_3_clk VGND VGND VPWR VPWR clkload23/Y sky130_fd_sc_hd__inv_8
XFILLER_0_23_341 VGND VGND VPWR VPWR sky130_fd_sc_hd__fill_2
Xclkload56 clknet_leaf_36_clk VGND VGND VPWR VPWR clkload56/Y sky130_fd_sc_hd__clkinvlp_4
Xclkload45 clknet_leaf_30_clk VGND VGND VPWR VPWR clkload45/Y sky130_fd_sc_hd__clkinvlp_4
XFILLER_0_113_549 VGND VGND VPWR VPWR sky130_fd_sc_hd__decap_3
Xclkload78 clknet_leaf_82_clk VGND VGND VPWR VPWR clkload78/X sky130_fd_sc_hd__clkbuf_4
X_5330_ registers\[8\]\[24\] registers\[9\]\[24\] registers\[10\]\[24\] registers\[11\]\[24\]
+ _2072_ _2073_ VGND VGND VPWR VPWR _2074_ sky130_fd_sc_hd__mux4_1
Xclkload67 clknet_leaf_90_clk VGND VGND VPWR VPWR clkload67/X sky130_fd_sc_hd__clkbuf_4
XANTENNA_clkbuf_leaf_53_clk_A clknet_4_13_0_clk VGND VGND VPWR VPWR sky130_fd_sc_hd__diode_2
Xclkload89 clknet_leaf_47_clk VGND VGND VPWR VPWR clkload89/Y sky130_fd_sc_hd__bufinv_16
XFILLER_0_50_182 VGND VGND VPWR VPWR sky130_fd_sc_hd__fill_2
XFILLER_0_11_558 VGND VGND VPWR VPWR sky130_fd_sc_hd__fill_2
X_5261_ _2007_ _2008_ _1856_ VGND VGND VPWR VPWR _2009_ sky130_fd_sc_hd__mux2_1
XFILLER_0_76_33 VGND VGND VPWR VPWR sky130_fd_sc_hd__fill_1
XFILLER_0_76_22 VGND VGND VPWR VPWR sky130_fd_sc_hd__fill_2
XFILLER_0_11_569 VGND VGND VPWR VPWR sky130_fd_sc_hd__decap_3
X_7000_ _3123_ registers\[14\]\[26\] _3383_ VGND VGND VPWR VPWR _3390_ sky130_fd_sc_hd__mux2_1
X_5192_ _1943_ VGND VGND VPWR VPWR net88 sky130_fd_sc_hd__inv_2
XFILLER_0_48_7 VGND VGND VPWR VPWR sky130_fd_sc_hd__fill_2
XANTENNA__6608__S _3175_ VGND VGND VPWR VPWR sky130_fd_sc_hd__diode_2
XANTENNA__8095__S _3984_ VGND VGND VPWR VPWR sky130_fd_sc_hd__diode_2
XANTENNA__4917__A _1627_ VGND VGND VPWR VPWR sky130_fd_sc_hd__diode_2
XANTENNA_clkbuf_leaf_68_clk_A clknet_4_11_0_clk VGND VGND VPWR VPWR sky130_fd_sc_hd__diode_2
X_8951_ clknet_leaf_71_clk _0048_ VGND VGND VPWR VPWR registers\[17\]\[23\] sky130_fd_sc_hd__dfxtp_1
X_7902_ _3884_ VGND VGND VPWR VPWR _0362_ sky130_fd_sc_hd__clkbuf_1
XANTENNA_clkbuf_leaf_111_clk_A clknet_4_0_0_clk VGND VGND VPWR VPWR sky130_fd_sc_hd__diode_2
XFILLER_0_116_61 VGND VGND VPWR VPWR sky130_fd_sc_hd__decap_3
XTAP_TAPCELL_ROW_104_1607 VGND VPWR sky130_fd_sc_hd__tapvpwrvgnd_1
XANTENNA__4291__A1 _1073_ VGND VGND VPWR VPWR sky130_fd_sc_hd__diode_2
X_8882_ clknet_leaf_67_clk _1003_ VGND VGND VPWR VPWR registers\[15\]\[18\] sky130_fd_sc_hd__dfxtp_1
X_7833_ _3104_ registers\[26\]\[17\] _3840_ VGND VGND VPWR VPWR _3848_ sky130_fd_sc_hd__mux2_1
XFILLER_0_116_83 VGND VGND VPWR VPWR sky130_fd_sc_hd__fill_1
XFILLER_0_78_558 VGND VGND VPWR VPWR sky130_fd_sc_hd__fill_1
XTAP_TAPCELL_ROW_47_870 VGND VPWR sky130_fd_sc_hd__tapvpwrvgnd_1
XFILLER_0_25_70 VGND VGND VPWR VPWR sky130_fd_sc_hd__fill_1
X_7764_ _3811_ VGND VGND VPWR VPWR _0297_ sky130_fd_sc_hd__clkbuf_1
XANTENNA__7439__S _3634_ VGND VGND VPWR VPWR sky130_fd_sc_hd__diode_2
XANTENNA__4652__A _1381_ VGND VGND VPWR VPWR sky130_fd_sc_hd__diode_2
X_4976_ _1733_ _1735_ _1738_ _1655_ net5 VGND VGND VPWR VPWR _1739_ sky130_fd_sc_hd__a221o_1
X_9503_ clknet_leaf_98_clk _0600_ VGND VGND VPWR VPWR registers\[5\]\[31\] sky130_fd_sc_hd__dfxtp_1
X_6715_ registers\[10\]\[21\] _3006_ _3236_ VGND VGND VPWR VPWR _3238_ sky130_fd_sc_hd__mux2_1
X_7695_ registers\[24\]\[16\] _3468_ _3768_ VGND VGND VPWR VPWR _3775_ sky130_fd_sc_hd__mux2_1
XTAP_TAPCELL_ROW_63_1083 VGND VPWR sky130_fd_sc_hd__tapvpwrvgnd_1
XTAP_TAPCELL_ROW_63_1072 VGND VPWR sky130_fd_sc_hd__tapvpwrvgnd_1
XFILLER_0_116_354 VGND VGND VPWR VPWR sky130_fd_sc_hd__fill_2
Xclkload6 clknet_4_7_0_clk VGND VGND VPWR VPWR clkload6/Y sky130_fd_sc_hd__clkinvlp_4
XFILLER_0_73_285 VGND VGND VPWR VPWR sky130_fd_sc_hd__fill_2
X_6646_ registers\[0\]\[22\] _3008_ _3197_ VGND VGND VPWR VPWR _3200_ sky130_fd_sc_hd__mux2_1
XFILLER_0_18_179 VGND VGND VPWR VPWR sky130_fd_sc_hd__decap_4
X_9434_ clknet_leaf_93_clk _0531_ VGND VGND VPWR VPWR registers\[6\]\[26\] sky130_fd_sc_hd__dfxtp_1
XFILLER_0_116_387 VGND VGND VPWR VPWR sky130_fd_sc_hd__decap_4
XFILLER_0_116_365 VGND VGND VPWR VPWR sky130_fd_sc_hd__decap_3
XFILLER_0_61_458 VGND VGND VPWR VPWR sky130_fd_sc_hd__fill_2
XFILLER_0_61_447 VGND VGND VPWR VPWR sky130_fd_sc_hd__fill_1
X_6577_ _3162_ VGND VGND VPWR VPWR _0783_ sky130_fd_sc_hd__clkbuf_1
X_9365_ clknet_leaf_82_clk _0462_ VGND VGND VPWR VPWR registers\[30\]\[21\] sky130_fd_sc_hd__dfxtp_1
X_5528_ _2239_ _2263_ _1108_ VGND VGND VPWR VPWR _2264_ sky130_fd_sc_hd__mux2_1
XANTENNA__5483__A _1049_ VGND VGND VPWR VPWR sky130_fd_sc_hd__diode_2
X_8316_ _3003_ registers\[31\]\[20\] _4103_ VGND VGND VPWR VPWR _4104_ sky130_fd_sc_hd__mux2_1
XTAP_TAPCELL_ROW_115_1758 VGND VPWR sky130_fd_sc_hd__tapvpwrvgnd_1
X_9296_ clknet_leaf_64_clk _0393_ VGND VGND VPWR VPWR registers\[28\]\[16\] sky130_fd_sc_hd__dfxtp_1
XANTENNA__7296__A1 _3479_ VGND VGND VPWR VPWR sky130_fd_sc_hd__diode_2
XFILLER_0_112_593 VGND VGND VPWR VPWR sky130_fd_sc_hd__fill_1
X_8247_ _4044_ VGND VGND VPWR VPWR _4067_ sky130_fd_sc_hd__clkbuf_8
XANTENNA__4729__S0 _1415_ VGND VGND VPWR VPWR sky130_fd_sc_hd__diode_2
X_5459_ _1977_ _2187_ _2195_ VGND VGND VPWR VPWR _2196_ sky130_fd_sc_hd__a21oi_4
X_8178_ _4030_ VGND VGND VPWR VPWR _0492_ sky130_fd_sc_hd__clkbuf_1
X_7129_ net22 VGND VGND VPWR VPWR _3466_ sky130_fd_sc_hd__buf_2
XANTENNA__5154__S0 _1690_ VGND VGND VPWR VPWR sky130_fd_sc_hd__diode_2
XFILLER_0_69_514 VGND VGND VPWR VPWR sky130_fd_sc_hd__fill_2
XANTENNA__7349__S _3586_ VGND VGND VPWR VPWR sky130_fd_sc_hd__diode_2
XANTENNA__5658__A net139 VGND VGND VPWR VPWR sky130_fd_sc_hd__diode_2
XANTENNA__4562__A _1140_ VGND VGND VPWR VPWR sky130_fd_sc_hd__diode_2
XFILLER_0_119_181 VPWR VGND VPWR VGND sky130_ef_sc_hd__decap_12
XANTENNA__5782__A1 net138 VGND VGND VPWR VPWR sky130_fd_sc_hd__diode_2
XFILLER_0_80_701 VGND VGND VPWR VPWR sky130_fd_sc_hd__decap_4
XFILLER_0_21_28 VGND VGND VPWR VPWR sky130_fd_sc_hd__fill_2
XTAP_TAPCELL_ROW_25_586 VGND VPWR sky130_fd_sc_hd__tapvpwrvgnd_1
XFILLER_0_25_617 VGND VGND VPWR VPWR sky130_fd_sc_hd__fill_2
XFILLER_0_92_594 VGND VGND VPWR VPWR sky130_fd_sc_hd__fill_1
XFILLER_0_92_572 VGND VGND VPWR VPWR sky130_fd_sc_hd__fill_2
XFILLER_0_64_296 VGND VGND VPWR VPWR sky130_fd_sc_hd__fill_2
XANTENNA__7084__S _3435_ VGND VGND VPWR VPWR sky130_fd_sc_hd__diode_2
XANTENNA__7287__A1 _3470_ VGND VGND VPWR VPWR sky130_fd_sc_hd__diode_2
XFILLER_0_60_491 VGND VGND VPWR VPWR sky130_fd_sc_hd__decap_6
XFILLER_0_103_582 VGND VGND VPWR VPWR sky130_fd_sc_hd__fill_2
XANTENNA__7812__S _3829_ VGND VGND VPWR VPWR sky130_fd_sc_hd__diode_2
XFILLER_0_20_344 VGND VGND VPWR VPWR sky130_fd_sc_hd__fill_2
XFILLER_0_20_399 VGND VGND VPWR VPWR sky130_fd_sc_hd__fill_2
XANTENNA__4737__A _1386_ VGND VGND VPWR VPWR sky130_fd_sc_hd__diode_2
XANTENNA__7113__A net17 VGND VGND VPWR VPWR sky130_fd_sc_hd__diode_2
XFILLER_0_46_69 VGND VGND VPWR VPWR sky130_fd_sc_hd__fill_2
XFILLER_0_1_27 VPWR VGND VPWR VGND sky130_ef_sc_hd__decap_12
XFILLER_0_87_333 VGND VGND VPWR VPWR sky130_fd_sc_hd__decap_3
XANTENNA__7211__A1 _3462_ VGND VGND VPWR VPWR sky130_fd_sc_hd__diode_2
XANTENNA__5568__A _1740_ VGND VGND VPWR VPWR sky130_fd_sc_hd__diode_2
X_4830_ _1381_ _1599_ _1372_ VGND VGND VPWR VPWR _1600_ sky130_fd_sc_hd__o21a_1
XANTENNA__5448__S1 _2120_ VGND VGND VPWR VPWR sky130_fd_sc_hd__diode_2
XFILLER_0_117_107 VGND VGND VPWR VPWR sky130_fd_sc_hd__decap_4
XFILLER_0_87_399 VGND VGND VPWR VPWR sky130_fd_sc_hd__decap_4
X_4761_ registers\[20\]\[27\] registers\[21\]\[27\] registers\[22\]\[27\] registers\[23\]\[27\]
+ _1404_ _1405_ VGND VGND VPWR VPWR _1534_ sky130_fd_sc_hd__mux4_1
X_7480_ _3092_ registers\[21\]\[11\] _3659_ VGND VGND VPWR VPWR _3661_ sky130_fd_sc_hd__mux2_1
XFILLER_0_83_583 VGND VGND VPWR VPWR sky130_fd_sc_hd__decap_4
X_6500_ net31 VGND VGND VPWR VPWR _3117_ sky130_fd_sc_hd__clkbuf_2
XFILLER_0_43_414 VGND VGND VPWR VPWR sky130_fd_sc_hd__decap_6
X_4692_ registers\[20\]\[23\] registers\[21\]\[23\] registers\[22\]\[23\] registers\[23\]\[23\]
+ _1320_ _1321_ VGND VGND VPWR VPWR _1469_ sky130_fd_sc_hd__mux4_1
XFILLER_0_28_477 VGND VGND VPWR VPWR sky130_fd_sc_hd__fill_1
Xclkload101 clknet_leaf_72_clk VGND VGND VPWR VPWR clkload101/Y sky130_fd_sc_hd__clkinvlp_4
X_6431_ _3070_ VGND VGND VPWR VPWR _0729_ sky130_fd_sc_hd__clkbuf_1
XFILLER_0_3_500 VGND VGND VPWR VPWR sky130_fd_sc_hd__fill_2
XFILLER_0_31_609 VGND VGND VPWR VPWR sky130_fd_sc_hd__decap_4
XFILLER_0_113_335 VGND VGND VPWR VPWR sky130_fd_sc_hd__fill_1
XFILLER_0_102_74 VGND VGND VPWR VPWR sky130_fd_sc_hd__fill_1
XFILLER_0_70_266 VGND VGND VPWR VPWR sky130_fd_sc_hd__fill_1
X_6362_ _3032_ VGND VGND VPWR VPWR _0698_ sky130_fd_sc_hd__clkbuf_1
X_9150_ clknet_leaf_96_clk _0247_ VGND VGND VPWR VPWR registers\[23\]\[30\] sky130_fd_sc_hd__dfxtp_1
XFILLER_0_30_108 VGND VGND VPWR VPWR sky130_fd_sc_hd__fill_2
XFILLER_0_87_21 VGND VGND VPWR VPWR sky130_fd_sc_hd__fill_1
X_8101_ _2993_ registers\[30\]\[15\] _3984_ VGND VGND VPWR VPWR _3990_ sky130_fd_sc_hd__mux2_1
X_5313_ registers\[8\]\[23\] registers\[9\]\[23\] registers\[10\]\[23\] registers\[11\]\[23\]
+ _1762_ _1764_ VGND VGND VPWR VPWR _2058_ sky130_fd_sc_hd__mux4_1
XFILLER_0_3_577 VGND VGND VPWR VPWR sky130_fd_sc_hd__fill_2
XFILLER_0_23_182 VGND VGND VPWR VPWR sky130_fd_sc_hd__fill_2
XFILLER_0_24_694 VGND VGND VPWR VPWR sky130_fd_sc_hd__fill_2
X_6293_ registers\[19\]\[11\] _2985_ _2983_ VGND VGND VPWR VPWR _2986_ sky130_fd_sc_hd__mux2_1
XFILLER_0_87_54 VGND VGND VPWR VPWR sky130_fd_sc_hd__fill_2
XANTENNA__7722__S _3779_ VGND VGND VPWR VPWR sky130_fd_sc_hd__diode_2
X_9081_ clknet_leaf_80_clk _0178_ VGND VGND VPWR VPWR registers\[21\]\[25\] sky130_fd_sc_hd__dfxtp_1
X_8032_ _3953_ VGND VGND VPWR VPWR _0423_ sky130_fd_sc_hd__clkbuf_1
X_5244_ _1991_ _1992_ _1631_ VGND VGND VPWR VPWR _1993_ sky130_fd_sc_hd__mux2_1
XANTENNA__5384__S0 _2076_ VGND VGND VPWR VPWR sky130_fd_sc_hd__diode_2
X_5175_ _1922_ _1924_ _1927_ _1754_ _1778_ VGND VGND VPWR VPWR _1928_ sky130_fd_sc_hd__a221o_1
XANTENNA__4647__A _1320_ VGND VGND VPWR VPWR sky130_fd_sc_hd__diode_2
XTAP_TAPCELL_ROW_110_1688 VGND VPWR sky130_fd_sc_hd__tapvpwrvgnd_1
XANTENNA__5136__S0 _1742_ VGND VGND VPWR VPWR sky130_fd_sc_hd__diode_2
XFILLER_0_97_108 VGND VGND VPWR VPWR sky130_fd_sc_hd__fill_2
X_8934_ clknet_leaf_34_clk _0031_ VGND VGND VPWR VPWR registers\[17\]\[6\] sky130_fd_sc_hd__dfxtp_1
XTAP_TAPCELL_ROW_65_1101 VGND VPWR sky130_fd_sc_hd__tapvpwrvgnd_1
X_8865_ clknet_leaf_7_clk _0986_ VGND VGND VPWR VPWR registers\[15\]\[1\] sky130_fd_sc_hd__dfxtp_1
XFILLER_0_39_709 VGND VGND VPWR VPWR sky130_fd_sc_hd__decap_3
XANTENNA__6073__S _2460_ VGND VGND VPWR VPWR sky130_fd_sc_hd__diode_2
XANTENNA__5478__A _2213_ VGND VGND VPWR VPWR sky130_fd_sc_hd__diode_2
XANTENNA__7202__A1 _3453_ VGND VGND VPWR VPWR sky130_fd_sc_hd__diode_2
X_7816_ _3087_ registers\[26\]\[9\] _3829_ VGND VGND VPWR VPWR _3839_ sky130_fd_sc_hd__mux2_1
XFILLER_0_109_608 VGND VGND VPWR VPWR sky130_fd_sc_hd__fill_2
XFILLER_0_47_720 VGND VGND VPWR VPWR sky130_fd_sc_hd__fill_2
X_8796_ clknet_leaf_104_clk _0917_ VGND VGND VPWR VPWR registers\[12\]\[28\] sky130_fd_sc_hd__dfxtp_1
X_4959_ _1721_ _1722_ _1682_ VGND VGND VPWR VPWR _1723_ sky130_fd_sc_hd__mux2_1
XFILLER_0_93_369 VPWR VGND VPWR VGND sky130_ef_sc_hd__decap_12
XANTENNA__5764__A1 _2267_ VGND VGND VPWR VPWR sky130_fd_sc_hd__diode_2
X_7747_ _3802_ VGND VGND VPWR VPWR _0289_ sky130_fd_sc_hd__clkbuf_1
XFILLER_0_62_701 VGND VGND VPWR VPWR sky130_fd_sc_hd__fill_2
XFILLER_0_19_444 VGND VGND VPWR VPWR sky130_fd_sc_hd__fill_2
XFILLER_0_117_641 VPWR VGND VPWR VGND sky130_ef_sc_hd__decap_12
X_7678_ registers\[24\]\[8\] _3451_ _3757_ VGND VGND VPWR VPWR _3766_ sky130_fd_sc_hd__mux2_1
XTAP_TAPCELL_ROW_22_545 VGND VPWR sky130_fd_sc_hd__tapvpwrvgnd_1
XFILLER_0_117_685 VPWR VGND VPWR VGND sky130_ef_sc_hd__decap_12
X_6629_ registers\[0\]\[14\] _2991_ _3186_ VGND VGND VPWR VPWR _3191_ sky130_fd_sc_hd__mux2_1
X_9417_ clknet_leaf_19_clk _0514_ VGND VGND VPWR VPWR registers\[6\]\[9\] sky130_fd_sc_hd__dfxtp_1
XFILLER_0_6_360 VGND VGND VPWR VPWR sky130_fd_sc_hd__fill_2
XFILLER_0_61_277 VGND VGND VPWR VPWR sky130_fd_sc_hd__decap_3
XFILLER_0_61_266 VGND VGND VPWR VPWR sky130_fd_sc_hd__decap_3
X_9348_ clknet_leaf_29_clk _0445_ VGND VGND VPWR VPWR registers\[30\]\[4\] sky130_fd_sc_hd__dfxtp_1
XTAP_TAPCELL_ROW_76_1241 VGND VPWR sky130_fd_sc_hd__tapvpwrvgnd_1
XTAP_TAPCELL_ROW_76_1252 VGND VPWR sky130_fd_sc_hd__tapvpwrvgnd_1
XANTENNA__7632__S _3731_ VGND VGND VPWR VPWR sky130_fd_sc_hd__diode_2
X_9279_ clknet_leaf_107_clk _0376_ VGND VGND VPWR VPWR registers\[27\]\[31\] sky130_fd_sc_hd__dfxtp_1
XFILLER_0_100_585 VGND VGND VPWR VPWR sky130_fd_sc_hd__decap_3
XANTENNA__6229__C1 _2560_ VGND VGND VPWR VPWR sky130_fd_sc_hd__diode_2
XFILLER_0_107_19 VGND VGND VPWR VPWR sky130_fd_sc_hd__decap_6
XFILLER_0_89_609 VGND VGND VPWR VPWR sky130_fd_sc_hd__decap_4
XANTENNA__4991__S _1752_ VGND VGND VPWR VPWR sky130_fd_sc_hd__diode_2
XANTENNA__7441__A1 _3487_ VGND VGND VPWR VPWR sky130_fd_sc_hd__diode_2
XTAP_TAPCELL_ROW_2_281 VGND VPWR sky130_fd_sc_hd__tapvpwrvgnd_1
XFILLER_0_96_152 VGND VGND VPWR VPWR sky130_fd_sc_hd__fill_2
XFILLER_0_96_141 VGND VGND VPWR VPWR sky130_fd_sc_hd__fill_2
XTAP_TAPCELL_ROW_87_1392 VGND VPWR sky130_fd_sc_hd__tapvpwrvgnd_1
XFILLER_0_84_303 VGND VGND VPWR VPWR sky130_fd_sc_hd__fill_2
XANTENNA__4292__A _1089_ VGND VGND VPWR VPWR sky130_fd_sc_hd__diode_2
XANTENNA__5388__A _2081_ VGND VGND VPWR VPWR sky130_fd_sc_hd__diode_2
XFILLER_0_84_325 VGND VGND VPWR VPWR sky130_fd_sc_hd__decap_3
XFILLER_0_32_27 VGND VGND VPWR VPWR sky130_fd_sc_hd__fill_1
XFILLER_0_65_561 VGND VGND VPWR VPWR sky130_fd_sc_hd__decap_6
XFILLER_0_37_252 VGND VGND VPWR VPWR sky130_fd_sc_hd__fill_1
XFILLER_0_108_630 VGND VGND VPWR VPWR sky130_fd_sc_hd__fill_2
XFILLER_0_37_274 VGND VGND VPWR VPWR sky130_fd_sc_hd__fill_1
XFILLER_0_108_674 VGND VGND VPWR VPWR sky130_fd_sc_hd__decap_3
XFILLER_0_92_391 VGND VGND VPWR VPWR sky130_fd_sc_hd__fill_2
XFILLER_0_52_277 VGND VGND VPWR VPWR sky130_fd_sc_hd__fill_1
XANTENNA__5327__S _2019_ VGND VGND VPWR VPWR sky130_fd_sc_hd__diode_2
XFILLER_0_20_141 VGND VGND VPWR VPWR sky130_fd_sc_hd__decap_3
XFILLER_0_21_642 VGND VGND VPWR VPWR sky130_fd_sc_hd__fill_1
XFILLER_0_21_653 VGND VGND VPWR VPWR sky130_fd_sc_hd__decap_3
XANTENNA__6158__S net124 VGND VGND VPWR VPWR sky130_fd_sc_hd__diode_2
XFILLER_0_57_57 VGND VGND VPWR VPWR sky130_fd_sc_hd__decap_3
XANTENNA__7680__A1 _3453_ VGND VGND VPWR VPWR sky130_fd_sc_hd__diode_2
XANTENNA__6666__B net11 VGND VGND VPWR VPWR sky130_fd_sc_hd__diode_2
XFILLER_0_57_79 VGND VGND VPWR VPWR sky130_fd_sc_hd__fill_1
XANTENNA__5118__S0 _1762_ VGND VGND VPWR VPWR sky130_fd_sc_hd__diode_2
XANTENNA__8373__S _4128_ VGND VGND VPWR VPWR sky130_fd_sc_hd__diode_2
X_6980_ _3379_ VGND VGND VPWR VPWR _0969_ sky130_fd_sc_hd__clkbuf_1
X_5931_ _2650_ _2653_ _2445_ VGND VGND VPWR VPWR _2654_ sky130_fd_sc_hd__mux2_1
XFILLER_0_88_653 VGND VGND VPWR VPWR sky130_fd_sc_hd__fill_2
XFILLER_0_88_631 VGND VGND VPWR VPWR sky130_fd_sc_hd__decap_3
XFILLER_0_48_528 VGND VGND VPWR VPWR sky130_fd_sc_hd__fill_2
XFILLER_0_48_517 VGND VGND VPWR VPWR sky130_fd_sc_hd__decap_4
X_8650_ clknet_leaf_40_clk _0771_ VGND VGND VPWR VPWR registers\[7\]\[10\] sky130_fd_sc_hd__dfxtp_1
X_5862_ _2391_ _2585_ _2586_ _2379_ _2588_ VGND VGND VPWR VPWR _2589_ sky130_fd_sc_hd__a221o_1
X_8581_ clknet_leaf_32_clk _0702_ VGND VGND VPWR VPWR registers\[3\]\[5\] sky130_fd_sc_hd__dfxtp_1
X_7601_ _3077_ registers\[23\]\[4\] _3720_ VGND VGND VPWR VPWR _3725_ sky130_fd_sc_hd__mux2_1
X_5793_ _1740_ _2486_ VGND VGND VPWR VPWR _2523_ sky130_fd_sc_hd__nor2_1
XFILLER_0_63_509 VGND VGND VPWR VPWR sky130_fd_sc_hd__fill_1
XFILLER_0_7_113 VGND VGND VPWR VPWR sky130_fd_sc_hd__fill_1
X_4813_ _1389_ _1583_ _1372_ VGND VGND VPWR VPWR _1584_ sky130_fd_sc_hd__o21ai_1
XANTENNA__4930__A _1627_ VGND VGND VPWR VPWR sky130_fd_sc_hd__diode_2
XANTENNA__6621__S _3186_ VGND VGND VPWR VPWR sky130_fd_sc_hd__diode_2
X_7532_ _3688_ VGND VGND VPWR VPWR _0188_ sky130_fd_sc_hd__clkbuf_1
XTAP_TAPCELL_ROW_60_1042 VGND VPWR sky130_fd_sc_hd__tapvpwrvgnd_1
XFILLER_0_8_658 VGND VGND VPWR VPWR sky130_fd_sc_hd__decap_8
X_4744_ registers\[20\]\[26\] registers\[21\]\[26\] registers\[22\]\[26\] registers\[23\]\[26\]
+ _1347_ _1348_ VGND VGND VPWR VPWR _1518_ sky130_fd_sc_hd__mux4_1
XFILLER_0_83_391 VGND VGND VPWR VPWR sky130_fd_sc_hd__fill_1
XFILLER_0_71_542 VGND VGND VPWR VPWR sky130_fd_sc_hd__fill_2
XFILLER_0_43_211 VGND VGND VPWR VPWR sky130_fd_sc_hd__fill_2
XFILLER_0_98_53 VGND VGND VPWR VPWR sky130_fd_sc_hd__fill_1
X_7463_ _3075_ registers\[21\]\[3\] _3648_ VGND VGND VPWR VPWR _3652_ sky130_fd_sc_hd__mux2_1
XFILLER_0_71_575 VGND VGND VPWR VPWR sky130_fd_sc_hd__decap_3
XANTENNA__5237__S _1687_ VGND VGND VPWR VPWR sky130_fd_sc_hd__diode_2
X_9202_ clknet_leaf_71_clk _0299_ VGND VGND VPWR VPWR registers\[25\]\[18\] sky130_fd_sc_hd__dfxtp_1
X_4675_ _1372_ _1445_ _1449_ _1453_ VGND VGND VPWR VPWR _1454_ sky130_fd_sc_hd__a2bb2o_1
XFILLER_0_12_620 VGND VGND VPWR VPWR sky130_fd_sc_hd__fill_2
X_6414_ _3059_ VGND VGND VPWR VPWR _0723_ sky130_fd_sc_hd__clkbuf_1
X_7394_ _3615_ VGND VGND VPWR VPWR _0123_ sky130_fd_sc_hd__clkbuf_1
XFILLER_0_114_699 VGND VGND VPWR VPWR sky130_fd_sc_hd__fill_1
XTAP_TAPCELL_ROW_112_1717 VGND VPWR sky130_fd_sc_hd__tapvpwrvgnd_1
X_9133_ clknet_leaf_56_clk _0230_ VGND VGND VPWR VPWR registers\[23\]\[13\] sky130_fd_sc_hd__dfxtp_1
XFILLER_0_98_97 VGND VGND VPWR VPWR sky130_fd_sc_hd__fill_2
X_6345_ registers\[19\]\[28\] _3020_ _3004_ VGND VGND VPWR VPWR _3021_ sky130_fd_sc_hd__mux2_1
XFILLER_0_11_130 VGND VGND VPWR VPWR sky130_fd_sc_hd__decap_3
X_6276_ net44 VGND VGND VPWR VPWR _2974_ sky130_fd_sc_hd__buf_2
X_9064_ clknet_leaf_8_clk _0161_ VGND VGND VPWR VPWR registers\[21\]\[8\] sky130_fd_sc_hd__dfxtp_1
XFILLER_0_11_152 VGND VGND VPWR VPWR sky130_fd_sc_hd__fill_2
XFILLER_0_12_686 VGND VGND VPWR VPWR sky130_fd_sc_hd__fill_2
X_8015_ _3944_ VGND VGND VPWR VPWR _0415_ sky130_fd_sc_hd__clkbuf_1
X_5227_ _1778_ VGND VGND VPWR VPWR _1977_ sky130_fd_sc_hd__buf_8
X_5158_ _1714_ _1907_ _1909_ _1911_ _1702_ VGND VGND VPWR VPWR _1912_ sky130_fd_sc_hd__a221o_1
XANTENNA__4580__S1 _1324_ VGND VGND VPWR VPWR sky130_fd_sc_hd__diode_2
XTAP_TAPCELL_ROW_71_1182 VGND VPWR sky130_fd_sc_hd__tapvpwrvgnd_1
XFILLER_0_98_439 VGND VGND VPWR VPWR sky130_fd_sc_hd__fill_1
X_5089_ registers\[4\]\[10\] registers\[5\]\[10\] registers\[6\]\[10\] registers\[7\]\[10\]
+ _1742_ _1743_ VGND VGND VPWR VPWR _1847_ sky130_fd_sc_hd__mux4_1
XFILLER_0_79_642 VGND VGND VPWR VPWR sky130_fd_sc_hd__decap_4
X_8917_ clknet_leaf_79_clk _0014_ VGND VGND VPWR VPWR registers\[16\]\[21\] sky130_fd_sc_hd__dfxtp_1
XTAP_TAPCELL_ROW_27_604 VGND VPWR sky130_fd_sc_hd__tapvpwrvgnd_1
XTAP_TAPCELL_ROW_27_615 VGND VPWR sky130_fd_sc_hd__tapvpwrvgnd_1
XFILLER_0_79_664 VGND VGND VPWR VPWR sky130_fd_sc_hd__fill_2
XTAP_TAPCELL_ROW_55_968 VGND VPWR sky130_fd_sc_hd__tapvpwrvgnd_1
XFILLER_0_2_81 VGND VGND VPWR VPWR sky130_fd_sc_hd__decap_3
XFILLER_0_94_645 VGND VGND VPWR VPWR sky130_fd_sc_hd__decap_8
XFILLER_0_93_122 VGND VGND VPWR VPWR sky130_fd_sc_hd__fill_2
XANTENNA__5001__A _1762_ VGND VGND VPWR VPWR sky130_fd_sc_hd__diode_2
X_8848_ clknet_leaf_64_clk _0969_ VGND VGND VPWR VPWR registers\[14\]\[16\] sky130_fd_sc_hd__dfxtp_1
XTAP_TAPCELL_ROW_55_979 VGND VPWR sky130_fd_sc_hd__tapvpwrvgnd_1
X_8779_ clknet_leaf_57_clk _0900_ VGND VGND VPWR VPWR registers\[12\]\[11\] sky130_fd_sc_hd__dfxtp_1
XFILLER_0_109_449 VGND VGND VPWR VPWR sky130_fd_sc_hd__fill_2
XFILLER_0_93_199 VGND VGND VPWR VPWR sky130_fd_sc_hd__fill_2
XANTENNA__5936__A _1286_ VGND VGND VPWR VPWR sky130_fd_sc_hd__diode_2
XFILLER_0_117_471 VGND VGND VPWR VPWR sky130_fd_sc_hd__fill_2
XFILLER_0_62_531 VGND VGND VPWR VPWR sky130_fd_sc_hd__fill_1
XFILLER_0_34_233 VGND VGND VPWR VPWR sky130_fd_sc_hd__fill_1
XFILLER_0_62_586 VGND VGND VPWR VPWR sky130_fd_sc_hd__fill_2
XFILLER_0_34_266 VGND VGND VPWR VPWR sky130_fd_sc_hd__fill_2
XANTENNA__4399__S1 _1137_ VGND VGND VPWR VPWR sky130_fd_sc_hd__diode_2
XFILLER_0_105_677 VGND VGND VPWR VPWR sky130_fd_sc_hd__decap_3
XANTENNA__8458__S _4175_ VGND VGND VPWR VPWR sky130_fd_sc_hd__diode_2
XANTENNA__7362__S _3597_ VGND VGND VPWR VPWR sky130_fd_sc_hd__diode_2
XFILLER_0_30_461 VGND VGND VPWR VPWR sky130_fd_sc_hd__fill_2
XANTENNA_input42_A wd3[4] VGND VGND VPWR VPWR sky130_fd_sc_hd__diode_2
XFILLER_0_118_29 VPWR VGND VPWR VGND sky130_ef_sc_hd__decap_12
XANTENNA__4476__A1 _1116_ VGND VGND VPWR VPWR sky130_fd_sc_hd__diode_2
XFILLER_0_100_393 VGND VGND VPWR VPWR sky130_fd_sc_hd__decap_3
XANTENNA__7662__A1 _3433_ VGND VGND VPWR VPWR sky130_fd_sc_hd__diode_2
XTAP_TAPCELL_ROW_7_351 VGND VPWR sky130_fd_sc_hd__tapvpwrvgnd_1
XTAP_TAPCELL_ROW_89_1421 VGND VPWR sky130_fd_sc_hd__tapvpwrvgnd_1
XTAP_TAPCELL_ROW_89_1410 VGND VPWR sky130_fd_sc_hd__tapvpwrvgnd_1
XFILLER_0_27_49 VGND VGND VPWR VPWR sky130_fd_sc_hd__fill_1
XANTENNA__6706__S _3225_ VGND VGND VPWR VPWR sky130_fd_sc_hd__diode_2
XANTENNA__5610__S _2344_ VGND VGND VPWR VPWR sky130_fd_sc_hd__diode_2
XANTENNA__5976__A1 _2321_ VGND VGND VPWR VPWR sky130_fd_sc_hd__diode_2
XANTENNA__4323__S1 _1113_ VGND VGND VPWR VPWR sky130_fd_sc_hd__diode_2
XANTENNA__6007__A net135 VGND VGND VPWR VPWR sky130_fd_sc_hd__diode_2
XANTENNA__7537__S _3684_ VGND VGND VPWR VPWR sky130_fd_sc_hd__diode_2
XFILLER_0_84_166 VGND VGND VPWR VPWR sky130_fd_sc_hd__fill_2
XFILLER_0_26_701 VGND VGND VPWR VPWR sky130_fd_sc_hd__decap_3
XANTENNA__5743__A4 _1106_ VGND VGND VPWR VPWR sky130_fd_sc_hd__diode_2
XANTENNA__5057__S _1689_ VGND VGND VPWR VPWR sky130_fd_sc_hd__diode_2
XFILLER_0_80_361 VGND VGND VPWR VPWR sky130_fd_sc_hd__fill_1
X_4460_ registers\[4\]\[10\] registers\[5\]\[10\] registers\[6\]\[10\] registers\[7\]\[10\]
+ _1110_ _1112_ VGND VGND VPWR VPWR _1250_ sky130_fd_sc_hd__mux4_1
X_4391_ _1184_ VGND VGND VPWR VPWR net141 sky130_fd_sc_hd__inv_2
XFILLER_0_111_669 VGND VGND VPWR VPWR sky130_fd_sc_hd__decap_3
XANTENNA__5581__A _1145_ VGND VGND VPWR VPWR sky130_fd_sc_hd__diode_2
X_6130_ _2233_ _2243_ VGND VGND VPWR VPWR _2842_ sky130_fd_sc_hd__nand2_1
XFILLER_0_0_322 VGND VGND VPWR VPWR sky130_fd_sc_hd__decap_4
XFILLER_0_110_157 VGND VGND VPWR VPWR sky130_fd_sc_hd__fill_2
XFILLER_0_84_11 VGND VGND VPWR VPWR sky130_fd_sc_hd__fill_2
X_6061_ _2704_ _2742_ _2773_ _2776_ VGND VGND VPWR VPWR _2777_ sky130_fd_sc_hd__o31ai_4
X_5012_ _1691_ VGND VGND VPWR VPWR _1774_ sky130_fd_sc_hd__clkbuf_8
XFILLER_0_30_7 VGND VGND VPWR VPWR sky130_fd_sc_hd__decap_3
XFILLER_0_108_40 VGND VGND VPWR VPWR sky130_fd_sc_hd__decap_3
XANTENNA__6616__S _3175_ VGND VGND VPWR VPWR sky130_fd_sc_hd__diode_2
XANTENNA__7405__A1 _3451_ VGND VGND VPWR VPWR sky130_fd_sc_hd__diode_2
XANTENNA__4925__A _1628_ VGND VGND VPWR VPWR sky130_fd_sc_hd__diode_2
XFILLER_0_17_71 VGND VGND VPWR VPWR sky130_fd_sc_hd__decap_3
X_6963_ _3370_ VGND VGND VPWR VPWR _0961_ sky130_fd_sc_hd__clkbuf_1
X_5914_ _2472_ _2637_ _2490_ VGND VGND VPWR VPWR _2638_ sky130_fd_sc_hd__mux2_1
X_6894_ _3333_ VGND VGND VPWR VPWR _0929_ sky130_fd_sc_hd__clkbuf_1
XFILLER_0_76_645 VGND VGND VPWR VPWR sky130_fd_sc_hd__decap_3
XFILLER_0_76_634 VGND VGND VPWR VPWR sky130_fd_sc_hd__fill_2
X_8702_ clknet_leaf_96_clk _0823_ VGND VGND VPWR VPWR registers\[0\]\[30\] sky130_fd_sc_hd__dfxtp_1
XFILLER_0_119_725 VGND VGND VPWR VPWR sky130_fd_sc_hd__decap_3
X_5845_ _2560_ _2566_ _2572_ VGND VGND VPWR VPWR _2573_ sky130_fd_sc_hd__o21a_1
XFILLER_0_76_678 VGND VGND VPWR VPWR sky130_fd_sc_hd__fill_2
XANTENNA__6916__A0 _3108_ VGND VGND VPWR VPWR sky130_fd_sc_hd__diode_2
XTAP_TAPCELL_ROW_52_938 VGND VPWR sky130_fd_sc_hd__tapvpwrvgnd_1
XFILLER_0_48_369 VGND VGND VPWR VPWR sky130_fd_sc_hd__fill_1
X_8633_ clknet_leaf_81_clk _0754_ VGND VGND VPWR VPWR registers\[29\]\[25\] sky130_fd_sc_hd__dfxtp_1
XFILLER_0_118_246 VGND VGND VPWR VPWR sky130_fd_sc_hd__decap_6
XFILLER_0_118_235 VGND VGND VPWR VPWR sky130_fd_sc_hd__decap_8
XANTENNA__5035__A1_N _1616_ VGND VGND VPWR VPWR sky130_fd_sc_hd__diode_2
XANTENNA__5756__A net108 VGND VGND VPWR VPWR sky130_fd_sc_hd__diode_2
XANTENNA__6351__S _2961_ VGND VGND VPWR VPWR sky130_fd_sc_hd__diode_2
XANTENNA__7447__S _3634_ VGND VGND VPWR VPWR sky130_fd_sc_hd__diode_2
XFILLER_0_33_81 VGND VGND VPWR VPWR sky130_fd_sc_hd__fill_1
XFILLER_0_33_92 VGND VGND VPWR VPWR sky130_fd_sc_hd__fill_2
X_5776_ _2312_ _2303_ VGND VGND VPWR VPWR _2506_ sky130_fd_sc_hd__nor2_1
XFILLER_0_90_136 VGND VGND VPWR VPWR sky130_fd_sc_hd__fill_2
XFILLER_0_75_199 VGND VGND VPWR VPWR sky130_fd_sc_hd__fill_1
XFILLER_0_44_520 VGND VGND VPWR VPWR sky130_fd_sc_hd__fill_2
X_8564_ clknet_leaf_74_clk _0685_ VGND VGND VPWR VPWR registers\[19\]\[20\] sky130_fd_sc_hd__dfxtp_1
XFILLER_0_16_211 VGND VGND VPWR VPWR sky130_fd_sc_hd__fill_2
XTAP_TAPCELL_ROW_32_673 VGND VPWR sky130_fd_sc_hd__tapvpwrvgnd_1
X_8495_ _4198_ VGND VGND VPWR VPWR _0641_ sky130_fd_sc_hd__clkbuf_1
XFILLER_0_44_575 VGND VGND VPWR VPWR sky130_fd_sc_hd__fill_2
XFILLER_0_44_553 VGND VGND VPWR VPWR sky130_fd_sc_hd__fill_2
X_7515_ _3127_ registers\[21\]\[28\] _3670_ VGND VGND VPWR VPWR _3679_ sky130_fd_sc_hd__mux2_1
X_4727_ registers\[16\]\[25\] registers\[17\]\[25\] registers\[18\]\[25\] registers\[19\]\[25\]
+ _1415_ _1416_ VGND VGND VPWR VPWR _1502_ sky130_fd_sc_hd__mux4_1
XFILLER_0_44_597 VGND VGND VPWR VPWR sky130_fd_sc_hd__fill_2
XFILLER_0_4_661 VGND VGND VPWR VPWR sky130_fd_sc_hd__fill_2
X_7446_ _3642_ VGND VGND VPWR VPWR _0148_ sky130_fd_sc_hd__clkbuf_1
X_4658_ _1143_ VGND VGND VPWR VPWR _1438_ sky130_fd_sc_hd__buf_4
XFILLER_0_31_225 VGND VGND VPWR VPWR sky130_fd_sc_hd__fill_1
XFILLER_0_114_474 VGND VGND VPWR VPWR sky130_fd_sc_hd__fill_2
XFILLER_0_101_113 VGND VGND VPWR VPWR sky130_fd_sc_hd__decap_4
XANTENNA__8278__S _4081_ VGND VGND VPWR VPWR sky130_fd_sc_hd__diode_2
XANTENNA__5491__A _2034_ VGND VGND VPWR VPWR sky130_fd_sc_hd__diode_2
XTAP_TAPCELL_ROW_73_1211 VGND VPWR sky130_fd_sc_hd__tapvpwrvgnd_1
X_4589_ _1371_ VGND VGND VPWR VPWR net121 sky130_fd_sc_hd__buf_1
X_9116_ clknet_leaf_104_clk _0213_ VGND VGND VPWR VPWR registers\[22\]\[28\] sky130_fd_sc_hd__dfxtp_1
XFILLER_0_12_472 VGND VGND VPWR VPWR sky130_fd_sc_hd__fill_2
X_7377_ _3605_ VGND VGND VPWR VPWR _0116_ sky130_fd_sc_hd__clkbuf_1
X_6328_ _3009_ VGND VGND VPWR VPWR _0687_ sky130_fd_sc_hd__clkbuf_1
XFILLER_0_110_691 VGND VGND VPWR VPWR sky130_fd_sc_hd__decap_8
X_9047_ clknet_leaf_75_clk _0144_ VGND VGND VPWR VPWR registers\[20\]\[23\] sky130_fd_sc_hd__dfxtp_1
XANTENNA__7910__S _3887_ VGND VGND VPWR VPWR sky130_fd_sc_hd__diode_2
X_6259_ registers\[19\]\[0\] _2958_ _2962_ VGND VGND VPWR VPWR _2963_ sky130_fd_sc_hd__mux2_1
XTAP_TAPCELL_ROW_4_310 VGND VPWR sky130_fd_sc_hd__tapvpwrvgnd_1
XFILLER_0_98_269 VGND VGND VPWR VPWR sky130_fd_sc_hd__decap_3
XANTENNA__4305__S1 _1040_ VGND VGND VPWR VPWR sky130_fd_sc_hd__diode_2
XTAP_TAPCELL_ROW_84_1351 VGND VPWR sky130_fd_sc_hd__tapvpwrvgnd_1
XFILLER_0_79_483 VGND VGND VPWR VPWR sky130_fd_sc_hd__fill_2
XFILLER_0_67_634 VGND VGND VPWR VPWR sky130_fd_sc_hd__fill_2
XFILLER_0_82_604 VGND VGND VPWR VPWR sky130_fd_sc_hd__fill_1
XFILLER_0_67_667 VGND VGND VPWR VPWR sky130_fd_sc_hd__fill_1
XPHY_EDGE_ROW_11_Right_11 VGND VGND VPWR VPWR sky130_fd_sc_hd__decap_3
XFILLER_0_94_497 VGND VGND VPWR VPWR sky130_fd_sc_hd__decap_4
XFILLER_0_94_486 VGND VGND VPWR VPWR sky130_fd_sc_hd__fill_2
XFILLER_0_94_475 VGND VGND VPWR VPWR sky130_fd_sc_hd__fill_1
XFILLER_0_82_637 VGND VGND VPWR VPWR sky130_fd_sc_hd__fill_2
XFILLER_0_82_626 VGND VGND VPWR VPWR sky130_fd_sc_hd__decap_4
XFILLER_0_66_188 VGND VGND VPWR VPWR sky130_fd_sc_hd__fill_2
XFILLER_0_66_166 VGND VGND VPWR VPWR sky130_fd_sc_hd__fill_2
XANTENNA__7357__S _3586_ VGND VGND VPWR VPWR sky130_fd_sc_hd__diode_2
XFILLER_0_62_394 VGND VGND VPWR VPWR sky130_fd_sc_hd__decap_3
XTAP_TAPCELL_ROW_10_389 VGND VPWR sky130_fd_sc_hd__tapvpwrvgnd_1
XANTENNA__8188__S _4031_ VGND VGND VPWR VPWR sky130_fd_sc_hd__diode_2
XTAP_TAPCELL_ROW_95_1491 VGND VPWR sky130_fd_sc_hd__tapvpwrvgnd_1
XANTENNA__6497__A net30 VGND VGND VPWR VPWR sky130_fd_sc_hd__diode_2
XFILLER_0_22_269 VGND VGND VPWR VPWR sky130_fd_sc_hd__decap_3
XANTENNA__4241__S0 _1039_ VGND VGND VPWR VPWR sky130_fd_sc_hd__diode_2
XPHY_EDGE_ROW_20_Right_20 VGND VGND VPWR VPWR sky130_fd_sc_hd__decap_3
XANTENNA__4449__A1 _1073_ VGND VGND VPWR VPWR sky130_fd_sc_hd__diode_2
XANTENNA__4544__S1 _1137_ VGND VGND VPWR VPWR sky130_fd_sc_hd__diode_2
XANTENNA__6436__S _3069_ VGND VGND VPWR VPWR sky130_fd_sc_hd__diode_2
XFILLER_0_89_269 VGND VGND VPWR VPWR sky130_fd_sc_hd__fill_1
XANTENNA__8060__A1 _3493_ VGND VGND VPWR VPWR sky130_fd_sc_hd__diode_2
XFILLER_0_57_111 VGND VGND VPWR VPWR sky130_fd_sc_hd__fill_1
XFILLER_0_85_442 VGND VGND VPWR VPWR sky130_fd_sc_hd__decap_4
XFILLER_0_58_678 VGND VGND VPWR VPWR sky130_fd_sc_hd__fill_1
XFILLER_0_57_122 VGND VGND VPWR VPWR sky130_fd_sc_hd__fill_2
XTAP_TAPCELL_ROW_18_489 VGND VPWR sky130_fd_sc_hd__tapvpwrvgnd_1
XFILLER_0_73_637 VGND VGND VPWR VPWR sky130_fd_sc_hd__fill_2
X_5630_ _1979_ _2234_ _1050_ VGND VGND VPWR VPWR _2365_ sky130_fd_sc_hd__o21ai_1
XFILLER_0_26_520 VGND VGND VPWR VPWR sky130_fd_sc_hd__fill_1
XANTENNA__4909__C1 net5 VGND VGND VPWR VPWR sky130_fd_sc_hd__diode_2
X_5561_ _2295_ _1108_ VGND VGND VPWR VPWR _2297_ sky130_fd_sc_hd__nor2_2
XFILLER_0_5_447 VGND VGND VPWR VPWR sky130_fd_sc_hd__fill_1
XFILLER_0_26_542 VGND VGND VPWR VPWR sky130_fd_sc_hd__fill_2
X_4512_ registers\[0\]\[13\] registers\[1\]\[13\] registers\[2\]\[13\] registers\[3\]\[13\]
+ _1198_ _1199_ VGND VGND VPWR VPWR _1299_ sky130_fd_sc_hd__mux4_1
X_5492_ net113 _2227_ VGND VGND VPWR VPWR _2228_ sky130_fd_sc_hd__nand2_1
X_8280_ _2968_ registers\[31\]\[3\] _4081_ VGND VGND VPWR VPWR _4085_ sky130_fd_sc_hd__mux2_1
X_7300_ registers\[18\]\[23\] _3483_ _3561_ VGND VGND VPWR VPWR _3565_ sky130_fd_sc_hd__mux2_1
XFILLER_0_13_225 VGND VGND VPWR VPWR sky130_fd_sc_hd__decap_4
XFILLER_0_26_586 VGND VGND VPWR VPWR sky130_fd_sc_hd__fill_2
XFILLER_0_110_52 VGND VGND VPWR VPWR sky130_fd_sc_hd__fill_2
X_7231_ _3528_ VGND VGND VPWR VPWR _0047_ sky130_fd_sc_hd__clkbuf_1
XFILLER_0_13_258 VGND VGND VPWR VPWR sky130_fd_sc_hd__fill_2
XFILLER_0_111_444 VGND VGND VPWR VPWR sky130_fd_sc_hd__decap_4
X_4443_ _1116_ _1233_ VGND VGND VPWR VPWR _1234_ sky130_fd_sc_hd__or2_1
XFILLER_0_41_589 VGND VGND VPWR VPWR sky130_fd_sc_hd__fill_1
XFILLER_0_13_269 VGND VGND VPWR VPWR sky130_fd_sc_hd__fill_1
XFILLER_0_95_32 VGND VGND VPWR VPWR sky130_fd_sc_hd__fill_2
XFILLER_0_95_10 VGND VGND VPWR VPWR sky130_fd_sc_hd__fill_2
X_4374_ _1112_ VGND VGND VPWR VPWR _1168_ sky130_fd_sc_hd__buf_4
X_7162_ _3488_ VGND VGND VPWR VPWR _0018_ sky130_fd_sc_hd__clkbuf_1
XFILLER_0_0_152 VGND VGND VPWR VPWR sky130_fd_sc_hd__fill_2
XFILLER_0_0_141 VGND VGND VPWR VPWR sky130_fd_sc_hd__decap_8
XANTENNA_clkload14_A clknet_4_15_0_clk VGND VGND VPWR VPWR sky130_fd_sc_hd__diode_2
X_7093_ registers\[16\]\[3\] _3441_ _3435_ VGND VGND VPWR VPWR _3442_ sky130_fd_sc_hd__mux2_1
X_6113_ _2209_ _2815_ VGND VGND VPWR VPWR _2825_ sky130_fd_sc_hd__nor2_1
X_6044_ _2362_ _2446_ _2755_ _2760_ VGND VGND VPWR VPWR _2761_ sky130_fd_sc_hd__o211a_1
XANTENNA__7730__S _3793_ VGND VGND VPWR VPWR sky130_fd_sc_hd__diode_2
XPHY_EDGE_ROW_13_Left_133 VGND VGND VPWR VPWR sky130_fd_sc_hd__decap_3
XTAP_TAPCELL_ROW_107_1649 VGND VPWR sky130_fd_sc_hd__tapvpwrvgnd_1
XFILLER_0_96_729 VGND VGND VPWR VPWR sky130_fd_sc_hd__fill_1
XTAP_TAPCELL_ROW_37_743 VGND VPWR sky130_fd_sc_hd__tapvpwrvgnd_1
X_7995_ _3933_ VGND VGND VPWR VPWR _0406_ sky130_fd_sc_hd__clkbuf_1
X_6946_ _3065_ registers\[14\]\[0\] _3361_ VGND VGND VPWR VPWR _3362_ sky130_fd_sc_hd__mux2_1
XFILLER_0_119_533 VGND VGND VPWR VPWR sky130_fd_sc_hd__fill_2
XFILLER_0_91_412 VGND VGND VPWR VPWR sky130_fd_sc_hd__fill_1
XFILLER_0_64_615 VGND VGND VPWR VPWR sky130_fd_sc_hd__fill_2
XFILLER_0_48_155 VGND VGND VPWR VPWR sky130_fd_sc_hd__decap_4
XPHY_EDGE_ROW_22_Left_142 VGND VGND VPWR VPWR sky130_fd_sc_hd__decap_3
X_6877_ _3065_ registers\[13\]\[0\] _3324_ VGND VGND VPWR VPWR _3325_ sky130_fd_sc_hd__mux2_1
XFILLER_0_36_317 VGND VGND VPWR VPWR sky130_fd_sc_hd__decap_6
XANTENNA__6081__S _2344_ VGND VGND VPWR VPWR sky130_fd_sc_hd__diode_2
XFILLER_0_107_706 VGND VGND VPWR VPWR sky130_fd_sc_hd__decap_8
X_5828_ _2553_ _2555_ VGND VGND VPWR VPWR _2556_ sky130_fd_sc_hd__nand2_1
X_8616_ clknet_leaf_20_clk _0737_ VGND VGND VPWR VPWR registers\[29\]\[8\] sky130_fd_sc_hd__dfxtp_1
XFILLER_0_8_263 VGND VGND VPWR VPWR sky130_fd_sc_hd__fill_2
X_5759_ _2445_ VGND VGND VPWR VPWR _2490_ sky130_fd_sc_hd__clkbuf_4
X_8547_ clknet_leaf_22_clk _0668_ VGND VGND VPWR VPWR registers\[19\]\[3\] sky130_fd_sc_hd__dfxtp_1
XFILLER_0_63_169 VGND VGND VPWR VPWR sky130_fd_sc_hd__fill_2
XANTENNA__7905__S _3876_ VGND VGND VPWR VPWR sky130_fd_sc_hd__diode_2
XFILLER_0_17_597 VGND VGND VPWR VPWR sky130_fd_sc_hd__fill_1
XFILLER_0_114_260 VGND VGND VPWR VPWR sky130_fd_sc_hd__fill_2
XFILLER_0_32_545 VGND VGND VPWR VPWR sky130_fd_sc_hd__fill_2
XFILLER_0_32_567 VGND VGND VPWR VPWR sky130_fd_sc_hd__fill_2
X_8478_ registers\[4\]\[0\] net16 _4189_ VGND VGND VPWR VPWR _4190_ sky130_fd_sc_hd__mux2_1
XTAP_TAPCELL_ROW_118_1789 VGND VPWR sky130_fd_sc_hd__tapvpwrvgnd_1
X_7429_ _3633_ VGND VGND VPWR VPWR _0140_ sky130_fd_sc_hd__clkbuf_1
XFILLER_0_32_589 VGND VGND VPWR VPWR sky130_fd_sc_hd__fill_2
XFILLER_0_102_477 VGND VGND VPWR VPWR sky130_fd_sc_hd__fill_2
XPHY_EDGE_ROW_31_Left_151 VGND VGND VPWR VPWR sky130_fd_sc_hd__decap_3
XFILLER_0_99_501 VGND VGND VPWR VPWR sky130_fd_sc_hd__decap_3
XANTENNA__4526__S1 _1128_ VGND VGND VPWR VPWR sky130_fd_sc_hd__diode_2
XFILLER_0_87_729 VGND VGND VPWR VPWR sky130_fd_sc_hd__fill_1
XFILLER_0_86_217 VGND VGND VPWR VPWR sky130_fd_sc_hd__fill_2
XPHY_EDGE_ROW_40_Left_160 VGND VGND VPWR VPWR sky130_fd_sc_hd__decap_3
XFILLER_0_67_486 VGND VGND VPWR VPWR sky130_fd_sc_hd__fill_2
XTAP_TAPCELL_ROW_15_448 VGND VPWR sky130_fd_sc_hd__tapvpwrvgnd_1
XTAP_TAPCELL_ROW_15_459 VGND VPWR sky130_fd_sc_hd__tapvpwrvgnd_1
XANTENNA__7087__S _3435_ VGND VGND VPWR VPWR sky130_fd_sc_hd__diode_2
XFILLER_0_27_317 VGND VGND VPWR VPWR sky130_fd_sc_hd__fill_1
XANTENNA__5396__A _2136_ VGND VGND VPWR VPWR sky130_fd_sc_hd__diode_2
XFILLER_0_54_125 VGND VGND VPWR VPWR sky130_fd_sc_hd__fill_2
XFILLER_0_113_709 VPWR VGND VPWR VGND sky130_ef_sc_hd__decap_12
XTAP_TAPCELL_ROW_97_1520 VGND VPWR sky130_fd_sc_hd__tapvpwrvgnd_1
XFILLER_0_49_14 VGND VGND VPWR VPWR sky130_fd_sc_hd__fill_1
XFILLER_0_11_729 VGND VGND VPWR VPWR sky130_fd_sc_hd__decap_4
XANTENNA__6020__A _2362_ VGND VGND VPWR VPWR sky130_fd_sc_hd__diode_2
XANTENNA__4765__S1 _1391_ VGND VGND VPWR VPWR sky130_fd_sc_hd__diode_2
XANTENNA__7550__S _3695_ VGND VGND VPWR VPWR sky130_fd_sc_hd__diode_2
XANTENNA__4517__S1 _1199_ VGND VGND VPWR VPWR sky130_fd_sc_hd__diode_2
XFILLER_0_65_57 VGND VGND VPWR VPWR sky130_fd_sc_hd__decap_4
XFILLER_0_65_35 VGND VGND VPWR VPWR sky130_fd_sc_hd__fill_1
XANTENNA__8033__A1 _3466_ VGND VGND VPWR VPWR sky130_fd_sc_hd__diode_2
XFILLER_0_77_217 VGND VGND VPWR VPWR sky130_fd_sc_hd__decap_4
XANTENNA__8381__S _4128_ VGND VGND VPWR VPWR sky130_fd_sc_hd__diode_2
X_6800_ _3282_ VGND VGND VPWR VPWR _0886_ sky130_fd_sc_hd__clkbuf_1
X_4992_ _1687_ VGND VGND VPWR VPWR _1754_ sky130_fd_sc_hd__clkbuf_8
X_7780_ _3119_ registers\[25\]\[24\] _3815_ VGND VGND VPWR VPWR _3820_ sky130_fd_sc_hd__mux2_1
XANTENNA__7792__A0 _3131_ VGND VGND VPWR VPWR sky130_fd_sc_hd__diode_2
XTAP_TAPCELL_ROW_34_702 VGND VPWR sky130_fd_sc_hd__tapvpwrvgnd_1
X_6731_ registers\[10\]\[29\] _3022_ _3236_ VGND VGND VPWR VPWR _3246_ sky130_fd_sc_hd__mux2_1
X_9450_ clknet_leaf_39_clk _0547_ VGND VGND VPWR VPWR registers\[31\]\[10\] sky130_fd_sc_hd__dfxtp_1
XTAP_TAPCELL_ROW_102_1579 VGND VPWR sky130_fd_sc_hd__tapvpwrvgnd_1
X_6662_ registers\[0\]\[30\] _3024_ _3174_ VGND VGND VPWR VPWR _3208_ sky130_fd_sc_hd__mux2_1
XFILLER_0_6_701 VPWR VGND VPWR VGND sky130_ef_sc_hd__decap_12
X_9381_ clknet_leaf_31_clk _0478_ VGND VGND VPWR VPWR registers\[9\]\[5\] sky130_fd_sc_hd__dfxtp_1
X_5613_ _2346_ _2347_ VGND VGND VPWR VPWR _2348_ sky130_fd_sc_hd__nand2_1
XFILLER_0_61_607 VGND VGND VPWR VPWR sky130_fd_sc_hd__fill_2
X_8401_ _4148_ VGND VGND VPWR VPWR _0597_ sky130_fd_sc_hd__clkbuf_1
XFILLER_0_116_569 VGND VGND VPWR VPWR sky130_fd_sc_hd__fill_1
XFILLER_0_116_558 VGND VGND VPWR VPWR sky130_fd_sc_hd__fill_1
XANTENNA__4453__S0 _1110_ VGND VGND VPWR VPWR sky130_fd_sc_hd__diode_2
XFILLER_0_73_489 VGND VGND VPWR VPWR sky130_fd_sc_hd__decap_4
XFILLER_0_54_681 VGND VGND VPWR VPWR sky130_fd_sc_hd__decap_3
X_6593_ _3170_ VGND VGND VPWR VPWR _0791_ sky130_fd_sc_hd__clkbuf_1
X_8332_ _3020_ registers\[31\]\[28\] _4103_ VGND VGND VPWR VPWR _4112_ sky130_fd_sc_hd__mux2_1
XFILLER_0_5_233 VGND VGND VPWR VPWR sky130_fd_sc_hd__decap_8
X_5544_ _1899_ _2216_ _2217_ VGND VGND VPWR VPWR _2280_ sky130_fd_sc_hd__o21ai_1
XFILLER_0_60_139 VGND VGND VPWR VPWR sky130_fd_sc_hd__fill_1
XTAP_TAPCELL_ROW_57_1003 VGND VPWR sky130_fd_sc_hd__tapvpwrvgnd_1
XFILLER_0_5_277 VGND VGND VPWR VPWR sky130_fd_sc_hd__decap_3
XFILLER_0_30_82 VGND VGND VPWR VPWR sky130_fd_sc_hd__fill_2
XANTENNA__5753__B net14 VGND VGND VPWR VPWR sky130_fd_sc_hd__diode_2
X_5475_ _2208_ _2209_ _2210_ VGND VGND VPWR VPWR _2211_ sky130_fd_sc_hd__nor3_1
X_8263_ _4075_ VGND VGND VPWR VPWR _0532_ sky130_fd_sc_hd__clkbuf_1
X_7214_ _3519_ VGND VGND VPWR VPWR _0039_ sky130_fd_sc_hd__clkbuf_1
X_4426_ registers\[0\]\[8\] registers\[1\]\[8\] registers\[2\]\[8\] registers\[3\]\[8\]
+ _1196_ _1202_ VGND VGND VPWR VPWR _1218_ sky130_fd_sc_hd__mux4_1
X_8194_ registers\[9\]\[27\] _3491_ _4031_ VGND VGND VPWR VPWR _4039_ sky130_fd_sc_hd__mux2_1
X_7145_ _3434_ VGND VGND VPWR VPWR _3477_ sky130_fd_sc_hd__clkbuf_8
X_4357_ _1150_ _1151_ _1148_ VGND VGND VPWR VPWR _1152_ sky130_fd_sc_hd__mux2_1
XFILLER_0_39_80 VGND VGND VPWR VPWR sky130_fd_sc_hd__fill_2
XANTENNA__4508__S1 _1161_ VGND VGND VPWR VPWR sky130_fd_sc_hd__diode_2
X_7076_ _3430_ VGND VGND VPWR VPWR _1014_ sky130_fd_sc_hd__clkbuf_1
X_4288_ registers\[12\]\[2\] registers\[13\]\[2\] registers\[14\]\[2\] registers\[15\]\[2\]
+ _1039_ _1040_ VGND VGND VPWR VPWR _1086_ sky130_fd_sc_hd__mux4_1
XANTENNA__4385__A _1124_ VGND VGND VPWR VPWR sky130_fd_sc_hd__diode_2
XANTENNA__5181__S1 _1765_ VGND VGND VPWR VPWR sky130_fd_sc_hd__diode_2
X_6027_ _2704_ _2742_ _2744_ VGND VGND VPWR VPWR _2745_ sky130_fd_sc_hd__o21a_1
XFILLER_0_96_537 VGND VGND VPWR VPWR sky130_fd_sc_hd__fill_2
XTAP_TAPCELL_ROW_68_1143 VGND VPWR sky130_fd_sc_hd__tapvpwrvgnd_1
XFILLER_0_68_228 VGND VGND VPWR VPWR sky130_fd_sc_hd__fill_2
XTAP_TAPCELL_ROW_81_1310 VGND VPWR sky130_fd_sc_hd__tapvpwrvgnd_1
X_7978_ _3006_ registers\[28\]\[21\] _3923_ VGND VGND VPWR VPWR _3925_ sky130_fd_sc_hd__mux2_1
XANTENNA__6586__A1 _3018_ VGND VGND VPWR VPWR sky130_fd_sc_hd__diode_2
XFILLER_0_92_710 VGND VGND VPWR VPWR sky130_fd_sc_hd__decap_3
XFILLER_0_49_453 VGND VGND VPWR VPWR sky130_fd_sc_hd__decap_3
X_6929_ _3121_ registers\[13\]\[25\] _3346_ VGND VGND VPWR VPWR _3352_ sky130_fd_sc_hd__mux2_1
XANTENNA__7535__A0 _3079_ VGND VGND VPWR VPWR sky130_fd_sc_hd__diode_2
XFILLER_0_76_272 VGND VGND VPWR VPWR sky130_fd_sc_hd__fill_1
XANTENNA__4692__S0 _1320_ VGND VGND VPWR VPWR sky130_fd_sc_hd__diode_2
XTAP_TAPCELL_ROW_12_418 VGND VPWR sky130_fd_sc_hd__tapvpwrvgnd_1
XFILLER_0_107_547 VGND VGND VPWR VPWR sky130_fd_sc_hd__fill_2
XFILLER_0_64_489 VGND VGND VPWR VPWR sky130_fd_sc_hd__fill_2
XFILLER_0_51_117 VGND VGND VPWR VPWR sky130_fd_sc_hd__decap_4
XFILLER_0_45_692 VPWR VGND VPWR VGND sky130_ef_sc_hd__decap_12
XFILLER_0_45_670 VGND VGND VPWR VPWR sky130_fd_sc_hd__fill_2
XFILLER_0_10_19 VGND VGND VPWR VPWR sky130_fd_sc_hd__fill_2
XANTENNA__7635__S _3742_ VGND VGND VPWR VPWR sky130_fd_sc_hd__diode_2
XFILLER_0_51_139 VGND VGND VPWR VPWR sky130_fd_sc_hd__fill_2
XFILLER_0_32_342 VGND VGND VPWR VPWR sky130_fd_sc_hd__fill_1
XFILLER_0_115_580 VGND VGND VPWR VPWR sky130_fd_sc_hd__fill_2
XTAP_TAPCELL_ROW_79_1283 VGND VPWR sky130_fd_sc_hd__tapvpwrvgnd_1
XFILLER_0_102_263 VGND VGND VPWR VPWR sky130_fd_sc_hd__fill_2
XFILLER_0_20_537 VGND VGND VPWR VPWR sky130_fd_sc_hd__decap_4
XFILLER_0_20_548 VGND VGND VPWR VPWR sky130_fd_sc_hd__fill_2
XTAP_TAPCELL_ROW_92_1461 VGND VPWR sky130_fd_sc_hd__tapvpwrvgnd_1
XTAP_TAPCELL_ROW_92_1450 VGND VPWR sky130_fd_sc_hd__tapvpwrvgnd_1
XANTENNA__4747__S1 _1348_ VGND VGND VPWR VPWR sky130_fd_sc_hd__diode_2
XANTENNA__7370__S _3597_ VGND VGND VPWR VPWR sky130_fd_sc_hd__diode_2
XANTENNA__8466__S _4175_ VGND VGND VPWR VPWR sky130_fd_sc_hd__diode_2
XANTENNA__5172__S1 _1811_ VGND VGND VPWR VPWR sky130_fd_sc_hd__diode_2
XFILLER_0_99_353 VGND VGND VPWR VPWR sky130_fd_sc_hd__fill_1
XFILLER_0_87_559 VGND VGND VPWR VPWR sky130_fd_sc_hd__fill_1
XFILLER_0_67_272 VGND VGND VPWR VPWR sky130_fd_sc_hd__fill_1
XFILLER_0_28_626 VGND VGND VPWR VPWR sky130_fd_sc_hd__decap_3
XFILLER_0_82_253 VGND VGND VPWR VPWR sky130_fd_sc_hd__fill_2
XFILLER_0_27_158 VGND VGND VPWR VPWR sky130_fd_sc_hd__decap_8
XFILLER_0_27_169 VGND VGND VPWR VPWR sky130_fd_sc_hd__decap_4
XANTENNA__4435__S0 _1053_ VGND VGND VPWR VPWR sky130_fd_sc_hd__diode_2
XFILLER_0_36_681 VGND VGND VPWR VPWR sky130_fd_sc_hd__fill_1
XFILLER_0_113_528 VGND VGND VPWR VPWR sky130_fd_sc_hd__fill_1
Xclkload13 clknet_4_14_0_clk VGND VGND VPWR VPWR clkload13/Y sky130_fd_sc_hd__inv_6
Xclkload24 clknet_leaf_6_clk VGND VGND VPWR VPWR clkload24/Y sky130_fd_sc_hd__bufinv_16
XFILLER_0_2_214 VGND VGND VPWR VPWR sky130_fd_sc_hd__decap_4
Xclkload35 clknet_leaf_10_clk VGND VGND VPWR VPWR clkload35/Y sky130_fd_sc_hd__clkinvlp_4
Xclkload57 clknet_leaf_38_clk VGND VGND VPWR VPWR clkload57/Y sky130_fd_sc_hd__clkinvlp_2
Xclkload46 clknet_leaf_31_clk VGND VGND VPWR VPWR clkload46/Y sky130_fd_sc_hd__inv_6
XFILLER_0_2_225 VGND VGND VPWR VPWR sky130_fd_sc_hd__fill_2
Xclkload68 clknet_leaf_92_clk VGND VGND VPWR VPWR clkload68/Y sky130_fd_sc_hd__bufinv_16
XFILLER_0_2_269 VGND VGND VPWR VPWR sky130_fd_sc_hd__decap_4
Xclkload79 clknet_leaf_83_clk VGND VGND VPWR VPWR clkload79/Y sky130_fd_sc_hd__clkinv_4
X_5260_ registers\[12\]\[20\] registers\[13\]\[20\] registers\[14\]\[20\] registers\[15\]\[20\]
+ _1758_ _1760_ VGND VGND VPWR VPWR _2008_ sky130_fd_sc_hd__mux4_1
X_5191_ _1741_ _1934_ _1942_ VGND VGND VPWR VPWR _1943_ sky130_fd_sc_hd__o21ai_4
XFILLER_0_76_89 VPWR VGND VPWR VGND sky130_ef_sc_hd__decap_12
XANTENNA__8254__A1 _3483_ VGND VGND VPWR VPWR sky130_fd_sc_hd__diode_2
X_8950_ clknet_leaf_95_clk _0047_ VGND VGND VPWR VPWR registers\[17\]\[22\] sky130_fd_sc_hd__dfxtp_1
X_7901_ _3104_ registers\[27\]\[17\] _3876_ VGND VGND VPWR VPWR _3884_ sky130_fd_sc_hd__mux2_1
XFILLER_0_92_33 VGND VGND VPWR VPWR sky130_fd_sc_hd__fill_2
XANTENNA__8006__A1 _3439_ VGND VGND VPWR VPWR sky130_fd_sc_hd__diode_2
XANTENNA__7012__C net48 VGND VGND VPWR VPWR sky130_fd_sc_hd__diode_2
XANTENNA__6017__B1 _1145_ VGND VGND VPWR VPWR sky130_fd_sc_hd__diode_2
X_8881_ clknet_leaf_49_clk _1002_ VGND VGND VPWR VPWR registers\[15\]\[17\] sky130_fd_sc_hd__dfxtp_1
XFILLER_0_78_537 VGND VGND VPWR VPWR sky130_fd_sc_hd__decap_8
XANTENNA__4291__A2 _1080_ VGND VGND VPWR VPWR sky130_fd_sc_hd__diode_2
XANTENNA__7765__A0 _3104_ VGND VGND VPWR VPWR sky130_fd_sc_hd__diode_2
XTAP_TAPCELL_ROW_104_1608 VGND VPWR sky130_fd_sc_hd__tapvpwrvgnd_1
XFILLER_0_78_548 VGND VGND VPWR VPWR sky130_fd_sc_hd__fill_2
X_7832_ _3847_ VGND VGND VPWR VPWR _0329_ sky130_fd_sc_hd__clkbuf_1
XTAP_TAPCELL_ROW_47_871 VGND VPWR sky130_fd_sc_hd__tapvpwrvgnd_1
X_4975_ _1736_ _1737_ _1627_ VGND VGND VPWR VPWR _1738_ sky130_fd_sc_hd__mux2_1
X_7763_ _3102_ registers\[25\]\[16\] _3804_ VGND VGND VPWR VPWR _3811_ sky130_fd_sc_hd__mux2_1
XFILLER_0_65_209 VGND VGND VPWR VPWR sky130_fd_sc_hd__fill_2
XFILLER_0_86_581 VGND VGND VPWR VPWR sky130_fd_sc_hd__decap_4
X_9502_ clknet_leaf_99_clk _0599_ VGND VGND VPWR VPWR registers\[5\]\[30\] sky130_fd_sc_hd__dfxtp_1
X_6714_ _3237_ VGND VGND VPWR VPWR _0845_ sky130_fd_sc_hd__clkbuf_1
XFILLER_0_116_322 VGND VGND VPWR VPWR sky130_fd_sc_hd__fill_2
XTAP_TAPCELL_ROW_63_1084 VGND VPWR sky130_fd_sc_hd__tapvpwrvgnd_1
XTAP_TAPCELL_ROW_63_1073 VGND VPWR sky130_fd_sc_hd__tapvpwrvgnd_1
X_7694_ _3774_ VGND VGND VPWR VPWR _0264_ sky130_fd_sc_hd__clkbuf_1
X_9433_ clknet_leaf_87_clk _0530_ VGND VGND VPWR VPWR registers\[6\]\[25\] sky130_fd_sc_hd__dfxtp_1
XFILLER_0_19_659 VGND VGND VPWR VPWR sky130_fd_sc_hd__fill_2
XANTENNA__4426__S0 _1196_ VGND VGND VPWR VPWR sky130_fd_sc_hd__diode_2
XFILLER_0_6_531 VGND VGND VPWR VPWR sky130_fd_sc_hd__fill_1
X_6645_ _3199_ VGND VGND VPWR VPWR _0814_ sky130_fd_sc_hd__clkbuf_1
Xclkload7 clknet_4_8_0_clk VGND VGND VPWR VPWR clkload7/X sky130_fd_sc_hd__clkbuf_8
X_6576_ registers\[7\]\[22\] _3008_ _3159_ VGND VGND VPWR VPWR _3162_ sky130_fd_sc_hd__mux2_1
X_9364_ clknet_leaf_75_clk _0461_ VGND VGND VPWR VPWR registers\[30\]\[20\] sky130_fd_sc_hd__dfxtp_1
XFILLER_0_33_139 VGND VGND VPWR VPWR sky130_fd_sc_hd__fill_2
X_5527_ _2250_ _2262_ _1090_ VGND VGND VPWR VPWR _2263_ sky130_fd_sc_hd__mux2_1
X_9295_ clknet_leaf_47_clk _0392_ VGND VGND VPWR VPWR registers\[28\]\[15\] sky130_fd_sc_hd__dfxtp_1
XFILLER_0_41_150 VGND VGND VPWR VPWR sky130_fd_sc_hd__fill_2
XFILLER_0_6_597 VGND VGND VPWR VPWR sky130_fd_sc_hd__fill_2
X_8315_ _4080_ VGND VGND VPWR VPWR _4103_ sky130_fd_sc_hd__clkbuf_8
XTAP_TAPCELL_ROW_115_1759 VGND VPWR sky130_fd_sc_hd__tapvpwrvgnd_1
XTAP_TAPCELL_ROW_115_1748 VGND VPWR sky130_fd_sc_hd__tapvpwrvgnd_1
X_8246_ _4066_ VGND VGND VPWR VPWR _0524_ sky130_fd_sc_hd__clkbuf_1
XANTENNA__4729__S1 _1416_ VGND VGND VPWR VPWR sky130_fd_sc_hd__diode_2
X_5458_ _2189_ _2191_ _2194_ _2026_ _1960_ VGND VGND VPWR VPWR _2195_ sky130_fd_sc_hd__o221a_1
XANTENNA__8286__S _4081_ VGND VGND VPWR VPWR sky130_fd_sc_hd__diode_2
X_4409_ _1061_ VGND VGND VPWR VPWR _1202_ sky130_fd_sc_hd__clkbuf_4
XANTENNA__7190__S _3503_ VGND VGND VPWR VPWR sky130_fd_sc_hd__diode_2
X_8177_ registers\[9\]\[19\] _3474_ _4020_ VGND VGND VPWR VPWR _4030_ sky130_fd_sc_hd__mux2_1
XFILLER_0_10_570 VGND VGND VPWR VPWR sky130_fd_sc_hd__fill_2
X_5389_ registers\[12\]\[27\] registers\[13\]\[27\] registers\[14\]\[27\] registers\[15\]\[27\]
+ _2126_ _2127_ VGND VGND VPWR VPWR _2130_ sky130_fd_sc_hd__mux4_1
X_7128_ _3465_ VGND VGND VPWR VPWR _0007_ sky130_fd_sc_hd__clkbuf_1
XANTENNA__5059__A1 _1741_ VGND VGND VPWR VPWR sky130_fd_sc_hd__diode_2
X_7059_ _3113_ registers\[15\]\[21\] _3420_ VGND VGND VPWR VPWR _3422_ sky130_fd_sc_hd__mux2_1
XANTENNA__5154__S1 _1692_ VGND VGND VPWR VPWR sky130_fd_sc_hd__diode_2
XANTENNA__5939__A _1319_ VGND VGND VPWR VPWR sky130_fd_sc_hd__diode_2
XFILLER_0_96_323 VGND VGND VPWR VPWR sky130_fd_sc_hd__fill_2
XANTENNA__6559__A1 _2991_ VGND VGND VPWR VPWR sky130_fd_sc_hd__diode_2
XFILLER_0_69_548 VGND VGND VPWR VPWR sky130_fd_sc_hd__fill_2
XANTENNA__6534__S _3137_ VGND VGND VPWR VPWR sky130_fd_sc_hd__diode_2
XANTENNA__8315__A _4080_ VGND VGND VPWR VPWR sky130_fd_sc_hd__diode_2
XFILLER_0_65_710 VGND VGND VPWR VPWR sky130_fd_sc_hd__decap_4
XFILLER_0_65_732 VGND VGND VPWR VPWR sky130_fd_sc_hd__fill_1
XFILLER_0_65_721 VGND VGND VPWR VPWR sky130_fd_sc_hd__fill_2
XANTENNA__4665__S0 _1427_ VGND VGND VPWR VPWR sky130_fd_sc_hd__diode_2
XFILLER_0_92_551 VGND VGND VPWR VPWR sky130_fd_sc_hd__fill_1
XFILLER_0_64_253 VGND VGND VPWR VPWR sky130_fd_sc_hd__decap_8
XTAP_TAPCELL_ROW_25_587 VGND VPWR sky130_fd_sc_hd__tapvpwrvgnd_1
XFILLER_0_119_193 VGND VGND VPWR VPWR sky130_fd_sc_hd__decap_3
XFILLER_0_64_286 VGND VGND VPWR VPWR sky130_fd_sc_hd__fill_1
XANTENNA__4417__S0 _1196_ VGND VGND VPWR VPWR sky130_fd_sc_hd__diode_2
XFILLER_0_37_478 VGND VGND VPWR VPWR sky130_fd_sc_hd__decap_6
XANTENNA__6192__C1 _2420_ VGND VGND VPWR VPWR sky130_fd_sc_hd__diode_2
XANTENNA__6731__A1 _3022_ VGND VGND VPWR VPWR sky130_fd_sc_hd__diode_2
XANTENNA__5090__S0 _1742_ VGND VGND VPWR VPWR sky130_fd_sc_hd__diode_2
XFILLER_0_33_651 VGND VGND VPWR VPWR sky130_fd_sc_hd__fill_2
XFILLER_0_33_673 VGND VGND VPWR VPWR sky130_fd_sc_hd__decap_3
XFILLER_0_103_561 VGND VGND VPWR VPWR sky130_fd_sc_hd__decap_6
XANTENNA__8484__A1 net41 VGND VGND VPWR VPWR sky130_fd_sc_hd__diode_2
XFILLER_0_60_470 VGND VGND VPWR VPWR sky130_fd_sc_hd__decap_6
XFILLER_0_0_729 VGND VGND VPWR VPWR sky130_fd_sc_hd__decap_4
XFILLER_0_20_334 VGND VGND VPWR VPWR sky130_fd_sc_hd__fill_1
XFILLER_0_32_183 VGND VGND VPWR VPWR sky130_fd_sc_hd__fill_2
XANTENNA__8196__S _4031_ VGND VGND VPWR VPWR sky130_fd_sc_hd__diode_2
XANTENNA__5849__A net112 VGND VGND VPWR VPWR sky130_fd_sc_hd__diode_2
XFILLER_0_1_39 VPWR VGND VPWR VGND sky130_ef_sc_hd__decap_12
XTAP_TAPCELL_ROW_44_830 VGND VPWR sky130_fd_sc_hd__tapvpwrvgnd_1
XANTENNA__4656__S0 _1433_ VGND VGND VPWR VPWR sky130_fd_sc_hd__diode_2
X_4760_ _1533_ VGND VGND VPWR VPWR net131 sky130_fd_sc_hd__dlymetal6s2s_1
XPHY_EDGE_ROW_112_Right_112 VGND VGND VPWR VPWR sky130_fd_sc_hd__decap_3
XANTENNA__7275__S _3550_ VGND VGND VPWR VPWR sky130_fd_sc_hd__diode_2
XFILLER_0_102_20 VGND VGND VPWR VPWR sky130_fd_sc_hd__decap_8
X_4691_ _1468_ VGND VGND VPWR VPWR net127 sky130_fd_sc_hd__clkbuf_2
XANTENNA__6183__C1 _2276_ VGND VGND VPWR VPWR sky130_fd_sc_hd__diode_2
Xclkload102 clknet_leaf_50_clk VGND VGND VPWR VPWR clkload102/Y sky130_fd_sc_hd__clkinv_1
X_6430_ _3065_ registers\[29\]\[0\] _3069_ VGND VGND VPWR VPWR _3070_ sky130_fd_sc_hd__mux2_1
XFILLER_0_11_51 VGND VGND VPWR VPWR sky130_fd_sc_hd__fill_2
XANTENNA__5081__S0 _1757_ VGND VGND VPWR VPWR sky130_fd_sc_hd__diode_2
X_6361_ registers\[3\]\[1\] _2964_ _3030_ VGND VGND VPWR VPWR _3032_ sky130_fd_sc_hd__mux2_1
XFILLER_0_11_73 VGND VGND VPWR VPWR sky130_fd_sc_hd__fill_2
X_8100_ _3989_ VGND VGND VPWR VPWR _0455_ sky130_fd_sc_hd__clkbuf_1
XFILLER_0_113_369 VGND VGND VPWR VPWR sky130_fd_sc_hd__fill_2
XFILLER_0_87_11 VGND VGND VPWR VPWR sky130_fd_sc_hd__fill_1
XPHY_EDGE_ROW_49_Right_49 VGND VGND VPWR VPWR sky130_fd_sc_hd__decap_3
X_5312_ _1752_ _2056_ VGND VGND VPWR VPWR _2057_ sky130_fd_sc_hd__or2_1
XFILLER_0_11_323 VGND VGND VPWR VPWR sky130_fd_sc_hd__fill_2
X_6292_ net18 VGND VGND VPWR VPWR _2985_ sky130_fd_sc_hd__buf_2
X_9080_ clknet_leaf_82_clk _0177_ VGND VGND VPWR VPWR registers\[21\]\[24\] sky130_fd_sc_hd__dfxtp_1
X_8031_ registers\[2\]\[14\] _3464_ _3948_ VGND VGND VPWR VPWR _3953_ sky130_fd_sc_hd__mux2_1
XANTENNA__4497__C1 _1142_ VGND VGND VPWR VPWR sky130_fd_sc_hd__diode_2
X_5243_ registers\[12\]\[19\] registers\[13\]\[19\] registers\[14\]\[19\] registers\[15\]\[19\]
+ _1690_ _1692_ VGND VGND VPWR VPWR _1992_ sky130_fd_sc_hd__mux4_1
XFILLER_0_11_378 VGND VGND VPWR VPWR sky130_fd_sc_hd__fill_2
XANTENNA__5384__S1 _2026_ VGND VGND VPWR VPWR sky130_fd_sc_hd__diode_2
XANTENNA__8227__A1 _3455_ VGND VGND VPWR VPWR sky130_fd_sc_hd__diode_2
X_5174_ _1925_ _1926_ _1809_ VGND VGND VPWR VPWR _1927_ sky130_fd_sc_hd__mux2_1
XTAP_TAPCELL_ROW_110_1689 VGND VPWR sky130_fd_sc_hd__tapvpwrvgnd_1
XANTENNA__5136__S1 _1743_ VGND VGND VPWR VPWR sky130_fd_sc_hd__diode_2
XANTENNA__7986__A0 _3014_ VGND VGND VPWR VPWR sky130_fd_sc_hd__diode_2
X_8933_ clknet_leaf_27_clk _0030_ VGND VGND VPWR VPWR registers\[17\]\[5\] sky130_fd_sc_hd__dfxtp_1
XFILLER_0_78_301 VGND VGND VPWR VPWR sky130_fd_sc_hd__fill_2
XPHY_EDGE_ROW_58_Right_58 VGND VGND VPWR VPWR sky130_fd_sc_hd__decap_3
XTAP_TAPCELL_ROW_65_1102 VGND VPWR sky130_fd_sc_hd__tapvpwrvgnd_1
XANTENNA__4895__S0 _1642_ VGND VGND VPWR VPWR sky130_fd_sc_hd__diode_2
XANTENNA__6354__S _2961_ VGND VGND VPWR VPWR sky130_fd_sc_hd__diode_2
X_8864_ clknet_leaf_2_clk _0985_ VGND VGND VPWR VPWR registers\[15\]\[0\] sky130_fd_sc_hd__dfxtp_1
XFILLER_0_93_304 VGND VGND VPWR VPWR sky130_fd_sc_hd__fill_1
XFILLER_0_78_378 VGND VGND VPWR VPWR sky130_fd_sc_hd__decap_8
XFILLER_0_78_356 VGND VGND VPWR VPWR sky130_fd_sc_hd__fill_1
X_7815_ _3838_ VGND VGND VPWR VPWR _0321_ sky130_fd_sc_hd__clkbuf_1
X_8795_ clknet_leaf_101_clk _0916_ VGND VGND VPWR VPWR registers\[12\]\[27\] sky130_fd_sc_hd__dfxtp_1
X_4958_ registers\[0\]\[4\] registers\[1\]\[4\] registers\[2\]\[4\] registers\[3\]\[4\]
+ _1678_ _1679_ VGND VGND VPWR VPWR _1722_ sky130_fd_sc_hd__mux4_1
XANTENNA__5764__A2 _1660_ VGND VGND VPWR VPWR sky130_fd_sc_hd__diode_2
X_7746_ _3085_ registers\[25\]\[8\] _3793_ VGND VGND VPWR VPWR _3802_ sky130_fd_sc_hd__mux2_1
XFILLER_0_117_653 VPWR VGND VPWR VGND sky130_ef_sc_hd__decap_12
XANTENNA__4972__B1 _1634_ VGND VGND VPWR VPWR sky130_fd_sc_hd__diode_2
X_7677_ _3765_ VGND VGND VPWR VPWR _0256_ sky130_fd_sc_hd__clkbuf_1
XFILLER_0_74_562 VGND VGND VPWR VPWR sky130_fd_sc_hd__fill_2
X_4889_ registers\[4\]\[1\] registers\[5\]\[1\] registers\[6\]\[1\] registers\[7\]\[1\]
+ _1628_ _1629_ VGND VGND VPWR VPWR _1656_ sky130_fd_sc_hd__mux4_1
XTAP_TAPCELL_ROW_22_546 VGND VPWR sky130_fd_sc_hd__tapvpwrvgnd_1
XFILLER_0_34_415 VGND VGND VPWR VPWR sky130_fd_sc_hd__fill_2
XFILLER_0_116_141 VGND VGND VPWR VPWR sky130_fd_sc_hd__fill_2
X_6628_ _3190_ VGND VGND VPWR VPWR _0806_ sky130_fd_sc_hd__clkbuf_1
X_9416_ clknet_leaf_17_clk _0513_ VGND VGND VPWR VPWR registers\[6\]\[8\] sky130_fd_sc_hd__dfxtp_1
XFILLER_0_61_234 VGND VGND VPWR VPWR sky130_fd_sc_hd__fill_2
XANTENNA__6713__A1 _3003_ VGND VGND VPWR VPWR sky130_fd_sc_hd__diode_2
XFILLER_0_117_697 VPWR VGND VPWR VGND sky130_ef_sc_hd__decap_12
XANTENNA__5072__S0 _1762_ VGND VGND VPWR VPWR sky130_fd_sc_hd__diode_2
XPHY_EDGE_ROW_67_Right_67 VGND VGND VPWR VPWR sky130_fd_sc_hd__decap_3
X_9347_ clknet_leaf_22_clk _0444_ VGND VGND VPWR VPWR registers\[30\]\[3\] sky130_fd_sc_hd__dfxtp_1
XFILLER_0_15_673 VGND VGND VPWR VPWR sky130_fd_sc_hd__fill_2
XFILLER_0_104_347 VPWR VGND VPWR VGND sky130_ef_sc_hd__decap_12
X_6559_ registers\[7\]\[14\] _2991_ _3148_ VGND VGND VPWR VPWR _3153_ sky130_fd_sc_hd__mux2_1
XTAP_TAPCELL_ROW_76_1242 VGND VPWR sky130_fd_sc_hd__tapvpwrvgnd_1
XTAP_TAPCELL_ROW_76_1253 VGND VPWR sky130_fd_sc_hd__tapvpwrvgnd_1
XPHY_EDGE_ROW_5_Left_125 VGND VGND VPWR VPWR sky130_fd_sc_hd__decap_3
XFILLER_0_14_194 VGND VGND VPWR VPWR sky130_fd_sc_hd__fill_2
XANTENNA__8466__A1 net35 VGND VGND VPWR VPWR sky130_fd_sc_hd__diode_2
XFILLER_0_30_643 VGND VGND VPWR VPWR sky130_fd_sc_hd__fill_1
X_9278_ clknet_leaf_98_clk _0375_ VGND VGND VPWR VPWR registers\[27\]\[30\] sky130_fd_sc_hd__dfxtp_1
XFILLER_0_100_542 VGND VGND VPWR VPWR sky130_fd_sc_hd__fill_2
X_8229_ registers\[6\]\[11\] _3458_ _4056_ VGND VGND VPWR VPWR _4058_ sky130_fd_sc_hd__mux2_1
XFILLER_0_30_687 VGND VGND VPWR VPWR sky130_fd_sc_hd__fill_2
XFILLER_0_30_698 VGND VGND VPWR VPWR sky130_fd_sc_hd__fill_2
XANTENNA__8218__A1 _3447_ VGND VGND VPWR VPWR sky130_fd_sc_hd__diode_2
XPHY_EDGE_ROW_76_Right_76 VGND VGND VPWR VPWR sky130_fd_sc_hd__decap_3
XFILLER_0_97_621 VGND VGND VPWR VPWR sky130_fd_sc_hd__decap_4
XANTENNA__5669__A _2295_ VGND VGND VPWR VPWR sky130_fd_sc_hd__diode_2
XFILLER_0_97_654 VGND VGND VPWR VPWR sky130_fd_sc_hd__fill_1
XFILLER_0_97_632 VGND VGND VPWR VPWR sky130_fd_sc_hd__fill_2
XTAP_TAPCELL_ROW_2_282 VGND VPWR sky130_fd_sc_hd__tapvpwrvgnd_1
XTAP_TAPCELL_ROW_87_1393 VGND VPWR sky130_fd_sc_hd__tapvpwrvgnd_1
XANTENNA_clkbuf_leaf_52_clk_A clknet_4_13_0_clk VGND VGND VPWR VPWR sky130_fd_sc_hd__diode_2
XFILLER_0_96_175 VGND VGND VPWR VPWR sky130_fd_sc_hd__fill_1
XFILLER_0_38_710 VPWR VGND VPWR VGND sky130_ef_sc_hd__decap_12
XFILLER_0_65_540 VGND VGND VPWR VPWR sky130_fd_sc_hd__decap_3
XFILLER_0_80_510 VGND VGND VPWR VPWR sky130_fd_sc_hd__fill_2
XFILLER_0_65_573 VGND VGND VPWR VPWR sky130_fd_sc_hd__fill_2
XFILLER_0_52_201 VGND VGND VPWR VPWR sky130_fd_sc_hd__fill_2
XANTENNA__7901__A0 _3104_ VGND VGND VPWR VPWR sky130_fd_sc_hd__diode_2
XPHY_EDGE_ROW_85_Right_85 VGND VGND VPWR VPWR sky130_fd_sc_hd__decap_3
XANTENNA_clkbuf_leaf_67_clk_A clknet_4_14_0_clk VGND VGND VPWR VPWR sky130_fd_sc_hd__diode_2
XFILLER_0_4_309 VGND VGND VPWR VPWR sky130_fd_sc_hd__fill_2
XANTENNA__5063__S0 _1820_ VGND VGND VPWR VPWR sky130_fd_sc_hd__diode_2
XFILLER_0_12_109 VGND VGND VPWR VPWR sky130_fd_sc_hd__decap_8
XANTENNA__7823__S _3840_ VGND VGND VPWR VPWR sky130_fd_sc_hd__diode_2
XANTENNA_clkbuf_leaf_110_clk_A clknet_4_0_0_clk VGND VGND VPWR VPWR sky130_fd_sc_hd__diode_2
XANTENNA__4810__S0 _1550_ VGND VGND VPWR VPWR sky130_fd_sc_hd__diode_2
XFILLER_0_21_621 VGND VGND VPWR VPWR sky130_fd_sc_hd__fill_2
XANTENNA__6439__S _3069_ VGND VGND VPWR VPWR sky130_fd_sc_hd__diode_2
XFILLER_0_20_197 VGND VGND VPWR VPWR sky130_fd_sc_hd__fill_2
XPHY_EDGE_ROW_94_Right_94 VGND VGND VPWR VPWR sky130_fd_sc_hd__decap_3
XTAP_TAPCELL_ROW_49_900 VGND VPWR sky130_fd_sc_hd__tapvpwrvgnd_1
XANTENNA__5118__S1 _1764_ VGND VGND VPWR VPWR sky130_fd_sc_hd__diode_2
X_5930_ _2581_ _2652_ _2403_ VGND VGND VPWR VPWR _2653_ sky130_fd_sc_hd__mux2_1
XFILLER_0_88_621 VGND VGND VPWR VPWR sky130_fd_sc_hd__decap_3
XPHY_EDGE_ROW_69_Left_189 VGND VGND VPWR VPWR sky130_fd_sc_hd__decap_3
XANTENNA__5443__B2 _1771_ VGND VGND VPWR VPWR sky130_fd_sc_hd__diode_2
XANTENNA__4877__S0 _1642_ VGND VGND VPWR VPWR sky130_fd_sc_hd__diode_2
XANTENNA__7196__A1 _3447_ VGND VGND VPWR VPWR sky130_fd_sc_hd__diode_2
X_5861_ _2345_ _2587_ VGND VGND VPWR VPWR _2588_ sky130_fd_sc_hd__nor2_1
X_7600_ _3724_ VGND VGND VPWR VPWR _0220_ sky130_fd_sc_hd__clkbuf_1
XANTENNA__4629__S0 _1347_ VGND VGND VPWR VPWR sky130_fd_sc_hd__diode_2
XFILLER_0_113_30 VGND VGND VPWR VPWR sky130_fd_sc_hd__decap_8
X_8580_ clknet_leaf_30_clk _0701_ VGND VGND VPWR VPWR registers\[3\]\[4\] sky130_fd_sc_hd__dfxtp_1
X_5792_ _2479_ _2487_ VGND VGND VPWR VPWR _2522_ sky130_fd_sc_hd__and2_1
XANTENNA__6902__S _3335_ VGND VGND VPWR VPWR sky130_fd_sc_hd__diode_2
XFILLER_0_56_551 VGND VGND VPWR VPWR sky130_fd_sc_hd__decap_8
XFILLER_0_8_637 VGND VGND VPWR VPWR sky130_fd_sc_hd__fill_1
XFILLER_0_8_626 VGND VGND VPWR VPWR sky130_fd_sc_hd__decap_3
XFILLER_0_8_615 VGND VGND VPWR VPWR sky130_fd_sc_hd__fill_2
X_4812_ _1581_ _1582_ _1386_ VGND VGND VPWR VPWR _1583_ sky130_fd_sc_hd__mux2_1
XFILLER_0_28_220 VGND VGND VPWR VPWR sky130_fd_sc_hd__decap_3
XFILLER_0_90_329 VGND VGND VPWR VPWR sky130_fd_sc_hd__decap_4
X_7531_ _3075_ registers\[22\]\[3\] _3684_ VGND VGND VPWR VPWR _3688_ sky130_fd_sc_hd__mux2_1
XTAP_TAPCELL_ROW_60_1043 VGND VPWR sky130_fd_sc_hd__tapvpwrvgnd_1
X_4743_ _1517_ VGND VGND VPWR VPWR net130 sky130_fd_sc_hd__inv_2
XFILLER_0_28_253 VGND VGND VPWR VPWR sky130_fd_sc_hd__decap_3
XANTENNA__4422__S _1031_ VGND VGND VPWR VPWR sky130_fd_sc_hd__diode_2
XFILLER_0_7_169 VGND VGND VPWR VPWR sky130_fd_sc_hd__decap_6
XFILLER_0_16_459 VGND VGND VPWR VPWR sky130_fd_sc_hd__fill_1
XFILLER_0_22_83 VGND VGND VPWR VPWR sky130_fd_sc_hd__fill_1
X_7462_ _3651_ VGND VGND VPWR VPWR _0155_ sky130_fd_sc_hd__clkbuf_1
X_9201_ clknet_leaf_56_clk _0298_ VGND VGND VPWR VPWR registers\[25\]\[17\] sky130_fd_sc_hd__dfxtp_1
XFILLER_0_114_645 VPWR VGND VPWR VGND sky130_ef_sc_hd__decap_12
XPHY_EDGE_ROW_78_Left_198 VGND VGND VPWR VPWR sky130_fd_sc_hd__decap_3
XFILLER_0_71_587 VGND VGND VPWR VPWR sky130_fd_sc_hd__fill_2
XANTENNA__4706__B1 _1143_ VGND VGND VPWR VPWR sky130_fd_sc_hd__diode_2
X_4674_ _1389_ _1452_ _1143_ VGND VGND VPWR VPWR _1453_ sky130_fd_sc_hd__a21oi_1
X_6413_ registers\[3\]\[26\] _3016_ _3052_ VGND VGND VPWR VPWR _3059_ sky130_fd_sc_hd__mux2_1
XFILLER_0_113_155 VGND VGND VPWR VPWR sky130_fd_sc_hd__fill_2
X_7393_ registers\[20\]\[2\] _3439_ _3612_ VGND VGND VPWR VPWR _3615_ sky130_fd_sc_hd__mux2_1
X_9132_ clknet_leaf_43_clk _0229_ VGND VGND VPWR VPWR registers\[23\]\[12\] sky130_fd_sc_hd__dfxtp_1
XFILLER_0_3_386 VGND VGND VPWR VPWR sky130_fd_sc_hd__decap_3
X_6344_ net36 VGND VGND VPWR VPWR _3020_ sky130_fd_sc_hd__buf_2
XFILLER_0_12_665 VGND VGND VPWR VPWR sky130_fd_sc_hd__fill_2
XFILLER_0_24_492 VGND VGND VPWR VPWR sky130_fd_sc_hd__decap_3
XTAP_TAPCELL_ROW_112_1718 VGND VPWR sky130_fd_sc_hd__tapvpwrvgnd_1
XFILLER_0_113_199 VGND VGND VPWR VPWR sky130_fd_sc_hd__fill_1
X_6275_ _2973_ VGND VGND VPWR VPWR _0670_ sky130_fd_sc_hd__clkbuf_1
X_9063_ clknet_leaf_24_clk _0160_ VGND VGND VPWR VPWR registers\[21\]\[7\] sky130_fd_sc_hd__dfxtp_1
XFILLER_0_12_698 VGND VGND VPWR VPWR sky130_fd_sc_hd__fill_2
XANTENNA__4658__A _1143_ VGND VGND VPWR VPWR sky130_fd_sc_hd__diode_2
X_8014_ registers\[2\]\[6\] _3447_ _3937_ VGND VGND VPWR VPWR _3944_ sky130_fd_sc_hd__mux2_1
X_5226_ _1974_ _1975_ _1768_ VGND VGND VPWR VPWR _1976_ sky130_fd_sc_hd__mux2_1
XFILLER_0_51_3 VGND VGND VPWR VPWR sky130_fd_sc_hd__decap_4
XANTENNA__5682__A1 _2267_ VGND VGND VPWR VPWR sky130_fd_sc_hd__diode_2
X_5157_ _1689_ _1910_ _1655_ VGND VGND VPWR VPWR _1911_ sky130_fd_sc_hd__o21a_1
XTAP_TAPCELL_ROW_71_1183 VGND VPWR sky130_fd_sc_hd__tapvpwrvgnd_1
XFILLER_0_98_418 VGND VGND VPWR VPWR sky130_fd_sc_hd__fill_2
X_5088_ _1756_ _1845_ VGND VGND VPWR VPWR _1846_ sky130_fd_sc_hd__nand2_1
X_8916_ clknet_leaf_74_clk _0013_ VGND VGND VPWR VPWR registers\[16\]\[20\] sky130_fd_sc_hd__dfxtp_1
XTAP_TAPCELL_ROW_27_605 VGND VPWR sky130_fd_sc_hd__tapvpwrvgnd_1
XTAP_TAPCELL_ROW_27_616 VGND VPWR sky130_fd_sc_hd__tapvpwrvgnd_1
XFILLER_0_78_153 VGND VGND VPWR VPWR sky130_fd_sc_hd__fill_1
XTAP_TAPCELL_ROW_55_969 VGND VPWR sky130_fd_sc_hd__tapvpwrvgnd_1
XFILLER_0_94_635 VGND VGND VPWR VPWR sky130_fd_sc_hd__fill_2
X_8847_ clknet_leaf_45_clk _0968_ VGND VGND VPWR VPWR registers\[14\]\[15\] sky130_fd_sc_hd__dfxtp_1
XANTENNA__7908__S _3887_ VGND VGND VPWR VPWR sky130_fd_sc_hd__diode_2
X_8778_ clknet_leaf_39_clk _0899_ VGND VGND VPWR VPWR registers\[12\]\[10\] sky130_fd_sc_hd__dfxtp_1
XFILLER_0_93_156 VGND VGND VPWR VPWR sky130_fd_sc_hd__fill_2
XFILLER_0_93_134 VGND VGND VPWR VPWR sky130_fd_sc_hd__fill_2
XFILLER_0_19_242 VGND VGND VPWR VPWR sky130_fd_sc_hd__fill_2
XANTENNA__5936__B _1302_ VGND VGND VPWR VPWR sky130_fd_sc_hd__diode_2
X_7729_ _3792_ VGND VGND VPWR VPWR _3793_ sky130_fd_sc_hd__clkbuf_8
XANTENNA__5293__S0 _1689_ VGND VGND VPWR VPWR sky130_fd_sc_hd__diode_2
XFILLER_0_7_670 VGND VGND VPWR VPWR sky130_fd_sc_hd__fill_2
XFILLER_0_105_645 VGND VGND VPWR VPWR sky130_fd_sc_hd__decap_6
XFILLER_0_105_612 VGND VGND VPWR VPWR sky130_fd_sc_hd__fill_2
XFILLER_0_104_111 VGND VGND VPWR VPWR sky130_fd_sc_hd__fill_1
XFILLER_0_7_692 VGND VGND VPWR VPWR sky130_fd_sc_hd__decap_3
XFILLER_0_7_681 VGND VGND VPWR VPWR sky130_fd_sc_hd__fill_1
XANTENNA__7643__S _3742_ VGND VGND VPWR VPWR sky130_fd_sc_hd__diode_2
XANTENNA__8439__A1 net21 VGND VGND VPWR VPWR sky130_fd_sc_hd__diode_2
XANTENNA__7111__A1 _3453_ VGND VGND VPWR VPWR sky130_fd_sc_hd__diode_2
XANTENNA__6259__S _2962_ VGND VGND VPWR VPWR sky130_fd_sc_hd__diode_2
XFILLER_0_30_473 VGND VGND VPWR VPWR sky130_fd_sc_hd__fill_1
XANTENNA__5163__S _1752_ VGND VGND VPWR VPWR sky130_fd_sc_hd__diode_2
XFILLER_0_30_484 VGND VGND VPWR VPWR sky130_fd_sc_hd__fill_2
XTAP_TAPCELL_ROW_7_352 VGND VPWR sky130_fd_sc_hd__tapvpwrvgnd_1
XTAP_TAPCELL_ROW_89_1422 VGND VPWR sky130_fd_sc_hd__tapvpwrvgnd_1
XTAP_TAPCELL_ROW_89_1411 VGND VPWR sky130_fd_sc_hd__tapvpwrvgnd_1
XANTENNA_input35_A wd3[27] VGND VGND VPWR VPWR sky130_fd_sc_hd__diode_2
XFILLER_0_84_101 VGND VGND VPWR VPWR sky130_fd_sc_hd__fill_1
XFILLER_0_85_646 VGND VGND VPWR VPWR sky130_fd_sc_hd__decap_4
XFILLER_0_84_134 VGND VGND VPWR VPWR sky130_fd_sc_hd__decap_4
XFILLER_0_57_359 VGND VGND VPWR VPWR sky130_fd_sc_hd__fill_2
XFILLER_0_57_337 VGND VGND VPWR VPWR sky130_fd_sc_hd__decap_4
Xclkbuf_leaf_104_clk clknet_4_2_0_clk VGND VGND VPWR VPWR clknet_leaf_104_clk sky130_fd_sc_hd__clkbuf_8
XANTENNA__5338__S _2081_ VGND VGND VPWR VPWR sky130_fd_sc_hd__diode_2
XFILLER_0_108_494 VGND VGND VPWR VPWR sky130_fd_sc_hd__fill_1
XANTENNA__6023__A _1979_ VGND VGND VPWR VPWR sky130_fd_sc_hd__diode_2
XFILLER_0_53_576 VGND VGND VPWR VPWR sky130_fd_sc_hd__decap_3
XFILLER_0_25_267 VGND VGND VPWR VPWR sky130_fd_sc_hd__decap_3
XFILLER_0_111_626 VGND VGND VPWR VPWR sky130_fd_sc_hd__fill_2
X_4390_ _1073_ _1175_ _1179_ _1183_ VGND VGND VPWR VPWR _1184_ sky130_fd_sc_hd__a2bb2o_4
XFILLER_0_68_35 VGND VGND VPWR VPWR sky130_fd_sc_hd__fill_2
XFILLER_0_21_440 VGND VGND VPWR VPWR sky130_fd_sc_hd__fill_2
XFILLER_0_110_125 VGND VGND VPWR VPWR sky130_fd_sc_hd__fill_2
XANTENNA__7102__A1 _3447_ VGND VGND VPWR VPWR sky130_fd_sc_hd__diode_2
XFILLER_0_68_79 VGND VGND VPWR VPWR sky130_fd_sc_hd__fill_2
X_6060_ _2744_ _2773_ _2774_ _2775_ VGND VGND VPWR VPWR _2776_ sky130_fd_sc_hd__o211a_1
X_5011_ _1690_ VGND VGND VPWR VPWR _1773_ sky130_fd_sc_hd__clkbuf_8
XANTENNA__8384__S _4139_ VGND VGND VPWR VPWR sky130_fd_sc_hd__diode_2
XFILLER_0_108_85 VGND VGND VPWR VPWR sky130_fd_sc_hd__fill_1
XFILLER_0_23_7 VGND VGND VPWR VPWR sky130_fd_sc_hd__fill_1
XTAP_TAPCELL_ROW_109_1680 VGND VPWR sky130_fd_sc_hd__tapvpwrvgnd_1
X_6962_ _3085_ registers\[14\]\[8\] _3361_ VGND VGND VPWR VPWR _3370_ sky130_fd_sc_hd__mux2_1
X_5913_ _2563_ _2636_ _2403_ VGND VGND VPWR VPWR _2637_ sky130_fd_sc_hd__mux2_1
X_6893_ _3085_ registers\[13\]\[8\] _3324_ VGND VGND VPWR VPWR _3333_ sky130_fd_sc_hd__mux2_1
XFILLER_0_75_101 VGND VGND VPWR VPWR sky130_fd_sc_hd__decap_4
X_8701_ clknet_leaf_105_clk _0822_ VGND VGND VPWR VPWR registers\[0\]\[29\] sky130_fd_sc_hd__dfxtp_1
X_5844_ _2276_ _2568_ _2571_ VGND VGND VPWR VPWR _2572_ sky130_fd_sc_hd__and3_1
XFILLER_0_75_123 VGND VGND VPWR VPWR sky130_fd_sc_hd__fill_1
XTAP_TAPCELL_ROW_52_939 VGND VPWR sky130_fd_sc_hd__tapvpwrvgnd_1
XFILLER_0_48_337 VGND VGND VPWR VPWR sky130_fd_sc_hd__fill_2
XANTENNA__4941__A _1642_ VGND VGND VPWR VPWR sky130_fd_sc_hd__diode_2
X_8632_ clknet_leaf_86_clk _0753_ VGND VGND VPWR VPWR registers\[29\]\[24\] sky130_fd_sc_hd__dfxtp_1
X_8563_ clknet_leaf_14_clk _0684_ VGND VGND VPWR VPWR registers\[19\]\[19\] sky130_fd_sc_hd__dfxtp_1
XANTENNA__5275__S0 _2020_ VGND VGND VPWR VPWR sky130_fd_sc_hd__diode_2
X_5775_ _2200_ _2504_ VGND VGND VPWR VPWR _2505_ sky130_fd_sc_hd__or2_1
XFILLER_0_90_115 VGND VGND VPWR VPWR sky130_fd_sc_hd__decap_3
XPHY_EDGE_ROW_86_Left_206 VGND VGND VPWR VPWR sky130_fd_sc_hd__decap_3
X_7514_ _3678_ VGND VGND VPWR VPWR _0180_ sky130_fd_sc_hd__clkbuf_1
XTAP_TAPCELL_ROW_32_674 VGND VPWR sky130_fd_sc_hd__tapvpwrvgnd_1
XANTENNA__5027__S0 _1678_ VGND VGND VPWR VPWR sky130_fd_sc_hd__diode_2
X_8494_ registers\[4\]\[8\] net46 _4189_ VGND VGND VPWR VPWR _4198_ sky130_fd_sc_hd__mux2_1
XFILLER_0_44_565 VGND VGND VPWR VPWR sky130_fd_sc_hd__decap_3
X_4726_ registers\[20\]\[25\] registers\[21\]\[25\] registers\[22\]\[25\] registers\[23\]\[25\]
+ _1415_ _1416_ VGND VGND VPWR VPWR _1501_ sky130_fd_sc_hd__mux4_1
XANTENNA__7341__A1 _3455_ VGND VGND VPWR VPWR sky130_fd_sc_hd__diode_2
XANTENNA__6144__A2 _2587_ VGND VGND VPWR VPWR sky130_fd_sc_hd__diode_2
XANTENNA__7463__S _3648_ VGND VGND VPWR VPWR sky130_fd_sc_hd__diode_2
X_7445_ registers\[20\]\[27\] _3491_ _3634_ VGND VGND VPWR VPWR _3642_ sky130_fd_sc_hd__mux2_1
X_4657_ _1435_ _1436_ _1346_ VGND VGND VPWR VPWR _1437_ sky130_fd_sc_hd__mux2_1
XFILLER_0_32_727 VGND VGND VPWR VPWR sky130_fd_sc_hd__decap_3
XFILLER_0_4_695 VGND VGND VPWR VPWR sky130_fd_sc_hd__fill_2
X_7376_ registers\[1\]\[27\] _3491_ _3597_ VGND VGND VPWR VPWR _3605_ sky130_fd_sc_hd__mux2_1
XFILLER_0_101_147 VGND VGND VPWR VPWR sky130_fd_sc_hd__fill_2
X_4588_ _1073_ _1361_ _1366_ _1370_ VGND VGND VPWR VPWR _1371_ sky130_fd_sc_hd__o22a_1
XTAP_TAPCELL_ROW_73_1212 VGND VPWR sky130_fd_sc_hd__tapvpwrvgnd_1
X_6327_ registers\[19\]\[22\] _3008_ _3004_ VGND VGND VPWR VPWR _3009_ sky130_fd_sc_hd__mux2_1
X_9115_ clknet_leaf_102_clk _0212_ VGND VGND VPWR VPWR registers\[22\]\[27\] sky130_fd_sc_hd__dfxtp_1
XFILLER_0_101_169 VGND VGND VPWR VPWR sky130_fd_sc_hd__fill_2
X_6258_ _2961_ VGND VGND VPWR VPWR _2962_ sky130_fd_sc_hd__clkbuf_8
X_9046_ clknet_leaf_94_clk _0143_ VGND VGND VPWR VPWR registers\[20\]\[22\] sky130_fd_sc_hd__dfxtp_1
XPHY_EDGE_ROW_95_Left_215 VGND VGND VPWR VPWR sky130_fd_sc_hd__decap_3
X_6189_ _2862_ _2896_ _2353_ VGND VGND VPWR VPWR _2897_ sky130_fd_sc_hd__mux2_1
X_5209_ _1959_ VGND VGND VPWR VPWR net89 sky130_fd_sc_hd__inv_2
XTAP_TAPCELL_ROW_4_311 VGND VPWR sky130_fd_sc_hd__tapvpwrvgnd_1
XFILLER_0_98_248 VGND VGND VPWR VPWR sky130_fd_sc_hd__fill_2
XANTENNA__5012__A _1691_ VGND VGND VPWR VPWR sky130_fd_sc_hd__diode_2
XANTENNA__4327__S _1122_ VGND VGND VPWR VPWR sky130_fd_sc_hd__diode_2
XANTENNA__5958__A2 _2587_ VGND VGND VPWR VPWR sky130_fd_sc_hd__diode_2
XFILLER_0_79_440 VGND VGND VPWR VPWR sky130_fd_sc_hd__fill_1
XFILLER_0_94_421 VGND VGND VPWR VPWR sky130_fd_sc_hd__fill_2
XTAP_TAPCELL_ROW_84_1352 VGND VPWR sky130_fd_sc_hd__tapvpwrvgnd_1
XFILLER_0_66_101 VGND VGND VPWR VPWR sky130_fd_sc_hd__decap_8
XFILLER_0_39_315 VGND VGND VPWR VPWR sky130_fd_sc_hd__decap_3
XANTENNA__6542__S _3137_ VGND VGND VPWR VPWR sky130_fd_sc_hd__diode_2
XFILLER_0_67_657 VGND VGND VPWR VPWR sky130_fd_sc_hd__fill_2
XFILLER_0_67_646 VGND VGND VPWR VPWR sky130_fd_sc_hd__decap_3
XFILLER_0_39_337 VGND VGND VPWR VPWR sky130_fd_sc_hd__decap_4
XFILLER_0_109_225 VGND VGND VPWR VPWR sky130_fd_sc_hd__fill_2
XANTENNA__5266__S0 _1968_ VGND VGND VPWR VPWR sky130_fd_sc_hd__diode_2
XFILLER_0_109_258 VGND VGND VPWR VPWR sky130_fd_sc_hd__decap_3
XFILLER_0_35_521 VGND VGND VPWR VPWR sky130_fd_sc_hd__fill_2
XFILLER_0_90_660 VGND VGND VPWR VPWR sky130_fd_sc_hd__fill_2
XANTENNA__7332__A1 _3447_ VGND VGND VPWR VPWR sky130_fd_sc_hd__diode_2
XFILLER_0_105_431 VGND VGND VPWR VPWR sky130_fd_sc_hd__fill_1
XFILLER_0_22_237 VGND VGND VPWR VPWR sky130_fd_sc_hd__decap_4
XFILLER_0_105_497 VGND VGND VPWR VPWR sky130_fd_sc_hd__fill_2
XFILLER_0_50_579 VGND VGND VPWR VPWR sky130_fd_sc_hd__fill_2
XANTENNA__4241__S1 _1040_ VGND VGND VPWR VPWR sky130_fd_sc_hd__diode_2
XTAP_TAPCELL_ROW_95_1492 VGND VPWR sky130_fd_sc_hd__tapvpwrvgnd_1
XFILLER_0_100_180 VGND VGND VPWR VPWR sky130_fd_sc_hd__fill_2
XANTENNA__6717__S _3236_ VGND VGND VPWR VPWR sky130_fd_sc_hd__diode_2
XANTENNA__7399__A1 _3445_ VGND VGND VPWR VPWR sky130_fd_sc_hd__diode_2
XANTENNA_clkload0_A clknet_4_1_0_clk VGND VGND VPWR VPWR sky130_fd_sc_hd__diode_2
XANTENNA__4237__S _1031_ VGND VGND VPWR VPWR sky130_fd_sc_hd__diode_2
XFILLER_0_58_635 VGND VGND VPWR VPWR sky130_fd_sc_hd__fill_2
XANTENNA__7548__S _3695_ VGND VGND VPWR VPWR sky130_fd_sc_hd__diode_2
XFILLER_0_58_668 VGND VGND VPWR VPWR sky130_fd_sc_hd__fill_2
XFILLER_0_85_465 VGND VGND VPWR VPWR sky130_fd_sc_hd__decap_3
XANTENNA__5257__S0 _1968_ VGND VGND VPWR VPWR sky130_fd_sc_hd__diode_2
XANTENNA__5582__B1 _2317_ VGND VGND VPWR VPWR sky130_fd_sc_hd__diode_2
X_5560_ _2286_ _2294_ _2295_ VGND VGND VPWR VPWR _2296_ sky130_fd_sc_hd__mux2_1
X_4511_ registers\[4\]\[13\] registers\[5\]\[13\] registers\[6\]\[13\] registers\[7\]\[13\]
+ _1198_ _1199_ VGND VGND VPWR VPWR _1298_ sky130_fd_sc_hd__mux4_1
X_5491_ _2034_ _2215_ VGND VGND VPWR VPWR _2227_ sky130_fd_sc_hd__or2_1
XFILLER_0_81_682 VGND VGND VPWR VPWR sky130_fd_sc_hd__decap_6
XANTENNA__8379__S _4128_ VGND VGND VPWR VPWR sky130_fd_sc_hd__diode_2
XFILLER_0_53_373 VGND VGND VPWR VPWR sky130_fd_sc_hd__fill_2
XFILLER_0_111_412 VGND VGND VPWR VPWR sky130_fd_sc_hd__fill_2
X_4442_ registers\[12\]\[9\] registers\[13\]\[9\] registers\[14\]\[9\] registers\[15\]\[9\]
+ _1196_ _1202_ VGND VGND VPWR VPWR _1233_ sky130_fd_sc_hd__mux4_1
XANTENNA__7283__S _3550_ VGND VGND VPWR VPWR sky130_fd_sc_hd__diode_2
X_7230_ registers\[17\]\[22\] _3481_ _3525_ VGND VGND VPWR VPWR _3528_ sky130_fd_sc_hd__mux2_1
XFILLER_0_41_535 VGND VGND VPWR VPWR sky130_fd_sc_hd__fill_2
XFILLER_0_110_97 VGND VGND VPWR VPWR sky130_fd_sc_hd__decap_3
X_4373_ _1110_ VGND VGND VPWR VPWR _1167_ sky130_fd_sc_hd__buf_4
X_7161_ registers\[16\]\[25\] _3487_ _3477_ VGND VGND VPWR VPWR _3488_ sky130_fd_sc_hd__mux2_1
XFILLER_0_21_281 VGND VGND VPWR VPWR sky130_fd_sc_hd__decap_3
XFILLER_0_95_55 VGND VGND VPWR VPWR sky130_fd_sc_hd__fill_1
X_6112_ _2812_ _2814_ _2824_ _2422_ VGND VGND VPWR VPWR net64 sky130_fd_sc_hd__o22a_1
X_7092_ net41 VGND VGND VPWR VPWR _3441_ sky130_fd_sc_hd__buf_2
XFILLER_0_0_197 VGND VGND VPWR VPWR sky130_fd_sc_hd__fill_1
XFILLER_0_0_164 VGND VGND VPWR VPWR sky130_fd_sc_hd__fill_2
XANTENNA__6627__S _3186_ VGND VGND VPWR VPWR sky130_fd_sc_hd__diode_2
X_6043_ _2618_ _2692_ _2759_ _2498_ VGND VGND VPWR VPWR _2760_ sky130_fd_sc_hd__o2bb2a_1
XFILLER_0_96_708 VGND VGND VPWR VPWR sky130_fd_sc_hd__decap_6
X_7994_ _3022_ registers\[28\]\[29\] _3923_ VGND VGND VPWR VPWR _3933_ sky130_fd_sc_hd__mux2_1
X_6945_ _3360_ VGND VGND VPWR VPWR _3361_ sky130_fd_sc_hd__clkbuf_8
XTAP_TAPCELL_ROW_37_744 VGND VPWR sky130_fd_sc_hd__tapvpwrvgnd_1
XFILLER_0_119_545 VGND VGND VPWR VPWR sky130_fd_sc_hd__fill_2
XFILLER_0_64_627 VGND VGND VPWR VPWR sky130_fd_sc_hd__fill_2
XFILLER_0_48_178 VGND VGND VPWR VPWR sky130_fd_sc_hd__decap_4
X_6876_ _3323_ VGND VGND VPWR VPWR _3324_ sky130_fd_sc_hd__buf_4
XFILLER_0_119_556 VGND VGND VPWR VPWR sky130_fd_sc_hd__fill_2
XFILLER_0_107_729 VGND VGND VPWR VPWR sky130_fd_sc_hd__fill_1
XFILLER_0_107_718 VGND VGND VPWR VPWR sky130_fd_sc_hd__fill_2
X_8615_ clknet_leaf_23_clk _0736_ VGND VGND VPWR VPWR registers\[29\]\[7\] sky130_fd_sc_hd__dfxtp_1
X_5827_ _2554_ _2529_ _2530_ VGND VGND VPWR VPWR _2555_ sky130_fd_sc_hd__a21o_1
XFILLER_0_57_690 VPWR VGND VPWR VGND sky130_ef_sc_hd__decap_12
XFILLER_0_8_253 VGND VGND VPWR VPWR sky130_fd_sc_hd__decap_8
XFILLER_0_17_532 VGND VGND VPWR VPWR sky130_fd_sc_hd__decap_8
XFILLER_0_119_589 VGND VGND VPWR VPWR sky130_fd_sc_hd__fill_2
X_5758_ _2487_ _2488_ VGND VGND VPWR VPWR _2489_ sky130_fd_sc_hd__xnor2_1
XFILLER_0_63_159 VGND VGND VPWR VPWR sky130_fd_sc_hd__fill_2
XFILLER_0_63_148 VGND VGND VPWR VPWR sky130_fd_sc_hd__decap_4
XFILLER_0_8_275 VGND VGND VPWR VPWR sky130_fd_sc_hd__fill_2
XFILLER_0_17_543 VGND VGND VPWR VPWR sky130_fd_sc_hd__fill_1
X_8546_ clknet_leaf_1_clk _0667_ VGND VGND VPWR VPWR registers\[19\]\[2\] sky130_fd_sc_hd__dfxtp_1
XFILLER_0_72_671 VGND VGND VPWR VPWR sky130_fd_sc_hd__fill_2
X_8477_ _4188_ VGND VGND VPWR VPWR _4189_ sky130_fd_sc_hd__clkbuf_8
X_4709_ registers\[24\]\[24\] registers\[25\]\[24\] registers\[26\]\[24\] registers\[27\]\[24\]
+ _1418_ _1419_ VGND VGND VPWR VPWR _1485_ sky130_fd_sc_hd__mux4_1
XFILLER_0_32_524 VGND VGND VPWR VPWR sky130_fd_sc_hd__fill_2
X_5689_ _1049_ _1070_ _2394_ VGND VGND VPWR VPWR _2423_ sky130_fd_sc_hd__a21oi_1
X_7428_ registers\[20\]\[19\] _3474_ _3623_ VGND VGND VPWR VPWR _3633_ sky130_fd_sc_hd__mux2_1
XFILLER_0_4_470 VGND VGND VPWR VPWR sky130_fd_sc_hd__decap_3
XFILLER_0_8_81 VGND VGND VPWR VPWR sky130_fd_sc_hd__decap_3
X_7359_ registers\[1\]\[19\] _3474_ _3586_ VGND VGND VPWR VPWR _3596_ sky130_fd_sc_hd__mux2_1
X_9029_ clknet_leaf_26_clk _0126_ VGND VGND VPWR VPWR registers\[20\]\[5\] sky130_fd_sc_hd__dfxtp_1
XFILLER_0_99_513 VGND VGND VPWR VPWR sky130_fd_sc_hd__decap_3
XFILLER_0_39_101 VGND VGND VPWR VPWR sky130_fd_sc_hd__decap_4
XFILLER_0_24_18 VGND VGND VPWR VPWR sky130_fd_sc_hd__fill_1
XFILLER_0_24_29 VGND VGND VPWR VPWR sky130_fd_sc_hd__fill_2
XFILLER_0_79_281 VGND VGND VPWR VPWR sky130_fd_sc_hd__fill_2
XANTENNA__7368__S _3597_ VGND VGND VPWR VPWR sky130_fd_sc_hd__diode_2
XFILLER_0_94_251 VGND VGND VPWR VPWR sky130_fd_sc_hd__fill_1
XFILLER_0_39_167 VGND VGND VPWR VPWR sky130_fd_sc_hd__fill_1
XTAP_TAPCELL_ROW_15_449 VGND VPWR sky130_fd_sc_hd__tapvpwrvgnd_1
XANTENNA__6666__C_N net12 VGND VGND VPWR VPWR sky130_fd_sc_hd__diode_2
XFILLER_0_40_39 VGND VGND VPWR VPWR sky130_fd_sc_hd__fill_2
XTAP_TAPCELL_ROW_97_1521 VGND VPWR sky130_fd_sc_hd__tapvpwrvgnd_1
XFILLER_0_63_660 VGND VGND VPWR VPWR sky130_fd_sc_hd__fill_1
XFILLER_0_23_513 VGND VGND VPWR VPWR sky130_fd_sc_hd__fill_2
XFILLER_0_35_362 VGND VGND VPWR VPWR sky130_fd_sc_hd__decap_3
XFILLER_0_62_192 VGND VGND VPWR VPWR sky130_fd_sc_hd__fill_2
XFILLER_0_50_332 VGND VGND VPWR VPWR sky130_fd_sc_hd__fill_1
XANTENNA__6301__A net21 VGND VGND VPWR VPWR sky130_fd_sc_hd__diode_2
XFILLER_0_50_365 VGND VGND VPWR VPWR sky130_fd_sc_hd__fill_2
XANTENNA__7831__S _3840_ VGND VGND VPWR VPWR sky130_fd_sc_hd__diode_2
XANTENNA__7069__A0 _3123_ VGND VGND VPWR VPWR sky130_fd_sc_hd__diode_2
XFILLER_0_31_590 VGND VGND VPWR VPWR sky130_fd_sc_hd__fill_2
XFILLER_0_4_39 VGND VGND VPWR VPWR sky130_fd_sc_hd__fill_1
XANTENNA__7132__A net23 VGND VGND VPWR VPWR sky130_fd_sc_hd__diode_2
XANTENNA__5351__S _2031_ VGND VGND VPWR VPWR sky130_fd_sc_hd__diode_2
XANTENNA__6044__A1 _2362_ VGND VGND VPWR VPWR sky130_fd_sc_hd__diode_2
XFILLER_0_81_35 VGND VGND VPWR VPWR sky130_fd_sc_hd__fill_2
XFILLER_0_77_229 VGND VGND VPWR VPWR sky130_fd_sc_hd__decap_4
XANTENNA__5587__A _1145_ VGND VGND VPWR VPWR sky130_fd_sc_hd__diode_2
X_4991_ _1750_ _1751_ _1752_ VGND VGND VPWR VPWR _1753_ sky130_fd_sc_hd__mux2_1
XANTENNA__4491__A _1148_ VGND VGND VPWR VPWR sky130_fd_sc_hd__diode_2
XFILLER_0_58_421 VGND VGND VPWR VPWR sky130_fd_sc_hd__fill_2
X_6730_ _3245_ VGND VGND VPWR VPWR _0853_ sky130_fd_sc_hd__clkbuf_1
XTAP_TAPCELL_ROW_34_703 VGND VPWR sky130_fd_sc_hd__tapvpwrvgnd_1
XFILLER_0_73_435 VPWR VGND VPWR VGND sky130_ef_sc_hd__decap_12
XFILLER_0_46_649 VGND VGND VPWR VPWR sky130_fd_sc_hd__fill_2
XFILLER_0_39_690 VGND VGND VPWR VPWR sky130_fd_sc_hd__decap_8
X_6661_ _3207_ VGND VGND VPWR VPWR _0822_ sky130_fd_sc_hd__clkbuf_1
X_9380_ clknet_leaf_30_clk _0477_ VGND VGND VPWR VPWR registers\[9\]\[4\] sky130_fd_sc_hd__dfxtp_1
X_5612_ _2253_ _2300_ VGND VGND VPWR VPWR _2347_ sky130_fd_sc_hd__nand2_1
XFILLER_0_73_479 VGND VGND VPWR VPWR sky130_fd_sc_hd__fill_1
XFILLER_0_73_457 VGND VGND VPWR VPWR sky130_fd_sc_hd__decap_6
XANTENNA__6910__S _3335_ VGND VGND VPWR VPWR sky130_fd_sc_hd__diode_2
X_6592_ registers\[7\]\[30\] _3024_ _3136_ VGND VGND VPWR VPWR _3170_ sky130_fd_sc_hd__mux2_1
XFILLER_0_6_713 VPWR VGND VPWR VGND sky130_ef_sc_hd__decap_12
X_8400_ registers\[5\]\[28\] _3493_ _4139_ VGND VGND VPWR VPWR _4148_ sky130_fd_sc_hd__mux2_1
XANTENNA__4453__S1 _1112_ VGND VGND VPWR VPWR sky130_fd_sc_hd__diode_2
X_5543_ _1108_ VGND VGND VPWR VPWR _2279_ sky130_fd_sc_hd__clkbuf_4
XFILLER_0_90_7 VGND VGND VPWR VPWR sky130_fd_sc_hd__fill_2
XFILLER_0_5_245 VGND VGND VPWR VPWR sky130_fd_sc_hd__decap_6
XFILLER_0_5_223 VGND VGND VPWR VPWR sky130_fd_sc_hd__fill_1
X_8331_ _4111_ VGND VGND VPWR VPWR _0564_ sky130_fd_sc_hd__clkbuf_1
XFILLER_0_81_490 VGND VGND VPWR VPWR sky130_fd_sc_hd__fill_1
XANTENNA__4430__S _1131_ VGND VGND VPWR VPWR sky130_fd_sc_hd__diode_2
XFILLER_0_41_343 VGND VGND VPWR VPWR sky130_fd_sc_hd__fill_1
XFILLER_0_112_732 VGND VGND VPWR VPWR sky130_fd_sc_hd__fill_1
XTAP_TAPCELL_ROW_57_1004 VGND VPWR sky130_fd_sc_hd__tapvpwrvgnd_1
XANTENNA__6211__A _2168_ VGND VGND VPWR VPWR sky130_fd_sc_hd__diode_2
X_5474_ _1569_ _1585_ VGND VGND VPWR VPWR _2210_ sky130_fd_sc_hd__nand2_1
X_8262_ registers\[6\]\[27\] _3491_ _4067_ VGND VGND VPWR VPWR _4075_ sky130_fd_sc_hd__mux2_1
X_7213_ registers\[17\]\[14\] _3464_ _3514_ VGND VGND VPWR VPWR _3519_ sky130_fd_sc_hd__mux2_1
X_4425_ _1116_ _1216_ VGND VGND VPWR VPWR _1217_ sky130_fd_sc_hd__or2_1
X_8193_ _4038_ VGND VGND VPWR VPWR _0499_ sky130_fd_sc_hd__clkbuf_1
XFILLER_0_111_275 VGND VGND VPWR VPWR sky130_fd_sc_hd__fill_2
X_4356_ registers\[24\]\[5\] registers\[25\]\[5\] registers\[26\]\[5\] registers\[27\]\[5\]
+ _1111_ _1113_ VGND VGND VPWR VPWR _1151_ sky130_fd_sc_hd__mux4_1
X_7144_ net28 VGND VGND VPWR VPWR _3476_ sky130_fd_sc_hd__buf_2
XANTENNA__7480__A0 _3092_ VGND VGND VPWR VPWR sky130_fd_sc_hd__diode_2
XANTENNA__6283__A1 _2978_ VGND VGND VPWR VPWR sky130_fd_sc_hd__diode_2
X_4287_ registers\[8\]\[2\] registers\[9\]\[2\] registers\[10\]\[2\] registers\[11\]\[2\]
+ _1026_ _1027_ VGND VGND VPWR VPWR _1085_ sky130_fd_sc_hd__mux4_1
X_7075_ _3129_ registers\[15\]\[29\] _3420_ VGND VGND VPWR VPWR _3430_ sky130_fd_sc_hd__mux2_1
XANTENNA__5261__S _1856_ VGND VGND VPWR VPWR sky130_fd_sc_hd__diode_2
X_6026_ _1959_ _2716_ _2743_ VGND VGND VPWR VPWR _2744_ sky130_fd_sc_hd__a21o_1
XFILLER_0_69_708 VGND VGND VPWR VPWR sky130_fd_sc_hd__fill_2
XTAP_TAPCELL_ROW_68_1144 VGND VPWR sky130_fd_sc_hd__tapvpwrvgnd_1
XFILLER_0_68_218 VGND VGND VPWR VPWR sky130_fd_sc_hd__fill_2
Xclkbuf_leaf_93_clk clknet_4_9_0_clk VGND VGND VPWR VPWR clknet_leaf_93_clk sky130_fd_sc_hd__clkbuf_8
XFILLER_0_96_549 VGND VGND VPWR VPWR sky130_fd_sc_hd__fill_2
XANTENNA__7188__S _3503_ VGND VGND VPWR VPWR sky130_fd_sc_hd__diode_2
X_7977_ _3924_ VGND VGND VPWR VPWR _0397_ sky130_fd_sc_hd__clkbuf_1
XTAP_TAPCELL_ROW_81_1311 VGND VPWR sky130_fd_sc_hd__tapvpwrvgnd_1
XANTENNA__4605__S _1386_ VGND VGND VPWR VPWR sky130_fd_sc_hd__diode_2
X_6928_ _3351_ VGND VGND VPWR VPWR _0945_ sky130_fd_sc_hd__clkbuf_1
XFILLER_0_64_435 VGND VGND VPWR VPWR sky130_fd_sc_hd__fill_2
XFILLER_0_49_498 VGND VGND VPWR VPWR sky130_fd_sc_hd__decap_4
XANTENNA__4692__S1 _1321_ VGND VGND VPWR VPWR sky130_fd_sc_hd__diode_2
X_6859_ registers\[12\]\[24\] _3012_ _3310_ VGND VGND VPWR VPWR _3315_ sky130_fd_sc_hd__mux2_1
XANTENNA__7916__S _3887_ VGND VGND VPWR VPWR sky130_fd_sc_hd__diode_2
XFILLER_0_9_584 VGND VGND VPWR VPWR sky130_fd_sc_hd__fill_2
XTAP_TAPCELL_ROW_12_419 VGND VPWR sky130_fd_sc_hd__tapvpwrvgnd_1
XFILLER_0_115_570 VGND VGND VPWR VPWR sky130_fd_sc_hd__fill_2
X_8529_ _4216_ VGND VGND VPWR VPWR _0657_ sky130_fd_sc_hd__clkbuf_1
XFILLER_0_17_384 VGND VGND VPWR VPWR sky130_fd_sc_hd__decap_8
XTAP_TAPCELL_ROW_79_1284 VGND VPWR sky130_fd_sc_hd__tapvpwrvgnd_1
XFILLER_0_60_685 VGND VGND VPWR VPWR sky130_fd_sc_hd__fill_2
XFILLER_0_32_365 VGND VGND VPWR VPWR sky130_fd_sc_hd__decap_4
XFILLER_0_102_253 VGND VGND VPWR VPWR sky130_fd_sc_hd__fill_1
XTAP_TAPCELL_ROW_92_1451 VGND VPWR sky130_fd_sc_hd__tapvpwrvgnd_1
XANTENNA__7651__S _3742_ VGND VGND VPWR VPWR sky130_fd_sc_hd__diode_2
XANTENNA__6274__A1 _2972_ VGND VGND VPWR VPWR sky130_fd_sc_hd__diode_2
XANTENNA__7471__A0 _3083_ VGND VGND VPWR VPWR sky130_fd_sc_hd__diode_2
XANTENNA__8482__S _4189_ VGND VGND VPWR VPWR sky130_fd_sc_hd__diode_2
XFILLER_0_35_17 VGND VGND VPWR VPWR sky130_fd_sc_hd__fill_2
XFILLER_0_99_387 VGND VGND VPWR VPWR sky130_fd_sc_hd__fill_2
XFILLER_0_87_527 VGND VGND VPWR VPWR sky130_fd_sc_hd__decap_4
XFILLER_0_87_505 VGND VGND VPWR VPWR sky130_fd_sc_hd__fill_2
XANTENNA__6026__A1 _1959_ VGND VGND VPWR VPWR sky130_fd_sc_hd__diode_2
Xclkbuf_leaf_84_clk clknet_4_10_0_clk VGND VGND VPWR VPWR clknet_leaf_84_clk sky130_fd_sc_hd__clkbuf_8
XANTENNA__4588__A1 _1073_ VGND VGND VPWR VPWR sky130_fd_sc_hd__diode_2
XANTENNA__5880__S0 _1072_ VGND VGND VPWR VPWR sky130_fd_sc_hd__diode_2
XFILLER_0_95_593 VGND VGND VPWR VPWR sky130_fd_sc_hd__decap_3
XFILLER_0_67_262 VGND VGND VPWR VPWR sky130_fd_sc_hd__decap_4
XFILLER_0_51_49 VGND VGND VPWR VPWR sky130_fd_sc_hd__fill_2
XFILLER_0_27_137 VGND VGND VPWR VPWR sky130_fd_sc_hd__fill_2
XANTENNA__4435__S1 _1054_ VGND VGND VPWR VPWR sky130_fd_sc_hd__diode_2
XFILLER_0_42_107 VGND VGND VPWR VPWR sky130_fd_sc_hd__fill_1
Xclkload14 clknet_4_15_0_clk VGND VGND VPWR VPWR clkload14/Y sky130_fd_sc_hd__inv_6
XFILLER_0_70_449 VGND VGND VPWR VPWR sky130_fd_sc_hd__decap_3
Xclkload25 clknet_leaf_7_clk VGND VGND VPWR VPWR clkload25/X sky130_fd_sc_hd__clkbuf_4
XFILLER_0_3_727 VGND VGND VPWR VPWR sky130_fd_sc_hd__fill_1
XFILLER_0_35_181 VGND VGND VPWR VPWR sky130_fd_sc_hd__fill_2
XFILLER_0_35_192 VGND VGND VPWR VPWR sky130_fd_sc_hd__decap_3
XFILLER_0_36_693 VGND VGND VPWR VPWR sky130_fd_sc_hd__fill_2
Xclkload47 clknet_leaf_32_clk VGND VGND VPWR VPWR clkload47/Y sky130_fd_sc_hd__bufinv_16
Xclkload58 clknet_leaf_40_clk VGND VGND VPWR VPWR clkload58/Y sky130_fd_sc_hd__clkinvlp_2
Xclkload36 clknet_leaf_12_clk VGND VGND VPWR VPWR clkload36/X sky130_fd_sc_hd__clkbuf_4
XFILLER_0_51_663 VGND VGND VPWR VPWR sky130_fd_sc_hd__fill_1
Xclkload69 clknet_leaf_93_clk VGND VGND VPWR VPWR clkload69/Y sky130_fd_sc_hd__clkinvlp_2
X_5190_ _1936_ _1938_ _1941_ _1771_ _1778_ VGND VGND VPWR VPWR _1942_ sky130_fd_sc_hd__a221o_1
XANTENNA__6265__A1 _2966_ VGND VGND VPWR VPWR sky130_fd_sc_hd__diode_2
XFILLER_0_92_23 VGND VGND VPWR VPWR sky130_fd_sc_hd__decap_4
X_7900_ _3883_ VGND VGND VPWR VPWR _0361_ sky130_fd_sc_hd__clkbuf_1
XANTENNA__7797__A _3828_ VGND VGND VPWR VPWR sky130_fd_sc_hd__diode_2
XANTENNA__8392__S _4139_ VGND VGND VPWR VPWR sky130_fd_sc_hd__diode_2
XFILLER_0_116_41 VPWR VGND VPWR VGND sky130_ef_sc_hd__decap_12
XANTENNA__6017__A1 net138 VGND VGND VPWR VPWR sky130_fd_sc_hd__diode_2
X_8880_ clknet_leaf_65_clk _1001_ VGND VGND VPWR VPWR registers\[15\]\[16\] sky130_fd_sc_hd__dfxtp_1
Xclkbuf_leaf_75_clk clknet_4_11_0_clk VGND VGND VPWR VPWR clknet_leaf_75_clk sky130_fd_sc_hd__clkbuf_8
XTAP_TAPCELL_ROW_104_1609 VGND VPWR sky130_fd_sc_hd__tapvpwrvgnd_1
X_7831_ _3102_ registers\[26\]\[16\] _3840_ VGND VGND VPWR VPWR _3847_ sky130_fd_sc_hd__mux2_1
XTAP_TAPCELL_ROW_47_872 VGND VPWR sky130_fd_sc_hd__tapvpwrvgnd_1
X_4974_ registers\[0\]\[5\] registers\[1\]\[5\] registers\[2\]\[5\] registers\[3\]\[5\]
+ _1731_ _1691_ VGND VGND VPWR VPWR _1737_ sky130_fd_sc_hd__mux4_1
XANTENNA__5110__A _1866_ VGND VGND VPWR VPWR sky130_fd_sc_hd__diode_2
X_7762_ _3810_ VGND VGND VPWR VPWR _0296_ sky130_fd_sc_hd__clkbuf_1
X_7693_ registers\[24\]\[15\] _3466_ _3768_ VGND VGND VPWR VPWR _3774_ sky130_fd_sc_hd__mux2_1
X_9501_ clknet_leaf_107_clk _0598_ VGND VGND VPWR VPWR registers\[5\]\[29\] sky130_fd_sc_hd__dfxtp_1
XFILLER_0_19_627 VGND VGND VPWR VPWR sky130_fd_sc_hd__fill_2
X_6713_ registers\[10\]\[20\] _3003_ _3236_ VGND VGND VPWR VPWR _3237_ sky130_fd_sc_hd__mux2_1
XANTENNA__7736__S _3793_ VGND VGND VPWR VPWR sky130_fd_sc_hd__diode_2
XTAP_TAPCELL_ROW_63_1074 VGND VPWR sky130_fd_sc_hd__tapvpwrvgnd_1
X_9432_ clknet_leaf_88_clk _0529_ VGND VGND VPWR VPWR registers\[6\]\[24\] sky130_fd_sc_hd__dfxtp_1
X_6644_ registers\[0\]\[21\] _3006_ _3197_ VGND VGND VPWR VPWR _3199_ sky130_fd_sc_hd__mux2_1
XFILLER_0_73_276 VGND VGND VPWR VPWR sky130_fd_sc_hd__fill_2
XANTENNA__4426__S1 _1202_ VGND VGND VPWR VPWR sky130_fd_sc_hd__diode_2
XANTENNA__8190__A1 _3487_ VGND VGND VPWR VPWR sky130_fd_sc_hd__diode_2
XFILLER_0_27_671 VGND VGND VPWR VPWR sky130_fd_sc_hd__fill_1
Xclkload8 clknet_4_9_0_clk VGND VGND VPWR VPWR clkload8/X sky130_fd_sc_hd__clkbuf_8
XFILLER_0_104_529 VGND VGND VPWR VPWR sky130_fd_sc_hd__decap_3
XFILLER_0_81_3 VGND VGND VPWR VPWR sky130_fd_sc_hd__fill_2
XFILLER_0_61_449 VGND VGND VPWR VPWR sky130_fd_sc_hd__fill_2
X_9363_ clknet_leaf_96_clk _0460_ VGND VGND VPWR VPWR registers\[30\]\[19\] sky130_fd_sc_hd__dfxtp_1
X_6575_ _3161_ VGND VGND VPWR VPWR _0782_ sky130_fd_sc_hd__clkbuf_1
XFILLER_0_26_170 VGND VGND VPWR VPWR sky130_fd_sc_hd__fill_1
XFILLER_0_33_129 VGND VGND VPWR VPWR sky130_fd_sc_hd__decap_4
X_9294_ clknet_leaf_53_clk _0391_ VGND VGND VPWR VPWR registers\[28\]\[14\] sky130_fd_sc_hd__dfxtp_1
X_5526_ _2256_ _2261_ _1071_ VGND VGND VPWR VPWR _2262_ sky130_fd_sc_hd__mux2_2
X_8314_ _4102_ VGND VGND VPWR VPWR _0556_ sky130_fd_sc_hd__clkbuf_1
XFILLER_0_14_365 VGND VGND VPWR VPWR sky130_fd_sc_hd__fill_2
XTAP_TAPCELL_ROW_115_1749 VGND VPWR sky130_fd_sc_hd__tapvpwrvgnd_1
X_8245_ registers\[6\]\[19\] _3474_ _4056_ VGND VGND VPWR VPWR _4066_ sky130_fd_sc_hd__mux2_1
X_5457_ _2192_ _2193_ _2076_ VGND VGND VPWR VPWR _2194_ sky130_fd_sc_hd__mux2_1
XANTENNA__6876__A _3323_ VGND VGND VPWR VPWR sky130_fd_sc_hd__diode_2
XFILLER_0_112_573 VGND VGND VPWR VPWR sky130_fd_sc_hd__fill_2
XFILLER_0_100_724 VGND VGND VPWR VPWR sky130_fd_sc_hd__decap_6
XANTENNA__7471__S _3648_ VGND VGND VPWR VPWR sky130_fd_sc_hd__diode_2
X_4408_ _1197_ VGND VGND VPWR VPWR _1201_ sky130_fd_sc_hd__buf_4
X_8176_ _4029_ VGND VGND VPWR VPWR _0491_ sky130_fd_sc_hd__clkbuf_1
X_5388_ _2081_ _2128_ VGND VGND VPWR VPWR _2129_ sky130_fd_sc_hd__and2_1
X_7127_ registers\[16\]\[14\] _3464_ _3456_ VGND VGND VPWR VPWR _3465_ sky130_fd_sc_hd__mux2_1
X_4339_ _1025_ VGND VGND VPWR VPWR _1135_ sky130_fd_sc_hd__clkbuf_8
XFILLER_0_5_93 VGND VGND VPWR VPWR sky130_fd_sc_hd__decap_3
X_7058_ _3421_ VGND VGND VPWR VPWR _1005_ sky130_fd_sc_hd__clkbuf_1
X_6009_ _2495_ _2722_ _2727_ _2468_ VGND VGND VPWR VPWR _2728_ sky130_fd_sc_hd__a22o_1
XANTENNA__6815__S _3288_ VGND VGND VPWR VPWR sky130_fd_sc_hd__diode_2
XFILLER_0_96_313 VGND VGND VPWR VPWR sky130_fd_sc_hd__fill_2
XANTENNA__6008__A1 net135 VGND VGND VPWR VPWR sky130_fd_sc_hd__diode_2
XFILLER_0_69_505 VGND VGND VPWR VPWR sky130_fd_sc_hd__fill_2
Xclkbuf_leaf_66_clk clknet_4_12_0_clk VGND VGND VPWR VPWR clknet_leaf_66_clk sky130_fd_sc_hd__clkbuf_8
XFILLER_0_96_346 VGND VGND VPWR VPWR sky130_fd_sc_hd__fill_2
XANTENNA__4665__S1 _1428_ VGND VGND VPWR VPWR sky130_fd_sc_hd__diode_2
XFILLER_0_119_161 VGND VGND VPWR VPWR sky130_fd_sc_hd__decap_6
XFILLER_0_21_19 VGND VGND VPWR VPWR sky130_fd_sc_hd__fill_2
XTAP_TAPCELL_ROW_25_588 VGND VPWR sky130_fd_sc_hd__tapvpwrvgnd_1
XFILLER_0_80_725 VGND VGND VPWR VPWR sky130_fd_sc_hd__fill_2
XANTENNA__4417__S1 _1202_ VGND VGND VPWR VPWR sky130_fd_sc_hd__diode_2
XFILLER_0_52_416 VGND VGND VPWR VPWR sky130_fd_sc_hd__fill_2
XANTENNA__5166__S _1752_ VGND VGND VPWR VPWR sky130_fd_sc_hd__diode_2
XANTENNA__5090__S1 _1743_ VGND VGND VPWR VPWR sky130_fd_sc_hd__diode_2
XANTENNA__4742__A1 _1438_ VGND VGND VPWR VPWR sky130_fd_sc_hd__diode_2
XFILLER_0_33_663 VGND VGND VPWR VPWR sky130_fd_sc_hd__fill_2
XFILLER_0_33_685 VGND VGND VPWR VPWR sky130_fd_sc_hd__decap_3
XANTENNA__5690__A _2295_ VGND VGND VPWR VPWR sky130_fd_sc_hd__diode_2
XFILLER_0_20_368 VGND VGND VPWR VPWR sky130_fd_sc_hd__fill_2
XFILLER_0_46_49 VGND VGND VPWR VPWR sky130_fd_sc_hd__decap_3
Xclkbuf_leaf_57_clk clknet_4_15_0_clk VGND VGND VPWR VPWR clknet_leaf_57_clk sky130_fd_sc_hd__clkbuf_8
XANTENNA__6725__S _3236_ VGND VGND VPWR VPWR sky130_fd_sc_hd__diode_2
XFILLER_0_99_173 VGND VGND VPWR VPWR sky130_fd_sc_hd__fill_1
XFILLER_0_87_324 VGND VGND VPWR VPWR sky130_fd_sc_hd__fill_2
XFILLER_0_87_357 VGND VGND VPWR VPWR sky130_fd_sc_hd__fill_2
XTAP_TAPCELL_ROW_44_831 VGND VPWR sky130_fd_sc_hd__tapvpwrvgnd_1
XANTENNA__4656__S1 _1434_ VGND VGND VPWR VPWR sky130_fd_sc_hd__diode_2
XANTENNA__7556__S _3695_ VGND VGND VPWR VPWR sky130_fd_sc_hd__diode_2
X_4690_ _1372_ _1459_ _1467_ VGND VGND VPWR VPWR _1468_ sky130_fd_sc_hd__o21a_1
Xclkload103 clknet_leaf_56_clk VGND VGND VPWR VPWR clkload103/X sky130_fd_sc_hd__clkbuf_4
XFILLER_0_102_43 VGND VGND VPWR VPWR sky130_fd_sc_hd__fill_2
XFILLER_0_43_449 VGND VGND VPWR VPWR sky130_fd_sc_hd__fill_2
XFILLER_0_113_337 VGND VGND VPWR VPWR sky130_fd_sc_hd__fill_2
XANTENNA__5081__S1 _1814_ VGND VGND VPWR VPWR sky130_fd_sc_hd__diode_2
XFILLER_0_70_246 VGND VGND VPWR VPWR sky130_fd_sc_hd__fill_2
X_6360_ _3031_ VGND VGND VPWR VPWR _0697_ sky130_fd_sc_hd__clkbuf_1
XFILLER_0_11_85 VGND VGND VPWR VPWR sky130_fd_sc_hd__fill_2
XFILLER_0_24_652 VGND VGND VPWR VPWR sky130_fd_sc_hd__fill_1
XFILLER_0_51_493 VGND VGND VPWR VPWR sky130_fd_sc_hd__decap_8
X_5311_ registers\[12\]\[23\] registers\[13\]\[23\] registers\[14\]\[23\] registers\[15\]\[23\]
+ _1762_ _1764_ VGND VGND VPWR VPWR _2056_ sky130_fd_sc_hd__mux4_1
XFILLER_0_11_96 VGND VGND VPWR VPWR sky130_fd_sc_hd__fill_2
XFILLER_0_11_302 VGND VGND VPWR VPWR sky130_fd_sc_hd__fill_1
X_6291_ _2984_ VGND VGND VPWR VPWR _0675_ sky130_fd_sc_hd__clkbuf_1
X_8030_ _3952_ VGND VGND VPWR VPWR _0422_ sky130_fd_sc_hd__clkbuf_1
XANTENNA__7291__S _3550_ VGND VGND VPWR VPWR sky130_fd_sc_hd__diode_2
XFILLER_0_11_346 VGND VGND VPWR VPWR sky130_fd_sc_hd__fill_2
X_5242_ registers\[8\]\[19\] registers\[9\]\[19\] registers\[10\]\[19\] registers\[11\]\[19\]
+ _1690_ _1692_ VGND VGND VPWR VPWR _1991_ sky130_fd_sc_hd__mux4_1
X_5173_ registers\[12\]\[15\] registers\[13\]\[15\] registers\[14\]\[15\] registers\[15\]\[15\]
+ _1810_ _1811_ VGND VGND VPWR VPWR _1926_ sky130_fd_sc_hd__mux4_1
XANTENNA__4592__S0 _1338_ VGND VGND VPWR VPWR sky130_fd_sc_hd__diode_2
Xinput1 a1[0] VGND VGND VPWR VPWR net1 sky130_fd_sc_hd__buf_1
X_8932_ clknet_leaf_29_clk _0029_ VGND VGND VPWR VPWR registers\[17\]\[4\] sky130_fd_sc_hd__dfxtp_1
Xclkbuf_leaf_48_clk clknet_4_13_0_clk VGND VGND VPWR VPWR clknet_leaf_48_clk sky130_fd_sc_hd__clkbuf_8
XANTENNA__6635__S _3186_ VGND VGND VPWR VPWR sky130_fd_sc_hd__diode_2
XTAP_TAPCELL_ROW_65_1103 VGND VPWR sky130_fd_sc_hd__tapvpwrvgnd_1
XANTENNA__4895__S1 _1643_ VGND VGND VPWR VPWR sky130_fd_sc_hd__diode_2
X_8863_ clknet_leaf_10_clk _0984_ VGND VGND VPWR VPWR registers\[14\]\[31\] sky130_fd_sc_hd__dfxtp_1
X_7814_ _3085_ registers\[26\]\[8\] _3829_ VGND VGND VPWR VPWR _3838_ sky130_fd_sc_hd__mux2_1
X_8794_ clknet_leaf_85_clk _0915_ VGND VGND VPWR VPWR registers\[12\]\[26\] sky130_fd_sc_hd__dfxtp_1
X_4957_ registers\[4\]\[4\] registers\[5\]\[4\] registers\[6\]\[4\] registers\[7\]\[4\]
+ _1719_ _1720_ VGND VGND VPWR VPWR _1721_ sky130_fd_sc_hd__mux4_1
X_7745_ _3801_ VGND VGND VPWR VPWR _0288_ sky130_fd_sc_hd__clkbuf_1
XFILLER_0_52_81 VGND VGND VPWR VPWR sky130_fd_sc_hd__decap_3
XFILLER_0_19_457 VGND VGND VPWR VPWR sky130_fd_sc_hd__fill_2
XANTENNA__4972__A1 _1682_ VGND VGND VPWR VPWR sky130_fd_sc_hd__diode_2
X_7676_ registers\[24\]\[7\] _3449_ _3757_ VGND VGND VPWR VPWR _3765_ sky130_fd_sc_hd__mux2_1
XFILLER_0_62_725 VGND VGND VPWR VPWR sky130_fd_sc_hd__fill_2
XTAP_TAPCELL_ROW_22_547 VGND VPWR sky130_fd_sc_hd__tapvpwrvgnd_1
X_4888_ _1636_ VGND VGND VPWR VPWR _1655_ sky130_fd_sc_hd__buf_4
XFILLER_0_117_665 VGND VGND VPWR VPWR sky130_fd_sc_hd__decap_6
X_9415_ clknet_leaf_33_clk _0512_ VGND VGND VPWR VPWR registers\[6\]\[7\] sky130_fd_sc_hd__dfxtp_1
X_6627_ registers\[0\]\[13\] _2989_ _3186_ VGND VGND VPWR VPWR _3190_ sky130_fd_sc_hd__mux2_1
XFILLER_0_27_490 VGND VGND VPWR VPWR sky130_fd_sc_hd__fill_2
XFILLER_0_116_197 VGND VGND VPWR VPWR sky130_fd_sc_hd__fill_2
XFILLER_0_116_175 VGND VGND VPWR VPWR sky130_fd_sc_hd__fill_2
X_6558_ _3152_ VGND VGND VPWR VPWR _0774_ sky130_fd_sc_hd__clkbuf_1
XANTENNA__5072__S1 _1764_ VGND VGND VPWR VPWR sky130_fd_sc_hd__diode_2
X_9346_ clknet_leaf_0_clk _0443_ VGND VGND VPWR VPWR registers\[30\]\[2\] sky130_fd_sc_hd__dfxtp_1
XFILLER_0_104_359 VGND VGND VPWR VPWR sky130_fd_sc_hd__fill_2
XFILLER_0_30_611 VGND VGND VPWR VPWR sky130_fd_sc_hd__fill_2
XANTENNA__8297__S _4092_ VGND VGND VPWR VPWR sky130_fd_sc_hd__diode_2
XTAP_TAPCELL_ROW_76_1243 VGND VPWR sky130_fd_sc_hd__tapvpwrvgnd_1
X_5509_ _2136_ _2234_ VGND VGND VPWR VPWR _2245_ sky130_fd_sc_hd__or2_1
X_6489_ _3109_ VGND VGND VPWR VPWR _0748_ sky130_fd_sc_hd__clkbuf_1
X_9277_ clknet_leaf_103_clk _0374_ VGND VGND VPWR VPWR registers\[27\]\[29\] sky130_fd_sc_hd__dfxtp_1
XFILLER_0_112_392 VGND VGND VPWR VPWR sky130_fd_sc_hd__fill_2
X_8228_ _4057_ VGND VGND VPWR VPWR _0515_ sky130_fd_sc_hd__clkbuf_1
X_8159_ registers\[9\]\[10\] _3455_ _4020_ VGND VGND VPWR VPWR _4021_ sky130_fd_sc_hd__mux2_1
XFILLER_0_10_390 VGND VGND VPWR VPWR sky130_fd_sc_hd__fill_1
Xclkbuf_leaf_39_clk clknet_4_7_0_clk VGND VGND VPWR VPWR clknet_leaf_39_clk sky130_fd_sc_hd__clkbuf_8
XFILLER_0_97_600 VGND VGND VPWR VPWR sky130_fd_sc_hd__decap_4
XTAP_TAPCELL_ROW_2_283 VGND VPWR sky130_fd_sc_hd__tapvpwrvgnd_1
XFILLER_0_97_688 VPWR VGND VPWR VGND sky130_ef_sc_hd__decap_12
XTAP_TAPCELL_ROW_87_1394 VGND VPWR sky130_fd_sc_hd__tapvpwrvgnd_1
XFILLER_0_69_346 VGND VGND VPWR VPWR sky130_fd_sc_hd__fill_2
XPHY_EDGE_ROW_106_Left_226 VGND VGND VPWR VPWR sky130_fd_sc_hd__decap_3
XFILLER_0_96_187 VGND VGND VPWR VPWR sky130_fd_sc_hd__fill_1
XFILLER_0_38_722 VGND VGND VPWR VPWR sky130_fd_sc_hd__fill_2
XANTENNA__6401__A1 _3003_ VGND VGND VPWR VPWR sky130_fd_sc_hd__diode_2
XFILLER_0_32_29 VGND VGND VPWR VPWR sky130_fd_sc_hd__decap_3
XFILLER_0_65_530 VGND VGND VPWR VPWR sky130_fd_sc_hd__fill_1
XANTENNA__7376__S _3597_ VGND VGND VPWR VPWR sky130_fd_sc_hd__diode_2
XFILLER_0_92_360 VGND VGND VPWR VPWR sky130_fd_sc_hd__fill_2
XANTENNA__6280__S _2962_ VGND VGND VPWR VPWR sky130_fd_sc_hd__diode_2
XANTENNA__8154__A1 _3451_ VGND VGND VPWR VPWR sky130_fd_sc_hd__diode_2
XFILLER_0_107_131 VGND VGND VPWR VPWR sky130_fd_sc_hd__decap_3
XFILLER_0_80_522 VGND VGND VPWR VPWR sky130_fd_sc_hd__fill_1
XFILLER_0_52_224 VGND VGND VPWR VPWR sky130_fd_sc_hd__fill_1
XFILLER_0_25_449 VGND VGND VPWR VPWR sky130_fd_sc_hd__fill_2
XANTENNA__5063__S1 _1821_ VGND VGND VPWR VPWR sky130_fd_sc_hd__diode_2
XFILLER_0_33_460 VGND VGND VPWR VPWR sky130_fd_sc_hd__fill_1
XFILLER_0_33_471 VGND VGND VPWR VPWR sky130_fd_sc_hd__fill_2
XPHY_EDGE_ROW_115_Left_235 VGND VGND VPWR VPWR sky130_fd_sc_hd__decap_3
XFILLER_0_110_318 VGND VGND VPWR VPWR sky130_fd_sc_hd__decap_6
XFILLER_0_110_307 VGND VGND VPWR VPWR sky130_fd_sc_hd__fill_1
XFILLER_0_0_505 VGND VGND VPWR VPWR sky130_fd_sc_hd__fill_2
XANTENNA__4574__S0 _1160_ VGND VGND VPWR VPWR sky130_fd_sc_hd__diode_2
XTAP_TAPCELL_ROW_49_901 VGND VPWR sky130_fd_sc_hd__tapvpwrvgnd_1
XANTENNA__4877__S1 _1643_ VGND VGND VPWR VPWR sky130_fd_sc_hd__diode_2
X_5860_ _2569_ VGND VGND VPWR VPWR _2587_ sky130_fd_sc_hd__buf_2
XANTENNA__4629__S1 _1348_ VGND VGND VPWR VPWR sky130_fd_sc_hd__diode_2
X_4811_ registers\[12\]\[29\] registers\[13\]\[29\] registers\[14\]\[29\] registers\[15\]\[29\]
+ _1550_ _1551_ VGND VGND VPWR VPWR _1582_ sky130_fd_sc_hd__mux4_1
XFILLER_0_87_198 VGND VGND VPWR VPWR sky130_fd_sc_hd__decap_3
X_5791_ _1740_ _2486_ VGND VGND VPWR VPWR _2521_ sky130_fd_sc_hd__nand2_1
XFILLER_0_7_104 VGND VGND VPWR VPWR sky130_fd_sc_hd__decap_4
XTAP_TAPCELL_ROW_60_1033 VGND VPWR sky130_fd_sc_hd__tapvpwrvgnd_1
XFILLER_0_8_649 VGND VGND VPWR VPWR sky130_fd_sc_hd__fill_1
X_4742_ _1438_ _1507_ _1516_ VGND VGND VPWR VPWR _1517_ sky130_fd_sc_hd__a21oi_2
X_7530_ _3687_ VGND VGND VPWR VPWR _0187_ sky130_fd_sc_hd__clkbuf_1
XFILLER_0_28_276 VGND VGND VPWR VPWR sky130_fd_sc_hd__fill_1
XFILLER_0_83_393 VGND VGND VPWR VPWR sky130_fd_sc_hd__fill_2
XTAP_TAPCELL_ROW_60_1044 VGND VPWR sky130_fd_sc_hd__tapvpwrvgnd_1
X_7461_ _3073_ registers\[21\]\[2\] _3648_ VGND VGND VPWR VPWR _3651_ sky130_fd_sc_hd__mux2_1
X_4673_ _1450_ _1451_ _1346_ VGND VGND VPWR VPWR _1452_ sky130_fd_sc_hd__mux2_1
XFILLER_0_28_287 VGND VGND VPWR VPWR sky130_fd_sc_hd__fill_2
XFILLER_0_114_624 VGND VGND VPWR VPWR sky130_fd_sc_hd__fill_2
XFILLER_0_98_33 VGND VGND VPWR VPWR sky130_fd_sc_hd__fill_2
XFILLER_0_98_11 VPWR VGND VPWR VGND sky130_ef_sc_hd__decap_12
XFILLER_0_71_555 VGND VGND VPWR VPWR sky130_fd_sc_hd__decap_3
X_9200_ clknet_leaf_62_clk _0297_ VGND VGND VPWR VPWR registers\[25\]\[16\] sky130_fd_sc_hd__dfxtp_1
XANTENNA__4706__A1 _1159_ VGND VGND VPWR VPWR sky130_fd_sc_hd__diode_2
X_6412_ _3058_ VGND VGND VPWR VPWR _0722_ sky130_fd_sc_hd__clkbuf_1
XFILLER_0_114_657 VPWR VGND VPWR VGND sky130_ef_sc_hd__decap_12
XFILLER_0_3_332 VGND VGND VPWR VPWR sky130_fd_sc_hd__fill_2
X_7392_ _3614_ VGND VGND VPWR VPWR _0122_ sky130_fd_sc_hd__clkbuf_1
X_9131_ clknet_leaf_59_clk _0228_ VGND VGND VPWR VPWR registers\[23\]\[11\] sky130_fd_sc_hd__dfxtp_1
X_6343_ _3019_ VGND VGND VPWR VPWR _0692_ sky130_fd_sc_hd__clkbuf_1
XTAP_TAPCELL_ROW_112_1719 VGND VPWR sky130_fd_sc_hd__tapvpwrvgnd_1
X_6274_ registers\[19\]\[5\] _2972_ _2962_ VGND VGND VPWR VPWR _2973_ sky130_fd_sc_hd__mux2_1
X_9062_ clknet_leaf_34_clk _0159_ VGND VGND VPWR VPWR registers\[21\]\[6\] sky130_fd_sc_hd__dfxtp_1
X_8013_ _3943_ VGND VGND VPWR VPWR _0414_ sky130_fd_sc_hd__clkbuf_1
XANTENNA__4565__S0 _1347_ VGND VGND VPWR VPWR sky130_fd_sc_hd__diode_2
X_5225_ registers\[0\]\[18\] registers\[1\]\[18\] registers\[2\]\[18\] registers\[3\]\[18\]
+ _1758_ _1760_ VGND VGND VPWR VPWR _1975_ sky130_fd_sc_hd__mux4_1
XANTENNA__5682__A2 _2310_ VGND VGND VPWR VPWR sky130_fd_sc_hd__diode_2
XFILLER_0_44_3 VGND VGND VPWR VPWR sky130_fd_sc_hd__fill_2
X_5156_ registers\[0\]\[14\] registers\[1\]\[14\] registers\[2\]\[14\] registers\[3\]\[14\]
+ _1883_ _1774_ VGND VGND VPWR VPWR _1910_ sky130_fd_sc_hd__mux4_1
XTAP_TAPCELL_ROW_71_1184 VGND VPWR sky130_fd_sc_hd__tapvpwrvgnd_1
X_5087_ _1843_ _1844_ _1809_ VGND VGND VPWR VPWR _1845_ sky130_fd_sc_hd__mux2_1
XANTENNA__6365__S _3030_ VGND VGND VPWR VPWR sky130_fd_sc_hd__diode_2
X_8915_ clknet_leaf_46_clk _0012_ VGND VGND VPWR VPWR registers\[16\]\[19\] sky130_fd_sc_hd__dfxtp_1
XFILLER_0_2_61 VPWR VGND VPWR VGND sky130_ef_sc_hd__decap_12
XTAP_TAPCELL_ROW_27_606 VGND VPWR sky130_fd_sc_hd__tapvpwrvgnd_1
XFILLER_0_79_677 VGND VGND VPWR VPWR sky130_fd_sc_hd__fill_2
XFILLER_0_78_132 VGND VGND VPWR VPWR sky130_fd_sc_hd__decap_3
X_8846_ clknet_leaf_39_clk _0967_ VGND VGND VPWR VPWR registers\[14\]\[14\] sky130_fd_sc_hd__dfxtp_1
XFILLER_0_93_113 VGND VGND VPWR VPWR sky130_fd_sc_hd__decap_3
XFILLER_0_79_688 VGND VGND VPWR VPWR sky130_fd_sc_hd__fill_1
XFILLER_0_78_165 VGND VGND VPWR VPWR sky130_fd_sc_hd__fill_1
XANTENNA__8384__A1 _3476_ VGND VGND VPWR VPWR sky130_fd_sc_hd__diode_2
XFILLER_0_109_407 VGND VGND VPWR VPWR sky130_fd_sc_hd__decap_3
XANTENNA__7196__S _3503_ VGND VGND VPWR VPWR sky130_fd_sc_hd__diode_2
X_8777_ clknet_leaf_19_clk _0898_ VGND VGND VPWR VPWR registers\[12\]\[9\] sky130_fd_sc_hd__dfxtp_1
X_5989_ _2705_ _2708_ VGND VGND VPWR VPWR _2709_ sky130_fd_sc_hd__xnor2_2
XFILLER_0_19_221 VGND VGND VPWR VPWR sky130_fd_sc_hd__decap_3
XFILLER_0_47_552 VGND VGND VPWR VPWR sky130_fd_sc_hd__decap_4
X_7728_ _3067_ _3755_ VGND VGND VPWR VPWR _3792_ sky130_fd_sc_hd__nand2_4
XANTENNA__5293__S1 _1701_ VGND VGND VPWR VPWR sky130_fd_sc_hd__diode_2
XFILLER_0_34_202 VGND VGND VPWR VPWR sky130_fd_sc_hd__fill_2
XFILLER_0_35_725 VGND VGND VPWR VPWR sky130_fd_sc_hd__decap_3
XFILLER_0_105_635 VGND VGND VPWR VPWR sky130_fd_sc_hd__decap_3
XANTENNA__6698__A1 _2989_ VGND VGND VPWR VPWR sky130_fd_sc_hd__diode_2
XANTENNA__7924__S _3887_ VGND VGND VPWR VPWR sky130_fd_sc_hd__diode_2
XFILLER_0_34_257 VGND VGND VPWR VPWR sky130_fd_sc_hd__fill_2
X_7659_ net11 net12 net13 VGND VGND VPWR VPWR _3755_ sky130_fd_sc_hd__and3b_2
XFILLER_0_105_657 VGND VGND VPWR VPWR sky130_fd_sc_hd__fill_2
XFILLER_0_104_167 VGND VGND VPWR VPWR sky130_fd_sc_hd__fill_1
X_9329_ clknet_leaf_48_clk _0426_ VGND VGND VPWR VPWR registers\[2\]\[17\] sky130_fd_sc_hd__dfxtp_1
XANTENNA__7647__A0 _3123_ VGND VGND VPWR VPWR sky130_fd_sc_hd__diode_2
XANTENNA__7225__A _3502_ VGND VGND VPWR VPWR sky130_fd_sc_hd__diode_2
XFILLER_0_100_351 VGND VGND VPWR VPWR sky130_fd_sc_hd__fill_2
XANTENNA__4556__S0 _1338_ VGND VGND VPWR VPWR sky130_fd_sc_hd__diode_2
XTAP_TAPCELL_ROW_7_353 VGND VPWR sky130_fd_sc_hd__tapvpwrvgnd_1
XTAP_TAPCELL_ROW_89_1412 VGND VPWR sky130_fd_sc_hd__tapvpwrvgnd_1
XANTENNA_input28_A wd3[20] VGND VGND VPWR VPWR sky130_fd_sc_hd__diode_2
XANTENNA__8072__A0 _2964_ VGND VGND VPWR VPWR sky130_fd_sc_hd__diode_2
XFILLER_0_69_110 VGND VGND VPWR VPWR sky130_fd_sc_hd__fill_2
XANTENNA__8490__S _4189_ VGND VGND VPWR VPWR sky130_fd_sc_hd__diode_2
XFILLER_0_85_603 VPWR VGND VPWR VGND sky130_ef_sc_hd__decap_12
XFILLER_0_69_176 VGND VGND VPWR VPWR sky130_fd_sc_hd__decap_3
XANTENNA__8375__A1 _3468_ VGND VGND VPWR VPWR sky130_fd_sc_hd__diode_2
XFILLER_0_85_669 VGND VGND VPWR VPWR sky130_fd_sc_hd__fill_1
XFILLER_0_85_658 VGND VGND VPWR VPWR sky130_fd_sc_hd__decap_3
XFILLER_0_38_541 VGND VGND VPWR VPWR sky130_fd_sc_hd__fill_1
XFILLER_0_38_530 VGND VGND VPWR VPWR sky130_fd_sc_hd__fill_2
XANTENNA__4523__S _1148_ VGND VGND VPWR VPWR sky130_fd_sc_hd__diode_2
XANTENNA__5619__S _2353_ VGND VGND VPWR VPWR sky130_fd_sc_hd__diode_2
XANTENNA__6304__A net22 VGND VGND VPWR VPWR sky130_fd_sc_hd__diode_2
XFILLER_0_65_360 VPWR VGND VPWR VGND sky130_ef_sc_hd__decap_12
XFILLER_0_26_714 VGND VGND VPWR VPWR sky130_fd_sc_hd__decap_8
XFILLER_0_65_393 VGND VGND VPWR VPWR sky130_fd_sc_hd__decap_8
XFILLER_0_53_533 VGND VGND VPWR VPWR sky130_fd_sc_hd__fill_1
XFILLER_0_38_596 VGND VGND VPWR VPWR sky130_fd_sc_hd__fill_2
XFILLER_0_38_585 VGND VGND VPWR VPWR sky130_fd_sc_hd__decap_3
XFILLER_0_111_7 VPWR VGND VPWR VGND sky130_ef_sc_hd__decap_12
XANTENNA__6689__A1 _2980_ VGND VGND VPWR VPWR sky130_fd_sc_hd__diode_2
XFILLER_0_4_118 VGND VGND VPWR VPWR sky130_fd_sc_hd__fill_2
XFILLER_0_80_396 VGND VGND VPWR VPWR sky130_fd_sc_hd__fill_2
XANTENNA_output96_A net96 VGND VGND VPWR VPWR sky130_fd_sc_hd__diode_2
XANTENNA__7135__A net24 VGND VGND VPWR VPWR sky130_fd_sc_hd__diode_2
XFILLER_0_0_346 VGND VGND VPWR VPWR sky130_fd_sc_hd__fill_2
XFILLER_0_0_379 VPWR VGND VPWR VGND sky130_ef_sc_hd__decap_12
X_5010_ registers\[4\]\[6\] registers\[5\]\[6\] registers\[6\]\[6\] registers\[7\]\[6\]
+ _1763_ _1765_ VGND VGND VPWR VPWR _1772_ sky130_fd_sc_hd__mux4_1
XANTENNA__6861__A1 _3014_ VGND VGND VPWR VPWR sky130_fd_sc_hd__diode_2
XANTENNA__4872__B1 net5 VGND VGND VPWR VPWR sky130_fd_sc_hd__diode_2
XTAP_TAPCELL_ROW_109_1681 VGND VPWR sky130_fd_sc_hd__tapvpwrvgnd_1
XTAP_TAPCELL_ROW_109_1670 VGND VPWR sky130_fd_sc_hd__tapvpwrvgnd_1
X_6961_ _3369_ VGND VGND VPWR VPWR _0960_ sky130_fd_sc_hd__clkbuf_1
X_8700_ clknet_leaf_109_clk _0821_ VGND VGND VPWR VPWR registers\[0\]\[28\] sky130_fd_sc_hd__dfxtp_1
X_5912_ net124 _2633_ _2635_ VGND VGND VPWR VPWR _2636_ sky130_fd_sc_hd__o21ai_1
X_6892_ _3332_ VGND VGND VPWR VPWR _0928_ sky130_fd_sc_hd__clkbuf_1
X_5843_ _2296_ _2569_ _2570_ _2239_ VGND VGND VPWR VPWR _2571_ sky130_fd_sc_hd__o22a_1
XFILLER_0_76_658 VGND VGND VPWR VPWR sky130_fd_sc_hd__fill_2
XFILLER_0_75_113 VGND VGND VPWR VPWR sky130_fd_sc_hd__fill_2
XTAP_TAPCELL_ROW_52_929 VGND VPWR sky130_fd_sc_hd__tapvpwrvgnd_1
X_8631_ clknet_leaf_70_clk _0752_ VGND VGND VPWR VPWR registers\[29\]\[23\] sky130_fd_sc_hd__dfxtp_1
XFILLER_0_75_157 VGND VGND VPWR VPWR sky130_fd_sc_hd__decap_4
X_8562_ clknet_leaf_72_clk _0683_ VGND VGND VPWR VPWR registers\[19\]\[18\] sky130_fd_sc_hd__dfxtp_1
XANTENNA__5275__S1 _2021_ VGND VGND VPWR VPWR sky130_fd_sc_hd__diode_2
XFILLER_0_29_574 VGND VGND VPWR VPWR sky130_fd_sc_hd__fill_2
X_5774_ _2413_ _2465_ _2503_ _2279_ VGND VGND VPWR VPWR _2504_ sky130_fd_sc_hd__o22a_1
XFILLER_0_91_639 VGND VGND VPWR VPWR sky130_fd_sc_hd__fill_2
XFILLER_0_8_468 VGND VGND VPWR VPWR sky130_fd_sc_hd__fill_2
XFILLER_0_16_224 VGND VGND VPWR VPWR sky130_fd_sc_hd__decap_3
X_7513_ _3125_ registers\[21\]\[27\] _3670_ VGND VGND VPWR VPWR _3678_ sky130_fd_sc_hd__mux2_1
XTAP_TAPCELL_ROW_32_675 VGND VPWR sky130_fd_sc_hd__tapvpwrvgnd_1
XANTENNA__5027__S1 _1679_ VGND VGND VPWR VPWR sky130_fd_sc_hd__diode_2
X_8493_ _4197_ VGND VGND VPWR VPWR _0640_ sky130_fd_sc_hd__clkbuf_1
XANTENNA__7744__S _3793_ VGND VGND VPWR VPWR sky130_fd_sc_hd__diode_2
XFILLER_0_71_352 VGND VGND VPWR VPWR sky130_fd_sc_hd__decap_6
X_4725_ _1500_ VGND VGND VPWR VPWR net129 sky130_fd_sc_hd__inv_2
XFILLER_0_16_235 VGND VGND VPWR VPWR sky130_fd_sc_hd__fill_2
XFILLER_0_4_641 VGND VGND VPWR VPWR sky130_fd_sc_hd__fill_1
X_4656_ registers\[0\]\[20\] registers\[1\]\[20\] registers\[2\]\[20\] registers\[3\]\[20\]
+ _1433_ _1434_ VGND VGND VPWR VPWR _1436_ sky130_fd_sc_hd__mux4_1
X_7444_ _3641_ VGND VGND VPWR VPWR _0147_ sky130_fd_sc_hd__clkbuf_1
XFILLER_0_31_216 VGND VGND VPWR VPWR sky130_fd_sc_hd__fill_2
X_4587_ _1135_ _1369_ _1142_ VGND VGND VPWR VPWR _1370_ sky130_fd_sc_hd__a21o_1
XANTENNA__4786__S0 _1555_ VGND VGND VPWR VPWR sky130_fd_sc_hd__diode_2
X_7375_ _3604_ VGND VGND VPWR VPWR _0115_ sky130_fd_sc_hd__clkbuf_1
XTAP_TAPCELL_ROW_73_1213 VGND VPWR sky130_fd_sc_hd__tapvpwrvgnd_1
XTAP_TAPCELL_ROW_73_1202 VGND VPWR sky130_fd_sc_hd__tapvpwrvgnd_1
X_6326_ net30 VGND VGND VPWR VPWR _3008_ sky130_fd_sc_hd__buf_2
X_9114_ clknet_leaf_77_clk _0211_ VGND VGND VPWR VPWR registers\[22\]\[26\] sky130_fd_sc_hd__dfxtp_1
XANTENNA_clkbuf_leaf_51_clk_A clknet_4_13_0_clk VGND VGND VPWR VPWR sky130_fd_sc_hd__diode_2
XFILLER_0_12_485 VGND VGND VPWR VPWR sky130_fd_sc_hd__fill_2
XFILLER_0_110_682 VGND VGND VPWR VPWR sky130_fd_sc_hd__fill_2
XFILLER_0_58_80 VGND VGND VPWR VPWR sky130_fd_sc_hd__fill_2
X_6257_ _2959_ _2960_ VGND VGND VPWR VPWR _2961_ sky130_fd_sc_hd__nor2_4
X_9045_ clknet_leaf_78_clk _0142_ VGND VGND VPWR VPWR registers\[20\]\[21\] sky130_fd_sc_hd__dfxtp_1
X_5208_ _1741_ _1950_ _1954_ _1958_ VGND VGND VPWR VPWR _1959_ sky130_fd_sc_hd__a2bb2o_2
X_6188_ _2246_ _2252_ VGND VGND VPWR VPWR _2896_ sky130_fd_sc_hd__nand2_1
XTAP_TAPCELL_ROW_4_312 VGND VPWR sky130_fd_sc_hd__tapvpwrvgnd_1
X_5139_ _1754_ _1893_ VGND VGND VPWR VPWR _1894_ sky130_fd_sc_hd__nand2_1
XANTENNA__6604__A1 _2966_ VGND VGND VPWR VPWR sky130_fd_sc_hd__diode_2
XANTENNA__6823__S _3288_ VGND VGND VPWR VPWR sky130_fd_sc_hd__diode_2
XTAP_TAPCELL_ROW_84_1353 VGND VPWR sky130_fd_sc_hd__tapvpwrvgnd_1
XFILLER_0_67_603 VGND VGND VPWR VPWR sky130_fd_sc_hd__fill_1
XANTENNA__4710__S0 _1418_ VGND VGND VPWR VPWR sky130_fd_sc_hd__diode_2
X_8829_ clknet_leaf_104_clk _0950_ VGND VGND VPWR VPWR registers\[13\]\[29\] sky130_fd_sc_hd__dfxtp_1
XFILLER_0_94_455 VGND VGND VPWR VPWR sky130_fd_sc_hd__fill_2
XANTENNA__5266__S1 _1969_ VGND VGND VPWR VPWR sky130_fd_sc_hd__diode_2
XFILLER_0_35_533 VGND VGND VPWR VPWR sky130_fd_sc_hd__fill_2
XANTENNA__7868__A0 _3071_ VGND VGND VPWR VPWR sky130_fd_sc_hd__diode_2
XFILLER_0_117_281 VGND VGND VPWR VPWR sky130_fd_sc_hd__fill_2
XFILLER_0_105_465 VGND VGND VPWR VPWR sky130_fd_sc_hd__fill_2
XANTENNA__4579__A _1131_ VGND VGND VPWR VPWR sky130_fd_sc_hd__diode_2
XANTENNA__4551__C1 _1142_ VGND VGND VPWR VPWR sky130_fd_sc_hd__diode_2
XANTENNA__5174__S _1809_ VGND VGND VPWR VPWR sky130_fd_sc_hd__diode_2
XANTENNA__7096__A1 _3443_ VGND VGND VPWR VPWR sky130_fd_sc_hd__diode_2
XFILLER_0_101_660 VPWR VGND VPWR VGND sky130_ef_sc_hd__decap_12
XTAP_TAPCELL_ROW_95_1493 VGND VPWR sky130_fd_sc_hd__tapvpwrvgnd_1
XANTENNA_clkbuf_leaf_19_clk_A clknet_4_4_0_clk VGND VGND VPWR VPWR sky130_fd_sc_hd__diode_2
XFILLER_0_30_271 VGND VGND VPWR VPWR sky130_fd_sc_hd__fill_2
XANTENNA__4529__S0 _1198_ VGND VGND VPWR VPWR sky130_fd_sc_hd__diode_2
XFILLER_0_100_170 VGND VGND VPWR VPWR sky130_fd_sc_hd__decap_4
XFILLER_0_100_192 VGND VGND VPWR VPWR sky130_fd_sc_hd__fill_2
XFILLER_0_89_216 VGND VGND VPWR VPWR sky130_fd_sc_hd__fill_2
XANTENNA__5203__A _1754_ VGND VGND VPWR VPWR sky130_fd_sc_hd__diode_2
XFILLER_0_54_27 VGND VGND VPWR VPWR sky130_fd_sc_hd__fill_1
XANTENNA__7829__S _3840_ VGND VGND VPWR VPWR sky130_fd_sc_hd__diode_2
XFILLER_0_85_422 VGND VGND VPWR VPWR sky130_fd_sc_hd__fill_2
XFILLER_0_58_658 VGND VGND VPWR VPWR sky130_fd_sc_hd__decap_4
XANTENNA__5257__S1 _1969_ VGND VGND VPWR VPWR sky130_fd_sc_hd__diode_2
XFILLER_0_26_500 VGND VGND VPWR VPWR sky130_fd_sc_hd__fill_2
XANTENNA__4909__B2 _1634_ VGND VGND VPWR VPWR sky130_fd_sc_hd__diode_2
XANTENNA__5582__A1 _2269_ VGND VGND VPWR VPWR sky130_fd_sc_hd__diode_2
XFILLER_0_81_650 VGND VGND VPWR VPWR sky130_fd_sc_hd__fill_2
XANTENNA__7564__S _3695_ VGND VGND VPWR VPWR sky130_fd_sc_hd__diode_2
XFILLER_0_5_416 VGND VGND VPWR VPWR sky130_fd_sc_hd__decap_3
XFILLER_0_26_533 VGND VGND VPWR VPWR sky130_fd_sc_hd__fill_2
X_5490_ _2222_ _2225_ _1072_ VGND VGND VPWR VPWR _2226_ sky130_fd_sc_hd__mux2_1
XANTENNA__5894__A1_N _2490_ VGND VGND VPWR VPWR sky130_fd_sc_hd__diode_2
X_4510_ _1124_ _1296_ VGND VGND VPWR VPWR _1297_ sky130_fd_sc_hd__nand2_1
XFILLER_0_5_449 VGND VGND VPWR VPWR sky130_fd_sc_hd__fill_2
XFILLER_0_14_717 VGND VGND VPWR VPWR sky130_fd_sc_hd__decap_4
XFILLER_0_111_402 VGND VGND VPWR VPWR sky130_fd_sc_hd__fill_1
XFILLER_0_102_3 VGND VGND VPWR VPWR sky130_fd_sc_hd__fill_1
XFILLER_0_79_57 VGND VGND VPWR VPWR sky130_fd_sc_hd__fill_1
X_4441_ registers\[8\]\[9\] registers\[9\]\[9\] registers\[10\]\[9\] registers\[11\]\[9\]
+ _1197_ _1203_ VGND VGND VPWR VPWR _1232_ sky130_fd_sc_hd__mux4_1
XFILLER_0_41_547 VGND VGND VPWR VPWR sky130_fd_sc_hd__fill_2
XANTENNA__4768__S0 _1382_ VGND VGND VPWR VPWR sky130_fd_sc_hd__diode_2
XANTENNA__8520__A1 net28 VGND VGND VPWR VPWR sky130_fd_sc_hd__diode_2
XANTENNA__5084__S _1714_ VGND VGND VPWR VPWR sky130_fd_sc_hd__diode_2
XANTENNA__5885__A2 _2515_ VGND VGND VPWR VPWR sky130_fd_sc_hd__diode_2
X_7160_ net33 VGND VGND VPWR VPWR _3487_ sky130_fd_sc_hd__buf_2
XPHY_EDGE_ROW_9_Right_9 VGND VGND VPWR VPWR sky130_fd_sc_hd__decap_3
XANTENNA__8284__A0 _2972_ VGND VGND VPWR VPWR sky130_fd_sc_hd__diode_2
X_4372_ _1166_ VGND VGND VPWR VPWR net140 sky130_fd_sc_hd__inv_2
X_6111_ _2821_ _2823_ VGND VGND VPWR VPWR _2824_ sky130_fd_sc_hd__xnor2_1
XANTENNA__7087__A1 _3437_ VGND VGND VPWR VPWR sky130_fd_sc_hd__diode_2
XANTENNA__5812__S _2295_ VGND VGND VPWR VPWR sky130_fd_sc_hd__diode_2
XANTENNA__6908__S _3335_ VGND VGND VPWR VPWR sky130_fd_sc_hd__diode_2
X_7091_ _3440_ VGND VGND VPWR VPWR _1019_ sky130_fd_sc_hd__clkbuf_1
XFILLER_0_119_41 VPWR VGND VPWR VGND sky130_ef_sc_hd__decap_12
XANTENNA__5193__S0 _1806_ VGND VGND VPWR VPWR sky130_fd_sc_hd__diode_2
XPHY_EDGE_ROW_107_Right_107 VGND VGND VPWR VPWR sky130_fd_sc_hd__decap_3
X_6042_ _2756_ _2758_ _2344_ VGND VGND VPWR VPWR _2759_ sky130_fd_sc_hd__mux2_1
XFILLER_0_119_85 VPWR VGND VPWR VGND sky130_ef_sc_hd__decap_12
XFILLER_0_28_83 VGND VGND VPWR VPWR sky130_fd_sc_hd__fill_1
XANTENNA__4845__B1 _1372_ VGND VGND VPWR VPWR sky130_fd_sc_hd__diode_2
X_7993_ _3932_ VGND VGND VPWR VPWR _0405_ sky130_fd_sc_hd__clkbuf_1
XTAP_TAPCELL_ROW_37_734 VGND VPWR sky130_fd_sc_hd__tapvpwrvgnd_1
XFILLER_0_49_625 VPWR VGND VPWR VGND sky130_ef_sc_hd__decap_12
X_6944_ _3359_ _3286_ VGND VGND VPWR VPWR _3360_ sky130_fd_sc_hd__nand2_2
XTAP_TAPCELL_ROW_37_745 VGND VPWR sky130_fd_sc_hd__tapvpwrvgnd_1
XFILLER_0_119_502 VGND VGND VPWR VPWR sky130_fd_sc_hd__fill_2
XFILLER_0_88_282 VGND VGND VPWR VPWR sky130_fd_sc_hd__fill_2
XFILLER_0_49_647 VGND VGND VPWR VPWR sky130_fd_sc_hd__decap_3
XFILLER_0_48_124 VGND VGND VPWR VPWR sky130_fd_sc_hd__fill_2
XFILLER_0_119_524 VGND VGND VPWR VPWR sky130_fd_sc_hd__decap_3
X_8614_ clknet_leaf_34_clk _0735_ VGND VGND VPWR VPWR registers\[29\]\[6\] sky130_fd_sc_hd__dfxtp_1
XFILLER_0_76_477 VGND VGND VPWR VPWR sky130_fd_sc_hd__fill_2
XFILLER_0_8_210 VGND VGND VPWR VPWR sky130_fd_sc_hd__fill_1
XTAP_TAPCELL_ROW_17_480 VGND VPWR sky130_fd_sc_hd__tapvpwrvgnd_1
X_6875_ _3067_ _3286_ VGND VGND VPWR VPWR _3323_ sky130_fd_sc_hd__nand2_2
X_5826_ _1780_ _2517_ VGND VGND VPWR VPWR _2554_ sky130_fd_sc_hd__nand2_1
XFILLER_0_8_232 VGND VGND VPWR VPWR sky130_fd_sc_hd__fill_1
XFILLER_0_29_382 VGND VGND VPWR VPWR sky130_fd_sc_hd__decap_4
X_5757_ _2479_ _2480_ _2477_ VGND VGND VPWR VPWR _2488_ sky130_fd_sc_hd__a21o_1
XFILLER_0_44_341 VGND VGND VPWR VPWR sky130_fd_sc_hd__fill_2
X_8545_ clknet_leaf_1_clk _0666_ VGND VGND VPWR VPWR registers\[19\]\[1\] sky130_fd_sc_hd__dfxtp_1
XFILLER_0_71_160 VGND VGND VPWR VPWR sky130_fd_sc_hd__fill_2
X_4708_ _1484_ VGND VGND VPWR VPWR net128 sky130_fd_sc_hd__inv_2
XFILLER_0_44_374 VGND VGND VPWR VPWR sky130_fd_sc_hd__fill_2
X_8476_ _3135_ _3173_ VGND VGND VPWR VPWR _4188_ sky130_fd_sc_hd__nor2_2
X_5688_ _2420_ VGND VGND VPWR VPWR _2422_ sky130_fd_sc_hd__buf_2
XFILLER_0_102_402 VGND VGND VPWR VPWR sky130_fd_sc_hd__fill_2
XANTENNA__8511__A1 net23 VGND VGND VPWR VPWR sky130_fd_sc_hd__diode_2
X_7427_ _3632_ VGND VGND VPWR VPWR _0139_ sky130_fd_sc_hd__clkbuf_1
XANTENNA__6522__A0 _3131_ VGND VGND VPWR VPWR sky130_fd_sc_hd__diode_2
X_4639_ _1199_ VGND VGND VPWR VPWR _1419_ sky130_fd_sc_hd__buf_4
XFILLER_0_8_71 VGND VGND VPWR VPWR sky130_fd_sc_hd__fill_1
XFILLER_0_4_493 VGND VGND VPWR VPWR sky130_fd_sc_hd__fill_2
X_7358_ _3595_ VGND VGND VPWR VPWR _0107_ sky130_fd_sc_hd__clkbuf_1
XFILLER_0_12_282 VGND VGND VPWR VPWR sky130_fd_sc_hd__fill_2
X_6309_ _2996_ VGND VGND VPWR VPWR _0681_ sky130_fd_sc_hd__clkbuf_1
X_7289_ registers\[18\]\[18\] _3472_ _3550_ VGND VGND VPWR VPWR _3559_ sky130_fd_sc_hd__mux2_1
XFILLER_0_5_7 VGND VGND VPWR VPWR sky130_fd_sc_hd__decap_4
X_9028_ clknet_leaf_28_clk _0125_ VGND VGND VPWR VPWR registers\[20\]\[4\] sky130_fd_sc_hd__dfxtp_1
XANTENNA__6825__A1 _2978_ VGND VGND VPWR VPWR sky130_fd_sc_hd__diode_2
XANTENNA__4931__S0 _1690_ VGND VGND VPWR VPWR sky130_fd_sc_hd__diode_2
XANTENNA__6553__S _3148_ VGND VGND VPWR VPWR sky130_fd_sc_hd__diode_2
XANTENNA__7649__S _3742_ VGND VGND VPWR VPWR sky130_fd_sc_hd__diode_2
XFILLER_0_95_720 VGND VGND VPWR VPWR sky130_fd_sc_hd__fill_2
XFILLER_0_82_403 VGND VGND VPWR VPWR sky130_fd_sc_hd__fill_2
XFILLER_0_94_296 VGND VGND VPWR VPWR sky130_fd_sc_hd__fill_2
XFILLER_0_82_425 VGND VGND VPWR VPWR sky130_fd_sc_hd__fill_2
XFILLER_0_82_414 VGND VGND VPWR VPWR sky130_fd_sc_hd__fill_2
XFILLER_0_54_105 VGND VGND VPWR VPWR sky130_fd_sc_hd__fill_1
XFILLER_0_70_609 VGND VGND VPWR VPWR sky130_fd_sc_hd__decap_6
XFILLER_0_63_650 VGND VGND VPWR VPWR sky130_fd_sc_hd__fill_2
XFILLER_0_40_29 VGND VGND VPWR VPWR sky130_fd_sc_hd__fill_1
XANTENNA__7384__S _3574_ VGND VGND VPWR VPWR sky130_fd_sc_hd__diode_2
XTAP_TAPCELL_ROW_97_1522 VGND VPWR sky130_fd_sc_hd__tapvpwrvgnd_1
XANTENNA__4801__S _1513_ VGND VGND VPWR VPWR sky130_fd_sc_hd__diode_2
XFILLER_0_2_419 VGND VGND VPWR VPWR sky130_fd_sc_hd__fill_1
XFILLER_0_50_344 VGND VGND VPWR VPWR sky130_fd_sc_hd__decap_3
XFILLER_0_10_219 VGND VGND VPWR VPWR sky130_fd_sc_hd__fill_1
XFILLER_0_4_29 VGND VGND VPWR VPWR sky130_fd_sc_hd__decap_3
XTAP_TAPCELL_ROW_106_1640 VGND VPWR sky130_fd_sc_hd__tapvpwrvgnd_1
X_4990_ _1682_ VGND VGND VPWR VPWR _1752_ sky130_fd_sc_hd__buf_4
XFILLER_0_81_47 VGND VGND VPWR VPWR sky130_fd_sc_hd__decap_3
XTAP_TAPCELL_ROW_34_704 VGND VPWR sky130_fd_sc_hd__tapvpwrvgnd_1
XFILLER_0_58_444 VGND VGND VPWR VPWR sky130_fd_sc_hd__fill_2
XFILLER_0_46_639 VGND VGND VPWR VPWR sky130_fd_sc_hd__decap_3
XFILLER_0_45_127 VGND VGND VPWR VPWR sky130_fd_sc_hd__fill_2
X_6660_ registers\[0\]\[29\] _3022_ _3197_ VGND VGND VPWR VPWR _3207_ sky130_fd_sc_hd__mux2_1
XFILLER_0_18_319 VGND VGND VPWR VPWR sky130_fd_sc_hd__decap_4
X_5611_ _1051_ _2290_ VGND VGND VPWR VPWR _2346_ sky130_fd_sc_hd__nand2_1
XANTENNA__4989__S0 _1748_ VGND VGND VPWR VPWR sky130_fd_sc_hd__diode_2
XFILLER_0_73_447 VGND VGND VPWR VPWR sky130_fd_sc_hd__fill_1
XFILLER_0_6_725 VGND VGND VPWR VPWR sky130_fd_sc_hd__decap_8
X_6591_ _3169_ VGND VGND VPWR VPWR _0790_ sky130_fd_sc_hd__clkbuf_1
X_5542_ _2269_ _2273_ _2277_ VGND VGND VPWR VPWR _2278_ sky130_fd_sc_hd__o21ai_1
XFILLER_0_53_160 VGND VGND VPWR VPWR sky130_fd_sc_hd__fill_2
XANTENNA__7294__S _3561_ VGND VGND VPWR VPWR sky130_fd_sc_hd__diode_2
XANTENNA__4711__S _1362_ VGND VGND VPWR VPWR sky130_fd_sc_hd__diode_2
X_8330_ _3018_ registers\[31\]\[27\] _4103_ VGND VGND VPWR VPWR _4111_ sky130_fd_sc_hd__mux2_1
XFILLER_0_26_352 VGND VGND VPWR VPWR sky130_fd_sc_hd__decap_3
XFILLER_0_26_374 VGND VGND VPWR VPWR sky130_fd_sc_hd__fill_1
XFILLER_0_14_525 VGND VGND VPWR VPWR sky130_fd_sc_hd__fill_2
XFILLER_0_111_210 VPWR VGND VPWR VGND sky130_ef_sc_hd__decap_12
XTAP_TAPCELL_ROW_57_1005 VGND VPWR sky130_fd_sc_hd__tapvpwrvgnd_1
X_5473_ net127 net128 VGND VGND VPWR VPWR _2209_ sky130_fd_sc_hd__or2_2
X_8261_ _4074_ VGND VGND VPWR VPWR _0531_ sky130_fd_sc_hd__clkbuf_1
XTAP_TAPCELL_ROW_117_1780 VGND VPWR sky130_fd_sc_hd__tapvpwrvgnd_1
X_7212_ _3518_ VGND VGND VPWR VPWR _0038_ sky130_fd_sc_hd__clkbuf_1
X_4424_ registers\[4\]\[8\] registers\[5\]\[8\] registers\[6\]\[8\] registers\[7\]\[8\]
+ _1196_ _1202_ VGND VGND VPWR VPWR _1216_ sky130_fd_sc_hd__mux4_1
X_8192_ registers\[9\]\[26\] _3489_ _4031_ VGND VGND VPWR VPWR _4038_ sky130_fd_sc_hd__mux2_1
XFILLER_0_111_287 VGND VGND VPWR VPWR sky130_fd_sc_hd__fill_2
XFILLER_0_111_265 VGND VGND VPWR VPWR sky130_fd_sc_hd__decap_4
X_4355_ registers\[28\]\[5\] registers\[29\]\[5\] registers\[30\]\[5\] registers\[31\]\[5\]
+ _1111_ _1113_ VGND VGND VPWR VPWR _1150_ sky130_fd_sc_hd__mux4_1
X_7143_ _3475_ VGND VGND VPWR VPWR _0012_ sky130_fd_sc_hd__clkbuf_1
XFILLER_0_10_731 VGND VGND VPWR VPWR sky130_fd_sc_hd__fill_2
X_7074_ _3429_ VGND VGND VPWR VPWR _1013_ sky130_fd_sc_hd__clkbuf_1
X_4286_ net6 _1083_ _1024_ VGND VGND VPWR VPWR _1084_ sky130_fd_sc_hd__o21a_1
X_6025_ _1943_ _2709_ _2716_ _1959_ VGND VGND VPWR VPWR _2743_ sky130_fd_sc_hd__o22a_1
XFILLER_0_96_506 VGND VGND VPWR VPWR sky130_fd_sc_hd__fill_2
XANTENNA__7469__S _3648_ VGND VGND VPWR VPWR sky130_fd_sc_hd__diode_2
XANTENNA__6373__S _3030_ VGND VGND VPWR VPWR sky130_fd_sc_hd__diode_2
XTAP_TAPCELL_ROW_68_1145 VGND VPWR sky130_fd_sc_hd__tapvpwrvgnd_1
XANTENNA__7232__A1 _3483_ VGND VGND VPWR VPWR sky130_fd_sc_hd__diode_2
X_7976_ _3003_ registers\[28\]\[20\] _3923_ VGND VGND VPWR VPWR _3924_ sky130_fd_sc_hd__mux2_1
XFILLER_0_119_321 VGND VGND VPWR VPWR sky130_fd_sc_hd__fill_1
XTAP_TAPCELL_ROW_81_1312 VGND VPWR sky130_fd_sc_hd__tapvpwrvgnd_1
XFILLER_0_49_444 VGND VGND VPWR VPWR sky130_fd_sc_hd__fill_2
XFILLER_0_37_617 VGND VGND VPWR VPWR sky130_fd_sc_hd__fill_2
XFILLER_0_37_606 VGND VGND VPWR VPWR sky130_fd_sc_hd__fill_1
X_6927_ _3119_ registers\[13\]\[24\] _3346_ VGND VGND VPWR VPWR _3351_ sky130_fd_sc_hd__mux2_1
XFILLER_0_64_425 VGND VGND VPWR VPWR sky130_fd_sc_hd__fill_2
X_6858_ _3314_ VGND VGND VPWR VPWR _0912_ sky130_fd_sc_hd__clkbuf_1
XTAP_TAPCELL_ROW_12_409 VGND VPWR sky130_fd_sc_hd__tapvpwrvgnd_1
XFILLER_0_119_365 VPWR VGND VPWR VGND sky130_ef_sc_hd__decap_12
XFILLER_0_107_505 VGND VGND VPWR VPWR sky130_fd_sc_hd__decap_4
X_5809_ _1072_ _2447_ _2448_ VGND VGND VPWR VPWR _2538_ sky130_fd_sc_hd__o21a_1
XFILLER_0_76_296 VGND VGND VPWR VPWR sky130_fd_sc_hd__fill_2
XFILLER_0_9_596 VGND VGND VPWR VPWR sky130_fd_sc_hd__fill_2
XANTENNA__4621__S _1344_ VGND VGND VPWR VPWR sky130_fd_sc_hd__diode_2
XFILLER_0_45_650 VGND VGND VPWR VPWR sky130_fd_sc_hd__fill_2
X_8528_ registers\[4\]\[24\] net32 _4211_ VGND VGND VPWR VPWR _4216_ sky130_fd_sc_hd__mux2_1
X_6789_ registers\[11\]\[24\] _3012_ _3272_ VGND VGND VPWR VPWR _3277_ sky130_fd_sc_hd__mux2_1
XFILLER_0_91_299 VGND VGND VPWR VPWR sky130_fd_sc_hd__decap_3
XFILLER_0_60_642 VGND VGND VPWR VPWR sky130_fd_sc_hd__fill_2
XFILLER_0_17_396 VGND VGND VPWR VPWR sky130_fd_sc_hd__decap_6
XTAP_TAPCELL_ROW_79_1285 VGND VPWR sky130_fd_sc_hd__tapvpwrvgnd_1
X_8459_ _4179_ VGND VGND VPWR VPWR _0624_ sky130_fd_sc_hd__clkbuf_1
XFILLER_0_60_697 VGND VGND VPWR VPWR sky130_fd_sc_hd__decap_3
XFILLER_0_20_528 VGND VGND VPWR VPWR sky130_fd_sc_hd__fill_2
XANTENNA__5109__A1_N _1741_ VGND VGND VPWR VPWR sky130_fd_sc_hd__diode_2
XTAP_TAPCELL_ROW_92_1452 VGND VPWR sky130_fd_sc_hd__tapvpwrvgnd_1
XANTENNA__6548__S _3137_ VGND VGND VPWR VPWR sky130_fd_sc_hd__diode_2
XANTENNA__4904__S0 _1642_ VGND VGND VPWR VPWR sky130_fd_sc_hd__diode_2
XANTENNA__5688__A _2420_ VGND VGND VPWR VPWR sky130_fd_sc_hd__diode_2
XANTENNA__6283__S _2962_ VGND VGND VPWR VPWR sky130_fd_sc_hd__diode_2
XFILLER_0_59_208 VGND VGND VPWR VPWR sky130_fd_sc_hd__fill_2
XANTENNA_input10_A a3[1] VGND VGND VPWR VPWR sky130_fd_sc_hd__diode_2
XFILLER_0_67_241 VGND VGND VPWR VPWR sky130_fd_sc_hd__fill_2
XFILLER_0_51_17 VGND VGND VPWR VPWR sky130_fd_sc_hd__fill_2
XANTENNA__5880__S1 net113 VGND VGND VPWR VPWR sky130_fd_sc_hd__diode_2
XFILLER_0_55_425 VGND VGND VPWR VPWR sky130_fd_sc_hd__fill_2
XFILLER_0_55_414 VGND VGND VPWR VPWR sky130_fd_sc_hd__fill_2
XFILLER_0_55_447 VGND VGND VPWR VPWR sky130_fd_sc_hd__fill_1
XANTENNA__4531__S _1132_ VGND VGND VPWR VPWR sky130_fd_sc_hd__diode_2
XTAP_TAPCELL_ROW_101_1570 VGND VPWR sky130_fd_sc_hd__tapvpwrvgnd_1
XFILLER_0_70_428 VGND VGND VPWR VPWR sky130_fd_sc_hd__fill_1
Xclkload26 clknet_leaf_9_clk VGND VGND VPWR VPWR clkload26/Y sky130_fd_sc_hd__inv_6
Xclkload15 clknet_leaf_0_clk VGND VGND VPWR VPWR clkload15/Y sky130_fd_sc_hd__clkinvlp_2
Xclkload48 clknet_leaf_33_clk VGND VGND VPWR VPWR clkload48/Y sky130_fd_sc_hd__clkinv_4
Xclkload59 clknet_leaf_41_clk VGND VGND VPWR VPWR clkload59/Y sky130_fd_sc_hd__clkinv_4
Xclkload37 clknet_leaf_13_clk VGND VGND VPWR VPWR clkload37/Y sky130_fd_sc_hd__clkinvlp_2
XANTENNA__7842__S _3851_ VGND VGND VPWR VPWR sky130_fd_sc_hd__diode_2
XANTENNA__5362__S _2031_ VGND VGND VPWR VPWR sky130_fd_sc_hd__diode_2
XANTENNA__5148__S0 _1748_ VGND VGND VPWR VPWR sky130_fd_sc_hd__diode_2
X_7830_ _3846_ VGND VGND VPWR VPWR _0328_ sky130_fd_sc_hd__clkbuf_1
XANTENNA__7289__S _3550_ VGND VGND VPWR VPWR sky130_fd_sc_hd__diode_2
XFILLER_0_116_53 VGND VGND VPWR VPWR sky130_fd_sc_hd__decap_8
XTAP_TAPCELL_ROW_47_873 VGND VPWR sky130_fd_sc_hd__tapvpwrvgnd_1
XFILLER_0_25_40 VGND VGND VPWR VPWR sky130_fd_sc_hd__fill_2
X_4973_ registers\[4\]\[5\] registers\[5\]\[5\] registers\[6\]\[5\] registers\[7\]\[5\]
+ _1731_ _1691_ VGND VGND VPWR VPWR _1736_ sky130_fd_sc_hd__mux4_1
XFILLER_0_58_241 VGND VGND VPWR VPWR sky130_fd_sc_hd__decap_4
X_7761_ _3100_ registers\[25\]\[15\] _3804_ VGND VGND VPWR VPWR _3810_ sky130_fd_sc_hd__mux2_1
X_7692_ _3773_ VGND VGND VPWR VPWR _0263_ sky130_fd_sc_hd__clkbuf_1
XFILLER_0_46_425 VGND VGND VPWR VPWR sky130_fd_sc_hd__fill_2
X_6712_ _3213_ VGND VGND VPWR VPWR _3236_ sky130_fd_sc_hd__clkbuf_8
X_9500_ clknet_leaf_109_clk _0597_ VGND VGND VPWR VPWR registers\[5\]\[28\] sky130_fd_sc_hd__dfxtp_1
XANTENNA__6921__S _3346_ VGND VGND VPWR VPWR sky130_fd_sc_hd__diode_2
XFILLER_0_19_617 VGND VGND VPWR VPWR sky130_fd_sc_hd__fill_2
XTAP_TAPCELL_ROW_63_1075 VGND VPWR sky130_fd_sc_hd__tapvpwrvgnd_1
X_9431_ clknet_leaf_69_clk _0528_ VGND VGND VPWR VPWR registers\[6\]\[23\] sky130_fd_sc_hd__dfxtp_1
X_6643_ _3198_ VGND VGND VPWR VPWR _0813_ sky130_fd_sc_hd__clkbuf_1
XFILLER_0_6_533 VGND VGND VPWR VPWR sky130_fd_sc_hd__fill_2
Xclkload9 clknet_4_10_0_clk VGND VGND VPWR VPWR clkload9/X sky130_fd_sc_hd__clkbuf_8
XTAP_TAPCELL_ROW_119_1820 VGND VPWR sky130_fd_sc_hd__tapvpwrvgnd_1
X_9362_ clknet_leaf_67_clk _0459_ VGND VGND VPWR VPWR registers\[30\]\[18\] sky130_fd_sc_hd__dfxtp_1
XFILLER_0_42_631 VGND VGND VPWR VPWR sky130_fd_sc_hd__fill_2
XFILLER_0_14_300 VGND VGND VPWR VPWR sky130_fd_sc_hd__fill_2
X_6574_ registers\[7\]\[21\] _3006_ _3159_ VGND VGND VPWR VPWR _3161_ sky130_fd_sc_hd__mux2_1
X_9293_ clknet_leaf_56_clk _0390_ VGND VGND VPWR VPWR registers\[28\]\[13\] sky130_fd_sc_hd__dfxtp_1
X_5525_ _2258_ _2260_ VGND VGND VPWR VPWR _2261_ sky130_fd_sc_hd__nand2_1
X_8313_ _3001_ registers\[31\]\[19\] _4092_ VGND VGND VPWR VPWR _4102_ sky130_fd_sc_hd__mux2_1
XFILLER_0_42_642 VGND VGND VPWR VPWR sky130_fd_sc_hd__fill_2
XFILLER_0_41_141 VGND VGND VPWR VPWR sky130_fd_sc_hd__decap_3
XFILLER_0_14_333 VGND VGND VPWR VPWR sky130_fd_sc_hd__decap_3
XFILLER_0_74_3 VGND VGND VPWR VPWR sky130_fd_sc_hd__decap_4
X_8244_ _4065_ VGND VGND VPWR VPWR _0523_ sky130_fd_sc_hd__clkbuf_1
XFILLER_0_14_388 VGND VGND VPWR VPWR sky130_fd_sc_hd__decap_3
XFILLER_0_14_399 VGND VGND VPWR VPWR sky130_fd_sc_hd__fill_1
XANTENNA__5387__S0 _2126_ VGND VGND VPWR VPWR sky130_fd_sc_hd__diode_2
X_5456_ registers\[12\]\[31\] registers\[13\]\[31\] registers\[14\]\[31\] registers\[15\]\[31\]
+ _2126_ _2127_ VGND VGND VPWR VPWR _2193_ sky130_fd_sc_hd__mux4_1
X_4407_ registers\[4\]\[7\] registers\[5\]\[7\] registers\[6\]\[7\] registers\[7\]\[7\]
+ _1198_ _1199_ VGND VGND VPWR VPWR _1200_ sky130_fd_sc_hd__mux4_1
X_8175_ registers\[9\]\[18\] _3472_ _4020_ VGND VGND VPWR VPWR _4029_ sky130_fd_sc_hd__mux2_1
XFILLER_0_1_293 VGND VGND VPWR VPWR sky130_fd_sc_hd__decap_3
X_5387_ registers\[8\]\[27\] registers\[9\]\[27\] registers\[10\]\[27\] registers\[11\]\[27\]
+ _2126_ _2127_ VGND VGND VPWR VPWR _2128_ sky130_fd_sc_hd__mux4_1
X_7126_ net21 VGND VGND VPWR VPWR _3464_ sky130_fd_sc_hd__buf_2
X_4338_ _1124_ _1133_ VGND VGND VPWR VPWR _1134_ sky130_fd_sc_hd__nand2_1
XFILLER_0_5_72 VGND VGND VPWR VPWR sky130_fd_sc_hd__fill_2
X_4269_ _1066_ _1067_ _1030_ VGND VGND VPWR VPWR _1068_ sky130_fd_sc_hd__mux2_1
XANTENNA_input2_A a1[1] VGND VGND VPWR VPWR sky130_fd_sc_hd__diode_2
X_7057_ _3110_ registers\[15\]\[20\] _3420_ VGND VGND VPWR VPWR _3421_ sky130_fd_sc_hd__mux2_1
X_6008_ net135 _2725_ _2726_ VGND VGND VPWR VPWR _2727_ sky130_fd_sc_hd__o21ai_1
XANTENNA__7205__A1 _3455_ VGND VGND VPWR VPWR sky130_fd_sc_hd__diode_2
XFILLER_0_96_369 VGND VGND VPWR VPWR sky130_fd_sc_hd__fill_1
XFILLER_0_84_509 VGND VGND VPWR VPWR sky130_fd_sc_hd__fill_2
X_7959_ _2987_ registers\[28\]\[12\] _3912_ VGND VGND VPWR VPWR _3915_ sky130_fd_sc_hd__mux2_1
XFILLER_0_82_90 VGND VGND VPWR VPWR sky130_fd_sc_hd__fill_2
XANTENNA__6964__A0 _3087_ VGND VGND VPWR VPWR sky130_fd_sc_hd__diode_2
XANTENNA__5311__S0 _1762_ VGND VGND VPWR VPWR sky130_fd_sc_hd__diode_2
XFILLER_0_64_211 VGND VGND VPWR VPWR sky130_fd_sc_hd__fill_2
XFILLER_0_49_285 VGND VGND VPWR VPWR sky130_fd_sc_hd__fill_1
XTAP_TAPCELL_ROW_25_578 VGND VPWR sky130_fd_sc_hd__tapvpwrvgnd_1
XTAP_TAPCELL_ROW_25_589 VGND VPWR sky130_fd_sc_hd__tapvpwrvgnd_1
XFILLER_0_107_346 VGND VGND VPWR VPWR sky130_fd_sc_hd__decap_4
XFILLER_0_92_564 VGND VGND VPWR VPWR sky130_fd_sc_hd__decap_8
XFILLER_0_9_393 VGND VGND VPWR VPWR sky130_fd_sc_hd__fill_2
XFILLER_0_18_661 VGND VGND VPWR VPWR sky130_fd_sc_hd__fill_2
XFILLER_0_17_160 VGND VGND VPWR VPWR sky130_fd_sc_hd__fill_2
XFILLER_0_32_141 VGND VGND VPWR VPWR sky130_fd_sc_hd__fill_2
XANTENNA__7662__S _3757_ VGND VGND VPWR VPWR sky130_fd_sc_hd__diode_2
XFILLER_0_46_39 VGND VGND VPWR VPWR sky130_fd_sc_hd__fill_1
XANTENNA__5910__S net113 VGND VGND VPWR VPWR sky130_fd_sc_hd__diode_2
XANTENNA__5207__B1 _1778_ VGND VGND VPWR VPWR sky130_fd_sc_hd__diode_2
XANTENNA__6307__A net23 VGND VGND VPWR VPWR sky130_fd_sc_hd__diode_2
XFILLER_0_62_27 VGND VGND VPWR VPWR sky130_fd_sc_hd__fill_1
XFILLER_0_75_509 VGND VGND VPWR VPWR sky130_fd_sc_hd__fill_1
XTAP_TAPCELL_ROW_44_832 VGND VPWR sky130_fd_sc_hd__tapvpwrvgnd_1
XFILLER_0_56_701 VGND VGND VPWR VPWR sky130_fd_sc_hd__decap_3
XANTENNA__7837__S _3840_ VGND VGND VPWR VPWR sky130_fd_sc_hd__diode_2
XANTENNA__6741__S _3250_ VGND VGND VPWR VPWR sky130_fd_sc_hd__diode_2
XFILLER_0_83_575 VGND VGND VPWR VPWR sky130_fd_sc_hd__fill_1
XFILLER_0_70_203 VGND VGND VPWR VPWR sky130_fd_sc_hd__fill_2
XANTENNA__7138__A net25 VGND VGND VPWR VPWR sky130_fd_sc_hd__diode_2
XFILLER_0_55_277 VGND VGND VPWR VPWR sky130_fd_sc_hd__decap_3
Xclkload104 clknet_leaf_58_clk VGND VGND VPWR VPWR clkload104/Y sky130_fd_sc_hd__clkinvlp_4
XFILLER_0_43_439 VGND VGND VPWR VPWR sky130_fd_sc_hd__decap_3
XFILLER_0_113_305 VGND VGND VPWR VPWR sky130_fd_sc_hd__decap_3
XFILLER_0_102_77 VGND VGND VPWR VPWR sky130_fd_sc_hd__fill_2
XFILLER_0_102_66 VGND VGND VPWR VPWR sky130_fd_sc_hd__fill_2
XFILLER_0_70_269 VGND VGND VPWR VPWR sky130_fd_sc_hd__fill_1
XFILLER_0_3_525 VGND VGND VPWR VPWR sky130_fd_sc_hd__fill_1
X_6290_ registers\[19\]\[10\] _2982_ _2983_ VGND VGND VPWR VPWR _2984_ sky130_fd_sc_hd__mux2_1
X_5310_ _2051_ _2054_ _1687_ VGND VGND VPWR VPWR _2055_ sky130_fd_sc_hd__mux2_1
XFILLER_0_23_174 VGND VGND VPWR VPWR sky130_fd_sc_hd__fill_2
XANTENNA__7683__A1 _3455_ VGND VGND VPWR VPWR sky130_fd_sc_hd__diode_2
XANTENNA__4497__B2 _1153_ VGND VGND VPWR VPWR sky130_fd_sc_hd__diode_2
X_5241_ _1689_ _1989_ _1655_ VGND VGND VPWR VPWR _1990_ sky130_fd_sc_hd__o21a_1
X_5172_ registers\[8\]\[15\] registers\[9\]\[15\] registers\[10\]\[15\] registers\[11\]\[15\]
+ _1810_ _1811_ VGND VGND VPWR VPWR _1925_ sky130_fd_sc_hd__mux4_1
XANTENNA__4592__S1 _1339_ VGND VGND VPWR VPWR sky130_fd_sc_hd__diode_2
XANTENNA__6916__S _3335_ VGND VGND VPWR VPWR sky130_fd_sc_hd__diode_2
X_8931_ clknet_leaf_22_clk _0028_ VGND VGND VPWR VPWR registers\[17\]\[3\] sky130_fd_sc_hd__dfxtp_1
XANTENNA__4249__A1 net8 VGND VGND VPWR VPWR sky130_fd_sc_hd__diode_2
Xinput2 a1[1] VGND VGND VPWR VPWR net2 sky130_fd_sc_hd__buf_1
XFILLER_0_36_50 VGND VGND VPWR VPWR sky130_fd_sc_hd__fill_1
XTAP_TAPCELL_ROW_65_1104 VGND VPWR sky130_fd_sc_hd__tapvpwrvgnd_1
XANTENNA__4436__S _1031_ VGND VGND VPWR VPWR sky130_fd_sc_hd__diode_2
X_8862_ clknet_leaf_11_clk _0983_ VGND VGND VPWR VPWR registers\[14\]\[30\] sky130_fd_sc_hd__dfxtp_1
X_7813_ _3837_ VGND VGND VPWR VPWR _0320_ sky130_fd_sc_hd__clkbuf_1
X_8793_ clknet_leaf_81_clk _0914_ VGND VGND VPWR VPWR registers\[12\]\[25\] sky130_fd_sc_hd__dfxtp_1
XANTENNA__6946__A0 _3065_ VGND VGND VPWR VPWR sky130_fd_sc_hd__diode_2
X_7744_ _3083_ registers\[25\]\[7\] _3793_ VGND VGND VPWR VPWR _3801_ sky130_fd_sc_hd__mux2_1
XFILLER_0_59_561 VGND VGND VPWR VPWR sky130_fd_sc_hd__fill_2
XFILLER_0_46_200 VGND VGND VPWR VPWR sky130_fd_sc_hd__fill_2
XFILLER_0_86_391 VGND VGND VPWR VPWR sky130_fd_sc_hd__fill_1
X_4956_ _1629_ VGND VGND VPWR VPWR _1720_ sky130_fd_sc_hd__buf_4
X_7675_ _3764_ VGND VGND VPWR VPWR _0255_ sky130_fd_sc_hd__clkbuf_1
XFILLER_0_74_586 VGND VGND VPWR VPWR sky130_fd_sc_hd__fill_2
X_4887_ _1634_ _1653_ VGND VGND VPWR VPWR _1654_ sky130_fd_sc_hd__nand2_1
XFILLER_0_46_277 VGND VGND VPWR VPWR sky130_fd_sc_hd__fill_1
XANTENNA__5267__S _1768_ VGND VGND VPWR VPWR sky130_fd_sc_hd__diode_2
XTAP_TAPCELL_ROW_22_548 VGND VPWR sky130_fd_sc_hd__tapvpwrvgnd_1
X_9414_ clknet_leaf_36_clk _0511_ VGND VGND VPWR VPWR registers\[6\]\[6\] sky130_fd_sc_hd__dfxtp_1
X_6626_ _3189_ VGND VGND VPWR VPWR _0805_ sky130_fd_sc_hd__clkbuf_1
XFILLER_0_104_327 VGND VGND VPWR VPWR sky130_fd_sc_hd__fill_1
XFILLER_0_104_305 VGND VGND VPWR VPWR sky130_fd_sc_hd__decap_3
X_6557_ registers\[7\]\[13\] _2989_ _3148_ VGND VGND VPWR VPWR _3152_ sky130_fd_sc_hd__mux2_1
XFILLER_0_61_258 VGND VGND VPWR VPWR sky130_fd_sc_hd__fill_2
X_9345_ clknet_leaf_110_clk _0442_ VGND VGND VPWR VPWR registers\[30\]\[1\] sky130_fd_sc_hd__dfxtp_1
XFILLER_0_14_141 VGND VGND VPWR VPWR sky130_fd_sc_hd__decap_6
XFILLER_0_15_664 VGND VGND VPWR VPWR sky130_fd_sc_hd__fill_2
XANTENNA__7482__S _3659_ VGND VGND VPWR VPWR sky130_fd_sc_hd__diode_2
X_5508_ _2241_ _2243_ VGND VGND VPWR VPWR _2244_ sky130_fd_sc_hd__nand2_1
XANTENNA__5791__A _1740_ VGND VGND VPWR VPWR sky130_fd_sc_hd__diode_2
XFILLER_0_42_472 VGND VGND VPWR VPWR sky130_fd_sc_hd__decap_4
XFILLER_0_14_163 VGND VGND VPWR VPWR sky130_fd_sc_hd__fill_1
XANTENNA__4280__S0 _1060_ VGND VGND VPWR VPWR sky130_fd_sc_hd__diode_2
XFILLER_0_30_601 VGND VGND VPWR VPWR sky130_fd_sc_hd__fill_2
XTAP_TAPCELL_ROW_76_1244 VGND VPWR sky130_fd_sc_hd__tapvpwrvgnd_1
X_6488_ _3108_ registers\[29\]\[19\] _3090_ VGND VGND VPWR VPWR _3109_ sky130_fd_sc_hd__mux2_1
XFILLER_0_42_494 VGND VGND VPWR VPWR sky130_fd_sc_hd__fill_2
X_9276_ clknet_leaf_103_clk _0373_ VGND VGND VPWR VPWR registers\[27\]\[28\] sky130_fd_sc_hd__dfxtp_1
X_8227_ registers\[6\]\[10\] _3455_ _4056_ VGND VGND VPWR VPWR _4057_ sky130_fd_sc_hd__mux2_1
XANTENNA__7674__A1 _3447_ VGND VGND VPWR VPWR sky130_fd_sc_hd__diode_2
XANTENNA__6098__S _2460_ VGND VGND VPWR VPWR sky130_fd_sc_hd__diode_2
X_5439_ _1768_ _2176_ _1754_ VGND VGND VPWR VPWR _2177_ sky130_fd_sc_hd__a21o_1
X_8158_ _4008_ VGND VGND VPWR VPWR _4020_ sky130_fd_sc_hd__clkbuf_8
X_7109_ _3452_ VGND VGND VPWR VPWR _0001_ sky130_fd_sc_hd__clkbuf_1
XANTENNA__7426__A1 _3472_ VGND VGND VPWR VPWR sky130_fd_sc_hd__diode_2
X_8089_ _3983_ VGND VGND VPWR VPWR _0450_ sky130_fd_sc_hd__clkbuf_1
XTAP_TAPCELL_ROW_87_1395 VGND VPWR sky130_fd_sc_hd__tapvpwrvgnd_1
XTAP_TAPCELL_ROW_87_1384 VGND VPWR sky130_fd_sc_hd__tapvpwrvgnd_1
XTAP_TAPCELL_ROW_2_284 VGND VPWR sky130_fd_sc_hd__tapvpwrvgnd_1
XANTENNA__6561__S _3148_ VGND VGND VPWR VPWR sky130_fd_sc_hd__diode_2
XANTENNA__7657__S _3719_ VGND VGND VPWR VPWR sky130_fd_sc_hd__diode_2
XFILLER_0_84_339 VGND VGND VPWR VPWR sky130_fd_sc_hd__decap_3
XFILLER_0_65_553 VGND VGND VPWR VPWR sky130_fd_sc_hd__decap_6
XANTENNA__6165__A1 _2084_ VGND VGND VPWR VPWR sky130_fd_sc_hd__diode_2
XANTENNA__6165__B2 _2101_ VGND VGND VPWR VPWR sky130_fd_sc_hd__diode_2
XFILLER_0_37_299 VGND VGND VPWR VPWR sky130_fd_sc_hd__decap_8
XFILLER_0_9_190 VGND VGND VPWR VPWR sky130_fd_sc_hd__fill_2
XANTENNA__8488__S _4189_ VGND VGND VPWR VPWR sky130_fd_sc_hd__diode_2
XFILLER_0_108_688 VGND VGND VPWR VPWR sky130_fd_sc_hd__fill_2
XANTENNA__5912__A1 net124 VGND VGND VPWR VPWR sky130_fd_sc_hd__diode_2
XFILLER_0_21_645 VGND VGND VPWR VPWR sky130_fd_sc_hd__fill_2
XFILLER_0_103_393 VGND VGND VPWR VPWR sky130_fd_sc_hd__decap_3
XANTENNA__5125__C1 _1778_ VGND VGND VPWR VPWR sky130_fd_sc_hd__diode_2
XFILLER_0_57_27 VGND VGND VPWR VPWR sky130_fd_sc_hd__fill_2
XFILLER_0_20_188 VGND VGND VPWR VPWR sky130_fd_sc_hd__fill_2
XANTENNA__4574__S1 _1161_ VGND VGND VPWR VPWR sky130_fd_sc_hd__diode_2
XTAP_TAPCELL_ROW_49_902 VGND VPWR sky130_fd_sc_hd__tapvpwrvgnd_1
XANTENNA__5428__B1 _1960_ VGND VGND VPWR VPWR sky130_fd_sc_hd__diode_2
XFILLER_0_88_645 VGND VGND VPWR VPWR sky130_fd_sc_hd__fill_2
XFILLER_0_87_188 VGND VGND VPWR VPWR sky130_fd_sc_hd__fill_2
XANTENNA__7567__S _3706_ VGND VGND VPWR VPWR sky130_fd_sc_hd__diode_2
X_4810_ registers\[8\]\[29\] registers\[9\]\[29\] registers\[10\]\[29\] registers\[11\]\[29\]
+ _1550_ _1551_ VGND VGND VPWR VPWR _1581_ sky130_fd_sc_hd__mux4_1
X_5790_ _2518_ _2519_ VGND VGND VPWR VPWR _2520_ sky130_fd_sc_hd__nor2_1
XANTENNA__5087__S _1809_ VGND VGND VPWR VPWR sky130_fd_sc_hd__diode_2
XFILLER_0_90_309 VGND VGND VPWR VPWR sky130_fd_sc_hd__fill_1
XTAP_TAPCELL_ROW_60_1034 VGND VPWR sky130_fd_sc_hd__tapvpwrvgnd_1
XFILLER_0_7_127 VGND VGND VPWR VPWR sky130_fd_sc_hd__fill_2
X_4741_ _1159_ _1510_ _1512_ _1515_ _1109_ VGND VGND VPWR VPWR _1516_ sky130_fd_sc_hd__o221a_1
XFILLER_0_113_87 VGND VGND VPWR VPWR sky130_fd_sc_hd__fill_2
XFILLER_0_83_372 VGND VGND VPWR VPWR sky130_fd_sc_hd__decap_3
XFILLER_0_71_534 VGND VGND VPWR VPWR sky130_fd_sc_hd__fill_2
XTAP_TAPCELL_ROW_60_1045 VGND VPWR sky130_fd_sc_hd__tapvpwrvgnd_1
X_7460_ _3650_ VGND VGND VPWR VPWR _0154_ sky130_fd_sc_hd__clkbuf_1
X_4672_ registers\[0\]\[21\] registers\[1\]\[21\] registers\[2\]\[21\] registers\[3\]\[21\]
+ _1382_ _1383_ VGND VGND VPWR VPWR _1451_ sky130_fd_sc_hd__mux4_1
XFILLER_0_113_113 VGND VGND VPWR VPWR sky130_fd_sc_hd__fill_1
XFILLER_0_71_567 VGND VGND VPWR VPWR sky130_fd_sc_hd__fill_2
X_6411_ registers\[3\]\[25\] _3014_ _3052_ VGND VGND VPWR VPWR _3058_ sky130_fd_sc_hd__mux2_1
XANTENNA__8398__S _4139_ VGND VGND VPWR VPWR sky130_fd_sc_hd__diode_2
X_9130_ clknet_leaf_37_clk _0227_ VGND VGND VPWR VPWR registers\[23\]\[10\] sky130_fd_sc_hd__dfxtp_1
XFILLER_0_114_669 VPWR VGND VPWR VGND sky130_ef_sc_hd__decap_12
XFILLER_0_12_612 VGND VGND VPWR VPWR sky130_fd_sc_hd__fill_2
X_7391_ registers\[20\]\[1\] _3437_ _3612_ VGND VGND VPWR VPWR _3614_ sky130_fd_sc_hd__mux2_1
XANTENNA__6500__A net31 VGND VGND VPWR VPWR sky130_fd_sc_hd__diode_2
XFILLER_0_11_100 VGND VGND VPWR VPWR sky130_fd_sc_hd__fill_2
XFILLER_0_11_122 VGND VGND VPWR VPWR sky130_fd_sc_hd__decap_8
XFILLER_0_12_634 VGND VGND VPWR VPWR sky130_fd_sc_hd__fill_2
X_6342_ registers\[19\]\[27\] _3018_ _3004_ VGND VGND VPWR VPWR _3019_ sky130_fd_sc_hd__mux2_1
X_6273_ net43 VGND VGND VPWR VPWR _2972_ sky130_fd_sc_hd__buf_2
XTAP_TAPCELL_ROW_112_1709 VGND VPWR sky130_fd_sc_hd__tapvpwrvgnd_1
X_9061_ clknet_leaf_27_clk _0158_ VGND VGND VPWR VPWR registers\[21\]\[5\] sky130_fd_sc_hd__dfxtp_1
X_8012_ registers\[2\]\[5\] _3445_ _3937_ VGND VGND VPWR VPWR _3943_ sky130_fd_sc_hd__mux2_1
X_5224_ registers\[4\]\[18\] registers\[5\]\[18\] registers\[6\]\[18\] registers\[7\]\[18\]
+ _1758_ _1760_ VGND VGND VPWR VPWR _1974_ sky130_fd_sc_hd__mux4_1
XANTENNA__4565__S1 _1348_ VGND VGND VPWR VPWR sky130_fd_sc_hd__diode_2
XANTENNA__5550__S _1072_ VGND VGND VPWR VPWR sky130_fd_sc_hd__diode_2
X_5155_ _1767_ _1908_ VGND VGND VPWR VPWR _1909_ sky130_fd_sc_hd__or2_1
XANTENNA__4955__A _1628_ VGND VGND VPWR VPWR sky130_fd_sc_hd__diode_2
XTAP_TAPCELL_ROW_71_1185 VGND VPWR sky130_fd_sc_hd__tapvpwrvgnd_1
XFILLER_0_47_71 VGND VGND VPWR VPWR sky130_fd_sc_hd__fill_2
XANTENNA__6646__S _3197_ VGND VGND VPWR VPWR sky130_fd_sc_hd__diode_2
XFILLER_0_37_3 VGND VGND VPWR VPWR sky130_fd_sc_hd__fill_1
X_5086_ registers\[12\]\[10\] registers\[13\]\[10\] registers\[14\]\[10\] registers\[15\]\[10\]
+ _1773_ _1775_ VGND VGND VPWR VPWR _1844_ sky130_fd_sc_hd__mux4_1
X_8914_ clknet_leaf_61_clk _0011_ VGND VGND VPWR VPWR registers\[16\]\[18\] sky130_fd_sc_hd__dfxtp_1
XTAP_TAPCELL_ROW_27_607 VGND VPWR sky130_fd_sc_hd__tapvpwrvgnd_1
X_8845_ clknet_leaf_50_clk _0966_ VGND VGND VPWR VPWR registers\[14\]\[13\] sky130_fd_sc_hd__dfxtp_1
XFILLER_0_2_73 VGND VGND VPWR VPWR sky130_fd_sc_hd__decap_8
XANTENNA__6919__A0 _3110_ VGND VGND VPWR VPWR sky130_fd_sc_hd__diode_2
XFILLER_0_78_177 VGND VGND VPWR VPWR sky130_fd_sc_hd__fill_1
X_8776_ clknet_leaf_18_clk _0897_ VGND VGND VPWR VPWR registers\[12\]\[8\] sky130_fd_sc_hd__dfxtp_1
X_5988_ _2205_ _2706_ _2707_ VGND VGND VPWR VPWR _2708_ sky130_fd_sc_hd__a21oi_1
XFILLER_0_47_531 VGND VGND VPWR VPWR sky130_fd_sc_hd__decap_3
XFILLER_0_93_169 VGND VGND VPWR VPWR sky130_fd_sc_hd__decap_3
X_4939_ _1677_ _1688_ _1703_ VGND VGND VPWR VPWR _1704_ sky130_fd_sc_hd__o21ai_4
X_7727_ _3791_ VGND VGND VPWR VPWR _0280_ sky130_fd_sc_hd__clkbuf_1
XFILLER_0_117_441 VGND VGND VPWR VPWR sky130_fd_sc_hd__decap_3
XFILLER_0_74_361 VGND VGND VPWR VPWR sky130_fd_sc_hd__fill_1
XFILLER_0_62_523 VGND VGND VPWR VPWR sky130_fd_sc_hd__fill_2
X_7658_ _3754_ VGND VGND VPWR VPWR _0248_ sky130_fd_sc_hd__clkbuf_1
X_6609_ _3180_ VGND VGND VPWR VPWR _0797_ sky130_fd_sc_hd__clkbuf_1
XFILLER_0_34_247 VGND VGND VPWR VPWR sky130_fd_sc_hd__decap_3
XFILLER_0_62_589 VGND VGND VPWR VPWR sky130_fd_sc_hd__fill_2
XFILLER_0_22_409 VGND VGND VPWR VPWR sky130_fd_sc_hd__fill_2
X_7589_ _3133_ registers\[22\]\[31\] _3683_ VGND VGND VPWR VPWR _3718_ sky130_fd_sc_hd__mux2_1
XANTENNA__8101__S _3984_ VGND VGND VPWR VPWR sky130_fd_sc_hd__diode_2
X_9328_ clknet_leaf_65_clk _0425_ VGND VGND VPWR VPWR registers\[2\]\[16\] sky130_fd_sc_hd__dfxtp_1
X_9259_ clknet_leaf_59_clk _0356_ VGND VGND VPWR VPWR registers\[27\]\[11\] sky130_fd_sc_hd__dfxtp_1
XFILLER_0_30_453 VGND VGND VPWR VPWR sky130_fd_sc_hd__fill_2
XANTENNA__7940__S _3901_ VGND VGND VPWR VPWR sky130_fd_sc_hd__diode_2
XFILLER_0_100_363 VGND VGND VPWR VPWR sky130_fd_sc_hd__fill_1
XANTENNA__4556__S1 _1339_ VGND VGND VPWR VPWR sky130_fd_sc_hd__diode_2
XTAP_TAPCELL_ROW_7_354 VGND VPWR sky130_fd_sc_hd__tapvpwrvgnd_1
XTAP_TAPCELL_ROW_89_1413 VGND VPWR sky130_fd_sc_hd__tapvpwrvgnd_1
XFILLER_0_27_19 VGND VGND VPWR VPWR sky130_fd_sc_hd__fill_1
XANTENNA__4865__A _1631_ VGND VGND VPWR VPWR sky130_fd_sc_hd__diode_2
XANTENNA__5467__D_N _1270_ VGND VGND VPWR VPWR sky130_fd_sc_hd__diode_2
XFILLER_0_97_442 VGND VGND VPWR VPWR sky130_fd_sc_hd__decap_3
XFILLER_0_85_615 VGND VGND VPWR VPWR sky130_fd_sc_hd__fill_1
XANTENNA__5696__A _2328_ VGND VGND VPWR VPWR sky130_fd_sc_hd__diode_2
XANTENNA__6386__A1 _2989_ VGND VGND VPWR VPWR sky130_fd_sc_hd__diode_2
XFILLER_0_69_199 VGND VGND VPWR VPWR sky130_fd_sc_hd__decap_4
XTAP_TAPCELL_ROW_54_960 VGND VPWR sky130_fd_sc_hd__tapvpwrvgnd_1
XANTENNA__4804__S _1513_ VGND VGND VPWR VPWR sky130_fd_sc_hd__diode_2
XANTENNA__4492__S0 _1201_ VGND VGND VPWR VPWR sky130_fd_sc_hd__diode_2
XFILLER_0_65_372 VGND VGND VPWR VPWR sky130_fd_sc_hd__fill_1
XFILLER_0_25_214 VGND VGND VPWR VPWR sky130_fd_sc_hd__fill_2
XFILLER_0_25_225 VGND VGND VPWR VPWR sky130_fd_sc_hd__fill_2
XFILLER_0_92_191 VGND VGND VPWR VPWR sky130_fd_sc_hd__decap_4
XFILLER_0_80_353 VGND VGND VPWR VPWR sky130_fd_sc_hd__decap_8
XFILLER_0_41_707 VGND VGND VPWR VPWR sky130_fd_sc_hd__fill_2
XFILLER_0_25_236 VGND VGND VPWR VPWR sky130_fd_sc_hd__decap_4
XFILLER_0_25_247 VGND VGND VPWR VPWR sky130_fd_sc_hd__fill_2
XANTENNA__6320__A _2961_ VGND VGND VPWR VPWR sky130_fd_sc_hd__diode_2
XFILLER_0_110_138 VGND VGND VPWR VPWR sky130_fd_sc_hd__fill_2
XFILLER_0_21_453 VGND VGND VPWR VPWR sky130_fd_sc_hd__decap_3
XANTENNA_output89_A net89 VGND VGND VPWR VPWR sky130_fd_sc_hd__diode_2
XANTENNA__7850__S _3851_ VGND VGND VPWR VPWR sky130_fd_sc_hd__diode_2
XFILLER_0_108_10 VGND VGND VPWR VPWR sky130_fd_sc_hd__fill_2
XANTENNA__7151__A net30 VGND VGND VPWR VPWR sky130_fd_sc_hd__diode_2
XFILLER_0_17_30 VGND VGND VPWR VPWR sky130_fd_sc_hd__fill_2
X_6960_ _3083_ registers\[14\]\[7\] _3361_ VGND VGND VPWR VPWR _3369_ sky130_fd_sc_hd__mux2_1
XTAP_TAPCELL_ROW_109_1682 VGND VPWR sky130_fd_sc_hd__tapvpwrvgnd_1
XTAP_TAPCELL_ROW_109_1671 VGND VPWR sky130_fd_sc_hd__tapvpwrvgnd_1
X_5911_ _2352_ _2634_ VGND VGND VPWR VPWR _2635_ sky130_fd_sc_hd__or2_1
XFILLER_0_17_96 VGND VGND VPWR VPWR sky130_fd_sc_hd__fill_2
XFILLER_0_88_486 VGND VGND VPWR VPWR sky130_fd_sc_hd__decap_3
X_6891_ _3083_ registers\[13\]\[7\] _3324_ VGND VGND VPWR VPWR _3332_ sky130_fd_sc_hd__mux2_1
XFILLER_0_76_626 VGND VGND VPWR VPWR sky130_fd_sc_hd__fill_2
XFILLER_0_76_604 VGND VGND VPWR VPWR sky130_fd_sc_hd__decap_3
X_5842_ _2445_ _2317_ VGND VGND VPWR VPWR _2570_ sky130_fd_sc_hd__or2_2
XANTENNA__6377__A1 _2980_ VGND VGND VPWR VPWR sky130_fd_sc_hd__diode_2
XANTENNA__4714__S _1344_ VGND VGND VPWR VPWR sky130_fd_sc_hd__diode_2
X_8630_ clknet_leaf_94_clk _0751_ VGND VGND VPWR VPWR registers\[29\]\[22\] sky130_fd_sc_hd__dfxtp_1
X_5773_ _2410_ _2412_ net135 VGND VGND VPWR VPWR _2503_ sky130_fd_sc_hd__mux2_1
X_8561_ clknet_leaf_55_clk _0682_ VGND VGND VPWR VPWR registers\[19\]\[17\] sky130_fd_sc_hd__dfxtp_1
XFILLER_0_8_414 VGND VGND VPWR VPWR sky130_fd_sc_hd__decap_3
XFILLER_0_29_553 VGND VGND VPWR VPWR sky130_fd_sc_hd__fill_2
XFILLER_0_33_84 VGND VGND VPWR VPWR sky130_fd_sc_hd__fill_2
XANTENNA__4483__S0 _1111_ VGND VGND VPWR VPWR sky130_fd_sc_hd__diode_2
XFILLER_0_56_361 VGND VGND VPWR VPWR sky130_fd_sc_hd__decap_3
XFILLER_0_44_501 VGND VGND VPWR VPWR sky130_fd_sc_hd__decap_3
X_4724_ _1438_ _1491_ _1495_ _1499_ VGND VGND VPWR VPWR _1500_ sky130_fd_sc_hd__o2bb2a_2
XANTENNA_clkbuf_4_8_0_clk_A clknet_0_clk VGND VGND VPWR VPWR sky130_fd_sc_hd__diode_2
X_7512_ _3677_ VGND VGND VPWR VPWR _0179_ sky130_fd_sc_hd__clkbuf_1
X_8492_ registers\[4\]\[7\] net45 _4189_ VGND VGND VPWR VPWR _4197_ sky130_fd_sc_hd__mux2_1
XFILLER_0_44_545 VGND VGND VPWR VPWR sky130_fd_sc_hd__fill_2
XFILLER_0_16_247 VGND VGND VPWR VPWR sky130_fd_sc_hd__fill_2
XTAP_TAPCELL_ROW_32_676 VGND VPWR sky130_fd_sc_hd__tapvpwrvgnd_1
XFILLER_0_44_589 VGND VGND VPWR VPWR sky130_fd_sc_hd__fill_2
XANTENNA__4235__S0 _1026_ VGND VGND VPWR VPWR sky130_fd_sc_hd__diode_2
X_7443_ registers\[20\]\[26\] _3489_ _3634_ VGND VGND VPWR VPWR _3641_ sky130_fd_sc_hd__mux2_1
X_4655_ registers\[4\]\[20\] registers\[5\]\[20\] registers\[6\]\[20\] registers\[7\]\[20\]
+ _1433_ _1434_ VGND VGND VPWR VPWR _1435_ sky130_fd_sc_hd__mux4_1
X_4586_ _1367_ _1368_ _1148_ VGND VGND VPWR VPWR _1369_ sky130_fd_sc_hd__mux2_1
XANTENNA__4786__S1 _1556_ VGND VGND VPWR VPWR sky130_fd_sc_hd__diode_2
X_7374_ registers\[1\]\[26\] _3489_ _3597_ VGND VGND VPWR VPWR _3604_ sky130_fd_sc_hd__mux2_1
XFILLER_0_102_639 VGND VGND VPWR VPWR sky130_fd_sc_hd__fill_2
XTAP_TAPCELL_ROW_73_1214 VGND VPWR sky130_fd_sc_hd__tapvpwrvgnd_1
XTAP_TAPCELL_ROW_73_1203 VGND VPWR sky130_fd_sc_hd__tapvpwrvgnd_1
X_9113_ clknet_leaf_80_clk _0210_ VGND VGND VPWR VPWR registers\[22\]\[25\] sky130_fd_sc_hd__dfxtp_1
XFILLER_0_12_464 VGND VGND VPWR VPWR sky130_fd_sc_hd__fill_2
X_6325_ _3007_ VGND VGND VPWR VPWR _0686_ sky130_fd_sc_hd__clkbuf_1
X_9044_ clknet_leaf_74_clk _0141_ VGND VGND VPWR VPWR registers\[20\]\[20\] sky130_fd_sc_hd__dfxtp_1
X_6256_ net10 net9 net48 VGND VGND VPWR VPWR _2960_ sky130_fd_sc_hd__nand3_4
X_6187_ _2490_ _2765_ VGND VGND VPWR VPWR _2895_ sky130_fd_sc_hd__nor2_1
X_5207_ _1771_ _1957_ _1778_ VGND VGND VPWR VPWR _1958_ sky130_fd_sc_hd__a21oi_1
XTAP_TAPCELL_ROW_4_313 VGND VPWR sky130_fd_sc_hd__tapvpwrvgnd_1
XFILLER_0_99_718 VGND VGND VPWR VPWR sky130_fd_sc_hd__fill_2
X_5138_ _1891_ _1892_ _1809_ VGND VGND VPWR VPWR _1893_ sky130_fd_sc_hd__mux2_1
XANTENNA__8054__A1 _3487_ VGND VGND VPWR VPWR sky130_fd_sc_hd__diode_2
XFILLER_0_98_239 VGND VGND VPWR VPWR sky130_fd_sc_hd__fill_2
XFILLER_0_98_217 VGND VGND VPWR VPWR sky130_fd_sc_hd__decap_3
XFILLER_0_74_80 VGND VGND VPWR VPWR sky130_fd_sc_hd__fill_2
X_5069_ _1752_ _1827_ VGND VGND VPWR VPWR _1828_ sky130_fd_sc_hd__or2_1
XFILLER_0_79_475 VGND VGND VPWR VPWR sky130_fd_sc_hd__fill_2
XANTENNA__4710__S1 _1419_ VGND VGND VPWR VPWR sky130_fd_sc_hd__diode_2
XFILLER_0_94_434 VGND VGND VPWR VPWR sky130_fd_sc_hd__fill_2
XTAP_TAPCELL_ROW_84_1354 VGND VPWR sky130_fd_sc_hd__tapvpwrvgnd_1
X_8828_ clknet_leaf_104_clk _0949_ VGND VGND VPWR VPWR registers\[13\]\[28\] sky130_fd_sc_hd__dfxtp_1
XANTENNA__7000__S _3383_ VGND VGND VPWR VPWR sky130_fd_sc_hd__diode_2
XFILLER_0_109_216 VGND VGND VPWR VPWR sky130_fd_sc_hd__decap_3
XFILLER_0_94_467 VGND VGND VPWR VPWR sky130_fd_sc_hd__fill_2
XFILLER_0_54_309 VGND VGND VPWR VPWR sky130_fd_sc_hd__decap_3
X_8759_ clknet_leaf_69_clk _0880_ VGND VGND VPWR VPWR registers\[11\]\[23\] sky130_fd_sc_hd__dfxtp_1
XFILLER_0_47_361 VGND VGND VPWR VPWR sky130_fd_sc_hd__fill_1
XFILLER_0_105_411 VGND VGND VPWR VPWR sky130_fd_sc_hd__decap_4
XFILLER_0_74_191 VGND VGND VPWR VPWR sky130_fd_sc_hd__fill_2
XFILLER_0_62_353 VGND VGND VPWR VPWR sky130_fd_sc_hd__decap_4
XFILLER_0_23_729 VGND VGND VPWR VPWR sky130_fd_sc_hd__fill_1
XANTENNA__6540__A1 _2972_ VGND VGND VPWR VPWR sky130_fd_sc_hd__diode_2
XFILLER_0_105_477 VGND VGND VPWR VPWR sky130_fd_sc_hd__fill_2
XFILLER_0_62_386 VGND VGND VPWR VPWR sky130_fd_sc_hd__fill_2
XFILLER_0_101_650 VGND VGND VPWR VPWR sky130_fd_sc_hd__decap_4
XTAP_TAPCELL_ROW_95_1494 VGND VPWR sky130_fd_sc_hd__tapvpwrvgnd_1
XANTENNA__7670__S _3757_ VGND VGND VPWR VPWR sky130_fd_sc_hd__diode_2
XANTENNA__4529__S1 _1199_ VGND VGND VPWR VPWR sky130_fd_sc_hd__diode_2
XFILLER_0_101_683 VPWR VGND VPWR VGND sky130_ef_sc_hd__decap_12
XANTENNA_input40_A wd3[31] VGND VGND VPWR VPWR sky130_fd_sc_hd__diode_2
XFILLER_0_38_29 VGND VGND VPWR VPWR sky130_fd_sc_hd__fill_2
XANTENNA__6286__S _2962_ VGND VGND VPWR VPWR sky130_fd_sc_hd__diode_2
XFILLER_0_57_103 VGND VGND VPWR VPWR sky130_fd_sc_hd__decap_3
XANTENNA__6359__A1 _2958_ VGND VGND VPWR VPWR sky130_fd_sc_hd__diode_2
XANTENNA__8006__S _3937_ VGND VGND VPWR VPWR sky130_fd_sc_hd__diode_2
XFILLER_0_57_169 VGND VGND VPWR VPWR sky130_fd_sc_hd__decap_3
XFILLER_0_72_106 VGND VGND VPWR VPWR sky130_fd_sc_hd__fill_2
XFILLER_0_26_512 VGND VGND VPWR VPWR sky130_fd_sc_hd__fill_2
XANTENNA__5582__A2 _2270_ VGND VGND VPWR VPWR sky130_fd_sc_hd__diode_2
XFILLER_0_53_331 VGND VGND VPWR VPWR sky130_fd_sc_hd__decap_3
XFILLER_0_5_428 VGND VGND VPWR VPWR sky130_fd_sc_hd__fill_2
XFILLER_0_5_406 VGND VGND VPWR VPWR sky130_fd_sc_hd__fill_2
XFILLER_0_53_364 VGND VGND VPWR VPWR sky130_fd_sc_hd__fill_1
XANTENNA__5365__S _2031_ VGND VGND VPWR VPWR sky130_fd_sc_hd__diode_2
XFILLER_0_26_589 VGND VGND VPWR VPWR sky130_fd_sc_hd__decap_4
XFILLER_0_110_33 VGND VGND VPWR VPWR sky130_fd_sc_hd__decap_6
XFILLER_0_110_22 VGND VGND VPWR VPWR sky130_fd_sc_hd__fill_2
XANTENNA__6050__A net139 VGND VGND VPWR VPWR sky130_fd_sc_hd__diode_2
XFILLER_0_80_194 VGND VGND VPWR VPWR sky130_fd_sc_hd__fill_2
X_4440_ _1227_ _1230_ _1034_ VGND VGND VPWR VPWR _1231_ sky130_fd_sc_hd__mux2_1
XFILLER_0_41_559 VGND VGND VPWR VPWR sky130_fd_sc_hd__fill_1
XANTENNA__4768__S1 _1383_ VGND VGND VPWR VPWR sky130_fd_sc_hd__diode_2
X_4371_ _1109_ _1154_ _1158_ _1165_ VGND VGND VPWR VPWR _1166_ sky130_fd_sc_hd__a2bb2o_4
X_6110_ _2822_ _2806_ VGND VGND VPWR VPWR _2823_ sky130_fd_sc_hd__nor2_1
XFILLER_0_1_667 VGND VGND VPWR VPWR sky130_fd_sc_hd__fill_2
XFILLER_0_21_250 VGND VGND VPWR VPWR sky130_fd_sc_hd__fill_2
XFILLER_0_95_57 VGND VGND VPWR VPWR sky130_fd_sc_hd__fill_2
XFILLER_0_0_188 VGND VGND VPWR VPWR sky130_fd_sc_hd__fill_2
XFILLER_0_1_689 VGND VGND VPWR VPWR sky130_fd_sc_hd__fill_2
X_7090_ registers\[16\]\[2\] _3439_ _3435_ VGND VGND VPWR VPWR _3440_ sky130_fd_sc_hd__mux2_1
XFILLER_0_119_53 VGND VGND VPWR VPWR sky130_fd_sc_hd__decap_3
XANTENNA__5193__S1 _1814_ VGND VGND VPWR VPWR sky130_fd_sc_hd__diode_2
X_6041_ _2724_ _2757_ _2352_ VGND VGND VPWR VPWR _2758_ sky130_fd_sc_hd__mux2_1
XFILLER_0_119_97 VPWR VGND VPWR VGND sky130_ef_sc_hd__decap_12
XFILLER_0_28_51 VGND VGND VPWR VPWR sky130_fd_sc_hd__fill_2
XFILLER_0_28_73 VGND VGND VPWR VPWR sky130_fd_sc_hd__fill_2
XANTENNA__4845__A1 _1381_ VGND VGND VPWR VPWR sky130_fd_sc_hd__diode_2
X_7992_ _3020_ registers\[28\]\[28\] _3923_ VGND VGND VPWR VPWR _3932_ sky130_fd_sc_hd__mux2_1
X_6943_ net9 _3211_ VGND VGND VPWR VPWR _3359_ sky130_fd_sc_hd__nor2_4
XTAP_TAPCELL_ROW_37_746 VGND VPWR sky130_fd_sc_hd__tapvpwrvgnd_1
XTAP_TAPCELL_ROW_37_735 VGND VPWR sky130_fd_sc_hd__tapvpwrvgnd_1
X_6874_ _3322_ VGND VGND VPWR VPWR _0920_ sky130_fd_sc_hd__clkbuf_1
X_8613_ clknet_leaf_26_clk _0734_ VGND VGND VPWR VPWR registers\[29\]\[5\] sky130_fd_sc_hd__dfxtp_1
X_5825_ _2480_ _2522_ _2530_ _2552_ VGND VGND VPWR VPWR _2553_ sky130_fd_sc_hd__a211o_1
XFILLER_0_48_136 VGND VGND VPWR VPWR sky130_fd_sc_hd__fill_2
XFILLER_0_9_712 VPWR VGND VPWR VGND sky130_ef_sc_hd__decap_12
XTAP_TAPCELL_ROW_17_481 VGND VPWR sky130_fd_sc_hd__tapvpwrvgnd_1
XFILLER_0_36_309 VGND VGND VPWR VPWR sky130_fd_sc_hd__fill_2
XANTENNA__4456__S0 _1197_ VGND VGND VPWR VPWR sky130_fd_sc_hd__diode_2
XANTENNA__7755__S _3804_ VGND VGND VPWR VPWR sky130_fd_sc_hd__diode_2
XFILLER_0_63_128 VGND VGND VPWR VPWR sky130_fd_sc_hd__fill_2
XFILLER_0_17_501 VGND VGND VPWR VPWR sky130_fd_sc_hd__decap_3
XFILLER_0_91_459 VGND VGND VPWR VPWR sky130_fd_sc_hd__decap_3
X_5756_ net108 _2486_ VGND VGND VPWR VPWR _2487_ sky130_fd_sc_hd__xnor2_1
X_8544_ clknet_leaf_0_clk _0665_ VGND VGND VPWR VPWR registers\[19\]\[0\] sky130_fd_sc_hd__dfxtp_1
X_5687_ _2200_ _2415_ _2419_ _2273_ _2420_ VGND VGND VPWR VPWR _2421_ sky130_fd_sc_hd__o221a_1
X_4707_ _1372_ _1475_ _1479_ _1483_ VGND VGND VPWR VPWR _1484_ sky130_fd_sc_hd__a2bb2o_1
X_8475_ _4187_ VGND VGND VPWR VPWR _0632_ sky130_fd_sc_hd__clkbuf_1
XFILLER_0_17_589 VGND VGND VPWR VPWR sky130_fd_sc_hd__fill_2
X_7426_ registers\[20\]\[18\] _3472_ _3623_ VGND VGND VPWR VPWR _3632_ sky130_fd_sc_hd__mux2_1
X_4638_ _1198_ VGND VGND VPWR VPWR _1418_ sky130_fd_sc_hd__buf_4
X_4569_ registers\[4\]\[16\] registers\[5\]\[16\] registers\[6\]\[16\] registers\[7\]\[16\]
+ _1323_ _1128_ VGND VGND VPWR VPWR _1353_ sky130_fd_sc_hd__mux4_1
XANTENNA__7490__S _3659_ VGND VGND VPWR VPWR sky130_fd_sc_hd__diode_2
X_7357_ registers\[1\]\[18\] _3472_ _3586_ VGND VGND VPWR VPWR _3595_ sky130_fd_sc_hd__mux2_1
XFILLER_0_40_581 VGND VGND VPWR VPWR sky130_fd_sc_hd__decap_6
X_7288_ _3558_ VGND VGND VPWR VPWR _0074_ sky130_fd_sc_hd__clkbuf_1
X_6308_ registers\[19\]\[16\] _2995_ _2983_ VGND VGND VPWR VPWR _2996_ sky130_fd_sc_hd__mux2_1
X_9027_ clknet_leaf_23_clk _0124_ VGND VGND VPWR VPWR registers\[20\]\[3\] sky130_fd_sc_hd__dfxtp_1
X_6239_ _2943_ _2917_ _2944_ _2907_ _2918_ VGND VGND VPWR VPWR _2945_ sky130_fd_sc_hd__o221a_1
XANTENNA__4931__S1 _1692_ VGND VGND VPWR VPWR sky130_fd_sc_hd__diode_2
XANTENNA__6834__S _3299_ VGND VGND VPWR VPWR sky130_fd_sc_hd__diode_2
XFILLER_0_86_209 VGND VGND VPWR VPWR sky130_fd_sc_hd__decap_6
XANTENNA__4354__S _1148_ VGND VGND VPWR VPWR sky130_fd_sc_hd__diode_2
XANTENNA__4695__S0 _1323_ VGND VGND VPWR VPWR sky130_fd_sc_hd__diode_2
XANTENNA__5974__A net124 VGND VGND VPWR VPWR sky130_fd_sc_hd__diode_2
XFILLER_0_94_275 VGND VGND VPWR VPWR sky130_fd_sc_hd__fill_2
XFILLER_0_82_437 VGND VGND VPWR VPWR sky130_fd_sc_hd__fill_2
XFILLER_0_67_478 VGND VGND VPWR VPWR sky130_fd_sc_hd__fill_2
XFILLER_0_39_169 VGND VGND VPWR VPWR sky130_fd_sc_hd__decap_3
XFILLER_0_106_720 VGND VGND VPWR VPWR sky130_fd_sc_hd__decap_6
XTAP_TAPCELL_ROW_97_1523 VGND VPWR sky130_fd_sc_hd__tapvpwrvgnd_1
XFILLER_0_62_150 VGND VGND VPWR VPWR sky130_fd_sc_hd__fill_2
XFILLER_0_35_397 VGND VGND VPWR VPWR sky130_fd_sc_hd__fill_2
XFILLER_0_105_263 VGND VGND VPWR VPWR sky130_fd_sc_hd__decap_3
XANTENNA__8496__S _4189_ VGND VGND VPWR VPWR sky130_fd_sc_hd__diode_2
XFILLER_0_50_378 VGND VGND VPWR VPWR sky130_fd_sc_hd__fill_2
XANTENNA__8266__A1 _3495_ VGND VGND VPWR VPWR sky130_fd_sc_hd__diode_2
XANTENNA__8018__A1 _3451_ VGND VGND VPWR VPWR sky130_fd_sc_hd__diode_2
XFILLER_0_65_49 VGND VGND VPWR VPWR sky130_fd_sc_hd__fill_1
XTAP_TAPCELL_ROW_106_1641 VGND VPWR sky130_fd_sc_hd__tapvpwrvgnd_1
XANTENNA__4686__S0 _1418_ VGND VGND VPWR VPWR sky130_fd_sc_hd__diode_2
XTAP_TAPCELL_ROW_34_705 VGND VPWR sky130_fd_sc_hd__tapvpwrvgnd_1
XFILLER_0_105_99 VGND VGND VPWR VPWR sky130_fd_sc_hd__decap_4
XANTENNA_clkbuf_leaf_50_clk_A clknet_4_15_0_clk VGND VGND VPWR VPWR sky130_fd_sc_hd__diode_2
XFILLER_0_58_489 VGND VGND VPWR VPWR sky130_fd_sc_hd__fill_2
XANTENNA__4438__S0 _1053_ VGND VGND VPWR VPWR sky130_fd_sc_hd__diode_2
XFILLER_0_45_106 VGND VGND VPWR VPWR sky130_fd_sc_hd__decap_4
XANTENNA__7575__S _3706_ VGND VGND VPWR VPWR sky130_fd_sc_hd__diode_2
XTAP_TAPCELL_ROW_14_440 VGND VPWR sky130_fd_sc_hd__tapvpwrvgnd_1
XFILLER_0_18_309 VGND VGND VPWR VPWR sky130_fd_sc_hd__fill_1
XANTENNA__4989__S1 _1749_ VGND VGND VPWR VPWR sky130_fd_sc_hd__diode_2
X_5610_ _2336_ _2343_ _2344_ VGND VGND VPWR VPWR _2345_ sky130_fd_sc_hd__mux2_1
XFILLER_0_45_139 VGND VGND VPWR VPWR sky130_fd_sc_hd__fill_2
X_6590_ registers\[7\]\[29\] _3022_ _3159_ VGND VGND VPWR VPWR _3169_ sky130_fd_sc_hd__mux2_1
X_5541_ _2268_ _2275_ _2276_ VGND VGND VPWR VPWR _2277_ sky130_fd_sc_hd__a21o_1
XFILLER_0_5_225 VGND VGND VPWR VPWR sky130_fd_sc_hd__fill_2
XFILLER_0_112_701 VPWR VGND VPWR VGND sky130_ef_sc_hd__decap_12
XFILLER_0_54_695 VGND VGND VPWR VPWR sky130_fd_sc_hd__fill_2
XFILLER_0_41_334 VGND VGND VPWR VPWR sky130_fd_sc_hd__fill_2
X_8260_ registers\[6\]\[26\] _3489_ _4067_ VGND VGND VPWR VPWR _4074_ sky130_fd_sc_hd__mux2_1
X_7211_ registers\[17\]\[13\] _3462_ _3514_ VGND VGND VPWR VPWR _3518_ sky130_fd_sc_hd__mux2_1
XFILLER_0_76_7 VPWR VGND VPWR VGND sky130_ef_sc_hd__decap_12
X_5472_ _1184_ _1208_ VGND VGND VPWR VPWR _2208_ sky130_fd_sc_hd__nand2_4
XTAP_TAPCELL_ROW_57_1006 VGND VPWR sky130_fd_sc_hd__tapvpwrvgnd_1
XTAP_TAPCELL_ROW_117_1781 VGND VPWR sky130_fd_sc_hd__tapvpwrvgnd_1
XFILLER_0_111_222 VGND VGND VPWR VPWR sky130_fd_sc_hd__fill_2
X_4423_ _1211_ _1214_ _1025_ VGND VGND VPWR VPWR _1215_ sky130_fd_sc_hd__mux2_1
XANTENNA__4610__S0 _1390_ VGND VGND VPWR VPWR sky130_fd_sc_hd__diode_2
X_8191_ _4037_ VGND VGND VPWR VPWR _0498_ sky130_fd_sc_hd__clkbuf_1
XFILLER_0_22_581 VGND VGND VPWR VPWR sky130_fd_sc_hd__decap_4
XANTENNA__6919__S _3346_ VGND VGND VPWR VPWR sky130_fd_sc_hd__diode_2
X_4354_ _1146_ _1147_ _1148_ VGND VGND VPWR VPWR _1149_ sky130_fd_sc_hd__mux2_1
X_7142_ registers\[16\]\[19\] _3474_ _3456_ VGND VGND VPWR VPWR _3475_ sky130_fd_sc_hd__mux2_1
XANTENNA_clkload12_A clknet_4_13_0_clk VGND VGND VPWR VPWR sky130_fd_sc_hd__diode_2
XANTENNA__4439__S _1031_ VGND VGND VPWR VPWR sky130_fd_sc_hd__diode_2
XFILLER_0_39_61 VGND VGND VPWR VPWR sky130_fd_sc_hd__fill_1
X_7073_ _3127_ registers\[15\]\[28\] _3420_ VGND VGND VPWR VPWR _3429_ sky130_fd_sc_hd__mux2_1
X_6024_ _2710_ _2717_ VGND VGND VPWR VPWR _2742_ sky130_fd_sc_hd__nand2_1
X_4285_ registers\[0\]\[2\] registers\[1\]\[2\] registers\[2\]\[2\] registers\[3\]\[2\]
+ _1026_ _1027_ VGND VGND VPWR VPWR _1083_ sky130_fd_sc_hd__mux4_1
XANTENNA__6654__S _3197_ VGND VGND VPWR VPWR sky130_fd_sc_hd__diode_2
XTAP_TAPCELL_ROW_68_1146 VGND VPWR sky130_fd_sc_hd__tapvpwrvgnd_1
X_7975_ _3900_ VGND VGND VPWR VPWR _3923_ sky130_fd_sc_hd__clkbuf_8
XFILLER_0_77_732 VGND VGND VPWR VPWR sky130_fd_sc_hd__fill_1
X_6926_ _3350_ VGND VGND VPWR VPWR _0944_ sky130_fd_sc_hd__clkbuf_1
XANTENNA__4677__S0 _1433_ VGND VGND VPWR VPWR sky130_fd_sc_hd__diode_2
XTAP_TAPCELL_ROW_81_1313 VGND VPWR sky130_fd_sc_hd__tapvpwrvgnd_1
XFILLER_0_76_242 VGND VGND VPWR VPWR sky130_fd_sc_hd__decap_4
XFILLER_0_49_467 VGND VGND VPWR VPWR sky130_fd_sc_hd__decap_6
XANTENNA__4429__S0 _1196_ VGND VGND VPWR VPWR sky130_fd_sc_hd__diode_2
XANTENNA_clkbuf_leaf_18_clk_A clknet_4_4_0_clk VGND VGND VPWR VPWR sky130_fd_sc_hd__diode_2
XFILLER_0_71_81 VGND VGND VPWR VPWR sky130_fd_sc_hd__fill_2
X_6857_ registers\[12\]\[23\] _3010_ _3310_ VGND VGND VPWR VPWR _3314_ sky130_fd_sc_hd__mux2_1
XFILLER_0_9_531 VGND VGND VPWR VPWR sky130_fd_sc_hd__fill_2
XFILLER_0_9_553 VGND VGND VPWR VPWR sky130_fd_sc_hd__fill_1
XFILLER_0_119_377 VPWR VGND VPWR VGND sky130_ef_sc_hd__decap_12
X_5808_ _2438_ _2465_ _2536_ _2445_ VGND VGND VPWR VPWR _2537_ sky130_fd_sc_hd__a2bb2o_1
X_6788_ _3276_ VGND VGND VPWR VPWR _0880_ sky130_fd_sc_hd__clkbuf_1
XFILLER_0_29_191 VGND VGND VPWR VPWR sky130_fd_sc_hd__fill_2
XANTENNA__6743__A1 _2966_ VGND VGND VPWR VPWR sky130_fd_sc_hd__diode_2
X_5739_ _2403_ _2269_ VGND VGND VPWR VPWR _2471_ sky130_fd_sc_hd__nor2_1
XFILLER_0_45_673 VGND VGND VPWR VPWR sky130_fd_sc_hd__fill_2
X_8527_ _4215_ VGND VGND VPWR VPWR _0656_ sky130_fd_sc_hd__clkbuf_1
XFILLER_0_44_150 VGND VGND VPWR VPWR sky130_fd_sc_hd__fill_2
XFILLER_0_17_364 VGND VGND VPWR VPWR sky130_fd_sc_hd__fill_2
XFILLER_0_115_550 VGND VGND VPWR VPWR sky130_fd_sc_hd__decap_3
XFILLER_0_60_621 VGND VGND VPWR VPWR sky130_fd_sc_hd__fill_2
XTAP_TAPCELL_ROW_79_1286 VGND VPWR sky130_fd_sc_hd__tapvpwrvgnd_1
XANTENNA__8496__A1 net47 VGND VGND VPWR VPWR sky130_fd_sc_hd__diode_2
X_8458_ registers\[8\]\[23\] net31 _4175_ VGND VGND VPWR VPWR _4179_ sky130_fd_sc_hd__mux2_1
XFILLER_0_102_244 VGND VGND VPWR VPWR sky130_fd_sc_hd__fill_2
X_7409_ _3611_ VGND VGND VPWR VPWR _3623_ sky130_fd_sc_hd__clkbuf_8
X_8389_ _4142_ VGND VGND VPWR VPWR _0591_ sky130_fd_sc_hd__clkbuf_1
XTAP_TAPCELL_ROW_92_1453 VGND VPWR sky130_fd_sc_hd__tapvpwrvgnd_1
XANTENNA__8248__A1 _3476_ VGND VGND VPWR VPWR sky130_fd_sc_hd__diode_2
XANTENNA__5482__A1 _1959_ VGND VGND VPWR VPWR sky130_fd_sc_hd__diode_2
XANTENNA__4904__S1 _1643_ VGND VGND VPWR VPWR sky130_fd_sc_hd__diode_2
XANTENNA__4668__S0 _1427_ VGND VGND VPWR VPWR sky130_fd_sc_hd__diode_2
XANTENNA__7395__S _3612_ VGND VGND VPWR VPWR sky130_fd_sc_hd__diode_2
XANTENNA__4812__S _1386_ VGND VGND VPWR VPWR sky130_fd_sc_hd__diode_2
XTAP_TAPCELL_ROW_101_1571 VGND VPWR sky130_fd_sc_hd__tapvpwrvgnd_1
XFILLER_0_82_278 VGND VGND VPWR VPWR sky130_fd_sc_hd__fill_1
XANTENNA__5209__A _1959_ VGND VGND VPWR VPWR sky130_fd_sc_hd__diode_2
XFILLER_0_51_621 VGND VGND VPWR VPWR sky130_fd_sc_hd__fill_2
Xclkload16 clknet_leaf_1_clk VGND VGND VPWR VPWR clkload16/Y sky130_fd_sc_hd__bufinv_16
Xclkload49 clknet_leaf_34_clk VGND VGND VPWR VPWR clkload49/Y sky130_fd_sc_hd__clkinv_4
Xclkload27 clknet_leaf_20_clk VGND VGND VPWR VPWR clkload27/Y sky130_fd_sc_hd__clkinvlp_2
XFILLER_0_3_729 VGND VGND VPWR VPWR sky130_fd_sc_hd__decap_4
XFILLER_0_2_206 VGND VGND VPWR VPWR sky130_fd_sc_hd__fill_2
XFILLER_0_23_345 VGND VGND VPWR VPWR sky130_fd_sc_hd__fill_2
Xclkload38 clknet_leaf_99_clk VGND VGND VPWR VPWR clkload38/Y sky130_fd_sc_hd__clkinv_1
XANTENNA__6739__S _3250_ VGND VGND VPWR VPWR sky130_fd_sc_hd__diode_2
XANTENNA__8239__A1 _3468_ VGND VGND VPWR VPWR sky130_fd_sc_hd__diode_2
XFILLER_0_76_26 VGND VGND VPWR VPWR sky130_fd_sc_hd__fill_2
XANTENNA__5148__S1 _1749_ VGND VGND VPWR VPWR sky130_fd_sc_hd__diode_2
XANTENNA__4783__A _1347_ VGND VGND VPWR VPWR sky130_fd_sc_hd__diode_2
XTAP_TAPCELL_ROW_19_510 VGND VPWR sky130_fd_sc_hd__tapvpwrvgnd_1
XTAP_TAPCELL_ROW_47_874 VGND VPWR sky130_fd_sc_hd__tapvpwrvgnd_1
XFILLER_0_25_52 VGND VGND VPWR VPWR sky130_fd_sc_hd__fill_2
X_7760_ _3809_ VGND VGND VPWR VPWR _0295_ sky130_fd_sc_hd__clkbuf_1
X_4972_ _1682_ _1734_ _1634_ VGND VGND VPWR VPWR _1735_ sky130_fd_sc_hd__o21a_1
X_7691_ registers\[24\]\[14\] _3464_ _3768_ VGND VGND VPWR VPWR _3773_ sky130_fd_sc_hd__mux2_1
XFILLER_0_74_713 VGND VGND VPWR VPWR sky130_fd_sc_hd__fill_2
X_6711_ _3235_ VGND VGND VPWR VPWR _0844_ sky130_fd_sc_hd__clkbuf_1
XFILLER_0_116_303 VGND VGND VPWR VPWR sky130_fd_sc_hd__decap_3
XTAP_TAPCELL_ROW_63_1076 VGND VPWR sky130_fd_sc_hd__tapvpwrvgnd_1
XFILLER_0_46_448 VGND VGND VPWR VPWR sky130_fd_sc_hd__fill_2
X_9430_ clknet_leaf_93_clk _0527_ VGND VGND VPWR VPWR registers\[6\]\[22\] sky130_fd_sc_hd__dfxtp_1
XANTENNA__6503__A net32 VGND VGND VPWR VPWR sky130_fd_sc_hd__diode_2
XANTENNA__4722__S _1386_ VGND VGND VPWR VPWR sky130_fd_sc_hd__diode_2
XANTENNA__6725__A1 _3016_ VGND VGND VPWR VPWR sky130_fd_sc_hd__diode_2
X_6642_ registers\[0\]\[20\] _3003_ _3197_ VGND VGND VPWR VPWR _3198_ sky130_fd_sc_hd__mux2_1
XTAP_TAPCELL_ROW_119_1810 VGND VPWR sky130_fd_sc_hd__tapvpwrvgnd_1
X_9361_ clknet_leaf_53_clk _0458_ VGND VGND VPWR VPWR registers\[30\]\[17\] sky130_fd_sc_hd__dfxtp_1
XTAP_TAPCELL_ROW_119_1821 VGND VPWR sky130_fd_sc_hd__tapvpwrvgnd_1
XFILLER_0_116_358 VGND VGND VPWR VPWR sky130_fd_sc_hd__decap_6
XFILLER_0_73_289 VGND VGND VPWR VPWR sky130_fd_sc_hd__fill_2
X_8312_ _4101_ VGND VGND VPWR VPWR _0555_ sky130_fd_sc_hd__clkbuf_1
X_6573_ _3160_ VGND VGND VPWR VPWR _0781_ sky130_fd_sc_hd__clkbuf_1
X_9292_ clknet_leaf_44_clk _0389_ VGND VGND VPWR VPWR registers\[28\]\[12\] sky130_fd_sc_hd__dfxtp_1
X_5524_ _2220_ _2259_ VGND VGND VPWR VPWR _2260_ sky130_fd_sc_hd__nand2_1
XFILLER_0_6_589 VGND VGND VPWR VPWR sky130_fd_sc_hd__fill_2
XANTENNA__8478__A1 net16 VGND VGND VPWR VPWR sky130_fd_sc_hd__diode_2
XFILLER_0_26_194 VGND VGND VPWR VPWR sky130_fd_sc_hd__fill_2
X_8243_ registers\[6\]\[18\] _3472_ _4056_ VGND VGND VPWR VPWR _4065_ sky130_fd_sc_hd__mux2_1
X_5455_ registers\[8\]\[31\] registers\[9\]\[31\] registers\[10\]\[31\] registers\[11\]\[31\]
+ _2126_ _2127_ VGND VGND VPWR VPWR _2192_ sky130_fd_sc_hd__mux4_1
X_4406_ _1127_ VGND VGND VPWR VPWR _1199_ sky130_fd_sc_hd__buf_4
X_8174_ _4028_ VGND VGND VPWR VPWR _0490_ sky130_fd_sc_hd__clkbuf_1
XFILLER_0_67_3 VGND VGND VPWR VPWR sky130_fd_sc_hd__fill_2
XFILLER_0_41_186 VGND VGND VPWR VPWR sky130_fd_sc_hd__fill_1
XANTENNA__5387__S1 _2127_ VGND VGND VPWR VPWR sky130_fd_sc_hd__diode_2
X_7125_ _3463_ VGND VGND VPWR VPWR _0006_ sky130_fd_sc_hd__clkbuf_1
X_5386_ _2109_ VGND VGND VPWR VPWR _2127_ sky130_fd_sc_hd__clkbuf_4
X_4337_ _1129_ _1130_ _1132_ VGND VGND VPWR VPWR _1133_ sky130_fd_sc_hd__mux2_1
X_4268_ registers\[0\]\[1\] registers\[1\]\[1\] registers\[2\]\[1\] registers\[3\]\[1\]
+ _1060_ _1061_ VGND VGND VPWR VPWR _1067_ sky130_fd_sc_hd__mux4_1
X_7056_ _3397_ VGND VGND VPWR VPWR _3420_ sky130_fd_sc_hd__clkbuf_8
X_6007_ net135 _2652_ VGND VGND VPWR VPWR _2726_ sky130_fd_sc_hd__nand2_1
XANTENNA__6384__S _3041_ VGND VGND VPWR VPWR sky130_fd_sc_hd__diode_2
XANTENNA__5789__A _1780_ VGND VGND VPWR VPWR sky130_fd_sc_hd__diode_2
XANTENNA__4898__S0 _1617_ VGND VGND VPWR VPWR sky130_fd_sc_hd__diode_2
XANTENNA__8402__A1 _3495_ VGND VGND VPWR VPWR sky130_fd_sc_hd__diode_2
X_7958_ _3914_ VGND VGND VPWR VPWR _0388_ sky130_fd_sc_hd__clkbuf_1
XFILLER_0_82_80 VGND VGND VPWR VPWR sky130_fd_sc_hd__fill_2
XFILLER_0_49_220 VGND VGND VPWR VPWR sky130_fd_sc_hd__fill_2
XANTENNA__5311__S1 _1764_ VGND VGND VPWR VPWR sky130_fd_sc_hd__diode_2
X_7889_ _3092_ registers\[27\]\[11\] _3876_ VGND VGND VPWR VPWR _3878_ sky130_fd_sc_hd__mux2_1
XFILLER_0_92_510 VGND VGND VPWR VPWR sky130_fd_sc_hd__fill_2
XFILLER_0_77_573 VGND VGND VPWR VPWR sky130_fd_sc_hd__fill_2
X_6909_ _3341_ VGND VGND VPWR VPWR _0936_ sky130_fd_sc_hd__clkbuf_1
XFILLER_0_64_201 VGND VGND VPWR VPWR sky130_fd_sc_hd__fill_2
XFILLER_0_119_141 VPWR VGND VPWR VGND sky130_ef_sc_hd__decap_12
XTAP_TAPCELL_ROW_25_579 VGND VPWR sky130_fd_sc_hd__tapvpwrvgnd_1
XFILLER_0_52_429 VGND VGND VPWR VPWR sky130_fd_sc_hd__fill_1
X_9559_ clknet_leaf_69_clk _0656_ VGND VGND VPWR VPWR registers\[4\]\[23\] sky130_fd_sc_hd__dfxtp_1
XFILLER_0_18_684 VPWR VGND VPWR VGND sky130_ef_sc_hd__decap_12
XFILLER_0_33_610 VGND VGND VPWR VPWR sky130_fd_sc_hd__decap_3
XFILLER_0_17_183 VGND VGND VPWR VPWR sky130_fd_sc_hd__fill_2
XANTENNA__6559__S _3148_ VGND VGND VPWR VPWR sky130_fd_sc_hd__diode_2
XFILLER_0_20_304 VGND VGND VPWR VPWR sky130_fd_sc_hd__fill_2
XANTENNA__4868__A net4 VGND VGND VPWR VPWR sky130_fd_sc_hd__diode_2
XFILLER_0_103_586 VGND VGND VPWR VPWR sky130_fd_sc_hd__decap_4
XFILLER_0_103_575 VGND VGND VPWR VPWR sky130_fd_sc_hd__fill_1
XFILLER_0_32_197 VGND VGND VPWR VPWR sky130_fd_sc_hd__fill_2
XFILLER_0_20_359 VGND VGND VPWR VPWR sky130_fd_sc_hd__fill_2
XANTENNA__6101__C1 _2429_ VGND VGND VPWR VPWR sky130_fd_sc_hd__diode_2
XFILLER_0_46_29 VGND VGND VPWR VPWR sky130_fd_sc_hd__decap_4
XANTENNA__5699__A _1704_ VGND VGND VPWR VPWR sky130_fd_sc_hd__diode_2
XANTENNA__4889__S0 _1628_ VGND VGND VPWR VPWR sky130_fd_sc_hd__diode_2
XFILLER_0_87_337 VGND VGND VPWR VPWR sky130_fd_sc_hd__decap_3
XANTENNA__5207__A1 _1771_ VGND VGND VPWR VPWR sky130_fd_sc_hd__diode_2
XTAP_TAPCELL_ROW_103_1600 VGND VPWR sky130_fd_sc_hd__tapvpwrvgnd_1
XFILLER_0_68_540 VGND VGND VPWR VPWR sky130_fd_sc_hd__fill_2
XTAP_TAPCELL_ROW_44_833 VGND VPWR sky130_fd_sc_hd__tapvpwrvgnd_1
XANTENNA__8014__S _3937_ VGND VGND VPWR VPWR sky130_fd_sc_hd__diode_2
XANTENNA__6323__A net29 VGND VGND VPWR VPWR sky130_fd_sc_hd__diode_2
XFILLER_0_83_565 VGND VGND VPWR VPWR sky130_fd_sc_hd__fill_2
XANTENNA__5066__S0 _1820_ VGND VGND VPWR VPWR sky130_fd_sc_hd__diode_2
XANTENNA__6183__A2 _2587_ VGND VGND VPWR VPWR sky130_fd_sc_hd__diode_2
XFILLER_0_83_587 VGND VGND VPWR VPWR sky130_fd_sc_hd__fill_1
XANTENNA__7380__A1 _3495_ VGND VGND VPWR VPWR sky130_fd_sc_hd__diode_2
Xclkload105 clknet_leaf_59_clk VGND VGND VPWR VPWR clkload105/X sky130_fd_sc_hd__clkbuf_4
XFILLER_0_36_492 VGND VGND VPWR VPWR sky130_fd_sc_hd__fill_1
XANTENNA__4778__A _1390_ VGND VGND VPWR VPWR sky130_fd_sc_hd__diode_2
XFILLER_0_24_698 VGND VGND VPWR VPWR sky130_fd_sc_hd__fill_2
XTAP_TAPCELL_ROW_114_1740 VGND VPWR sky130_fd_sc_hd__tapvpwrvgnd_1
XANTENNA__5143__B1 _1778_ VGND VGND VPWR VPWR sky130_fd_sc_hd__diode_2
X_5240_ registers\[0\]\[19\] registers\[1\]\[19\] registers\[2\]\[19\] registers\[3\]\[19\]
+ _1798_ _1799_ VGND VGND VPWR VPWR _1989_ sky130_fd_sc_hd__mux4_1
XANTENNA__7154__A net31 VGND VGND VPWR VPWR sky130_fd_sc_hd__diode_2
XFILLER_0_11_337 VGND VGND VPWR VPWR sky130_fd_sc_hd__decap_3
XANTENNA__6891__A0 _3083_ VGND VGND VPWR VPWR sky130_fd_sc_hd__diode_2
X_5171_ _1809_ _1923_ _1655_ VGND VGND VPWR VPWR _1924_ sky130_fd_sc_hd__o21a_1
XPHY_EDGE_ROW_18_Right_18 VGND VGND VPWR VPWR sky130_fd_sc_hd__decap_3
X_8930_ clknet_leaf_1_clk _0027_ VGND VGND VPWR VPWR registers\[17\]\[2\] sky130_fd_sc_hd__dfxtp_1
Xinput3 a1[2] VGND VGND VPWR VPWR net3 sky130_fd_sc_hd__dlymetal6s2s_1
X_8861_ clknet_leaf_105_clk _0982_ VGND VGND VPWR VPWR registers\[14\]\[29\] sky130_fd_sc_hd__dfxtp_1
XFILLER_0_78_348 VGND VGND VPWR VPWR sky130_fd_sc_hd__fill_2
X_7812_ _3083_ registers\[26\]\[7\] _3829_ VGND VGND VPWR VPWR _3837_ sky130_fd_sc_hd__mux2_1
XTAP_TAPCELL_ROW_65_1105 VGND VPWR sky130_fd_sc_hd__tapvpwrvgnd_1
X_8792_ clknet_leaf_87_clk _0913_ VGND VGND VPWR VPWR registers\[12\]\[24\] sky130_fd_sc_hd__dfxtp_1
X_7743_ _3800_ VGND VGND VPWR VPWR _0287_ sky130_fd_sc_hd__clkbuf_1
X_4955_ _1628_ VGND VGND VPWR VPWR _1719_ sky130_fd_sc_hd__clkbuf_8
XFILLER_0_47_724 VGND VGND VPWR VPWR sky130_fd_sc_hd__fill_1
XPHY_EDGE_ROW_27_Right_27 VGND VGND VPWR VPWR sky130_fd_sc_hd__decap_3
XFILLER_0_86_381 VGND VGND VPWR VPWR sky130_fd_sc_hd__fill_2
XFILLER_0_74_510 VGND VGND VPWR VPWR sky130_fd_sc_hd__decap_3
XFILLER_0_117_612 VGND VGND VPWR VPWR sky130_fd_sc_hd__fill_2
X_7674_ registers\[24\]\[6\] _3447_ _3757_ VGND VGND VPWR VPWR _3764_ sky130_fd_sc_hd__mux2_1
XFILLER_0_62_705 VPWR VGND VPWR VGND sky130_ef_sc_hd__decap_12
X_4886_ _1651_ _1652_ _1631_ VGND VGND VPWR VPWR _1653_ sky130_fd_sc_hd__mux2_1
XTAP_TAPCELL_ROW_22_549 VGND VPWR sky130_fd_sc_hd__tapvpwrvgnd_1
X_9413_ clknet_leaf_32_clk _0510_ VGND VGND VPWR VPWR registers\[6\]\[5\] sky130_fd_sc_hd__dfxtp_1
X_6625_ registers\[0\]\[12\] _2987_ _3186_ VGND VGND VPWR VPWR _3189_ sky130_fd_sc_hd__mux2_1
XANTENNA__7763__S _3804_ VGND VGND VPWR VPWR sky130_fd_sc_hd__diode_2
XFILLER_0_15_621 VGND VGND VPWR VPWR sky130_fd_sc_hd__fill_2
X_6556_ _3151_ VGND VGND VPWR VPWR _0773_ sky130_fd_sc_hd__clkbuf_1
X_9344_ clknet_leaf_111_clk _0441_ VGND VGND VPWR VPWR registers\[30\]\[0\] sky130_fd_sc_hd__dfxtp_1
X_5507_ _2220_ _2242_ VGND VGND VPWR VPWR _2243_ sky130_fd_sc_hd__nand2_1
XFILLER_0_15_698 VPWR VGND VPWR VGND sky130_ef_sc_hd__decap_12
X_9275_ clknet_leaf_89_clk _0372_ VGND VGND VPWR VPWR registers\[27\]\[27\] sky130_fd_sc_hd__dfxtp_1
XANTENNA__4280__S1 _1061_ VGND VGND VPWR VPWR sky130_fd_sc_hd__diode_2
XFILLER_0_100_501 VGND VGND VPWR VPWR sky130_fd_sc_hd__fill_2
XTAP_TAPCELL_ROW_76_1245 VGND VPWR sky130_fd_sc_hd__tapvpwrvgnd_1
X_6487_ net26 VGND VGND VPWR VPWR _3108_ sky130_fd_sc_hd__buf_2
X_8226_ _4044_ VGND VGND VPWR VPWR _4056_ sky130_fd_sc_hd__clkbuf_8
XFILLER_0_14_197 VGND VGND VPWR VPWR sky130_fd_sc_hd__decap_4
XFILLER_0_30_657 VGND VGND VPWR VPWR sky130_fd_sc_hd__fill_1
XANTENNA__5685__A1 _2353_ VGND VGND VPWR VPWR sky130_fd_sc_hd__diode_2
X_5438_ registers\[0\]\[30\] registers\[1\]\[30\] registers\[2\]\[30\] registers\[3\]\[30\]
+ _1968_ _1969_ VGND VGND VPWR VPWR _2176_ sky130_fd_sc_hd__mux4_1
XFILLER_0_30_679 VGND VGND VPWR VPWR sky130_fd_sc_hd__fill_2
XPHY_EDGE_ROW_36_Right_36 VGND VGND VPWR VPWR sky130_fd_sc_hd__decap_3
X_8157_ _4019_ VGND VGND VPWR VPWR _0482_ sky130_fd_sc_hd__clkbuf_1
XFILLER_0_10_381 VGND VGND VPWR VPWR sky130_fd_sc_hd__fill_2
X_5369_ _2076_ _2110_ VGND VGND VPWR VPWR _2111_ sky130_fd_sc_hd__and2_1
XFILLER_0_100_589 VPWR VGND VPWR VGND sky130_ef_sc_hd__decap_12
X_7108_ registers\[16\]\[8\] _3451_ _3435_ VGND VGND VPWR VPWR _3452_ sky130_fd_sc_hd__mux2_1
X_8088_ _2980_ registers\[30\]\[9\] _3973_ VGND VGND VPWR VPWR _3983_ sky130_fd_sc_hd__mux2_1
X_7039_ _3411_ VGND VGND VPWR VPWR _0996_ sky130_fd_sc_hd__clkbuf_1
XANTENNA__4627__S _1362_ VGND VGND VPWR VPWR sky130_fd_sc_hd__diode_2
XANTENNA__5312__A _1752_ VGND VGND VPWR VPWR sky130_fd_sc_hd__diode_2
XFILLER_0_97_646 VGND VGND VPWR VPWR sky130_fd_sc_hd__fill_2
XTAP_TAPCELL_ROW_87_1396 VGND VPWR sky130_fd_sc_hd__tapvpwrvgnd_1
XTAP_TAPCELL_ROW_87_1385 VGND VPWR sky130_fd_sc_hd__tapvpwrvgnd_1
XANTENNA__6842__S _3299_ VGND VGND VPWR VPWR sky130_fd_sc_hd__diode_2
XPHY_EDGE_ROW_45_Right_45 VGND VGND VPWR VPWR sky130_fd_sc_hd__decap_3
XTAP_TAPCELL_ROW_2_285 VGND VPWR sky130_fd_sc_hd__tapvpwrvgnd_1
XANTENNA__7938__S _3901_ VGND VGND VPWR VPWR sky130_fd_sc_hd__diode_2
XANTENNA__4362__S _1132_ VGND VGND VPWR VPWR sky130_fd_sc_hd__diode_2
XFILLER_0_37_223 VGND VGND VPWR VPWR sky130_fd_sc_hd__fill_1
XFILLER_0_108_634 VGND VGND VPWR VPWR sky130_fd_sc_hd__fill_1
XFILLER_0_80_502 VGND VGND VPWR VPWR sky130_fd_sc_hd__fill_2
XFILLER_0_53_705 VGND VGND VPWR VPWR sky130_fd_sc_hd__fill_2
XFILLER_0_107_122 VGND VGND VPWR VPWR sky130_fd_sc_hd__fill_2
XFILLER_0_53_727 VGND VGND VPWR VPWR sky130_fd_sc_hd__fill_1
XFILLER_0_37_278 VGND VGND VPWR VPWR sky130_fd_sc_hd__fill_2
XANTENNA__7362__A1 _3476_ VGND VGND VPWR VPWR sky130_fd_sc_hd__diode_2
XFILLER_0_60_292 VGND VGND VPWR VPWR sky130_fd_sc_hd__decap_3
XFILLER_0_60_270 VGND VGND VPWR VPWR sky130_fd_sc_hd__fill_1
XPHY_EDGE_ROW_54_Right_54 VGND VGND VPWR VPWR sky130_fd_sc_hd__decap_3
XFILLER_0_0_518 VPWR VGND VPWR VGND sky130_ef_sc_hd__decap_12
XANTENNA__5220__S0 _1968_ VGND VGND VPWR VPWR sky130_fd_sc_hd__diode_2
XPHY_EDGE_ROW_29_Left_149 VGND VGND VPWR VPWR sky130_fd_sc_hd__decap_3
XANTENNA__5428__A1 _2019_ VGND VGND VPWR VPWR sky130_fd_sc_hd__diode_2
XPHY_EDGE_ROW_63_Right_63 VGND VGND VPWR VPWR sky130_fd_sc_hd__decap_3
XFILLER_0_88_657 VGND VGND VPWR VPWR sky130_fd_sc_hd__fill_1
XFILLER_0_87_145 VGND VGND VPWR VPWR sky130_fd_sc_hd__decap_3
XANTENNA__7848__S _3851_ VGND VGND VPWR VPWR sky130_fd_sc_hd__diode_2
XANTENNA__7050__A0 _3104_ VGND VGND VPWR VPWR sky130_fd_sc_hd__diode_2
XFILLER_0_29_702 VGND VGND VPWR VPWR sky130_fd_sc_hd__decap_3
XFILLER_0_96_690 VGND VGND VPWR VPWR sky130_fd_sc_hd__fill_2
XFILLER_0_56_510 VGND VGND VPWR VPWR sky130_fd_sc_hd__decap_3
XPHY_EDGE_ROW_38_Left_158 VGND VGND VPWR VPWR sky130_fd_sc_hd__decap_3
XFILLER_0_8_607 VGND VGND VPWR VPWR sky130_fd_sc_hd__fill_2
XPHY_EDGE_ROW_1_Left_121 VGND VGND VPWR VPWR sky130_fd_sc_hd__decap_3
XFILLER_0_29_724 VGND VGND VPWR VPWR sky130_fd_sc_hd__fill_2
XFILLER_0_44_716 VGND VGND VPWR VPWR sky130_fd_sc_hd__fill_2
X_4740_ _1513_ _1514_ _1124_ VGND VGND VPWR VPWR _1515_ sky130_fd_sc_hd__a21o_1
Xclkbuf_leaf_107_clk clknet_4_2_0_clk VGND VGND VPWR VPWR clknet_leaf_107_clk sky130_fd_sc_hd__clkbuf_8
XANTENNA__7353__A1 _3468_ VGND VGND VPWR VPWR sky130_fd_sc_hd__diode_2
XTAP_TAPCELL_ROW_60_1035 VGND VPWR sky130_fd_sc_hd__tapvpwrvgnd_1
X_4671_ registers\[4\]\[21\] registers\[5\]\[21\] registers\[6\]\[21\] registers\[7\]\[21\]
+ _1382_ _1383_ VGND VGND VPWR VPWR _1450_ sky130_fd_sc_hd__mux4_1
XFILLER_0_71_546 VGND VGND VPWR VPWR sky130_fd_sc_hd__fill_2
XANTENNA__7583__S _3706_ VGND VGND VPWR VPWR sky130_fd_sc_hd__diode_2
X_6410_ _3057_ VGND VGND VPWR VPWR _0721_ sky130_fd_sc_hd__clkbuf_1
X_7390_ _3613_ VGND VGND VPWR VPWR _0121_ sky130_fd_sc_hd__clkbuf_1
XPHY_EDGE_ROW_72_Right_72 VGND VGND VPWR VPWR sky130_fd_sc_hd__decap_3
X_6341_ net35 VGND VGND VPWR VPWR _3018_ sky130_fd_sc_hd__buf_2
XANTENNA__7105__A1 _3449_ VGND VGND VPWR VPWR sky130_fd_sc_hd__diode_2
XFILLER_0_51_281 VGND VGND VPWR VPWR sky130_fd_sc_hd__decap_4
XFILLER_0_24_484 VGND VGND VPWR VPWR sky130_fd_sc_hd__fill_2
X_6272_ _2971_ VGND VGND VPWR VPWR _0669_ sky130_fd_sc_hd__clkbuf_1
X_9060_ clknet_leaf_28_clk _0157_ VGND VGND VPWR VPWR registers\[21\]\[4\] sky130_fd_sc_hd__dfxtp_1
XFILLER_0_11_156 VGND VGND VPWR VPWR sky130_fd_sc_hd__fill_2
X_8011_ _3942_ VGND VGND VPWR VPWR _0413_ sky130_fd_sc_hd__clkbuf_1
XANTENNA__5211__S0 _1820_ VGND VGND VPWR VPWR sky130_fd_sc_hd__diode_2
X_5223_ _1756_ _1972_ VGND VGND VPWR VPWR _1973_ sky130_fd_sc_hd__nand2_1
XPHY_EDGE_ROW_47_Left_167 VGND VGND VPWR VPWR sky130_fd_sc_hd__decap_3
XANTENNA__6927__S _3346_ VGND VGND VPWR VPWR sky130_fd_sc_hd__diode_2
X_5154_ registers\[4\]\[14\] registers\[5\]\[14\] registers\[6\]\[14\] registers\[7\]\[14\]
+ _1690_ _1692_ VGND VGND VPWR VPWR _1908_ sky130_fd_sc_hd__mux4_1
XFILLER_0_20_690 VGND VGND VPWR VPWR sky130_fd_sc_hd__fill_1
XANTENNA_clkbuf_4_4_0_clk_A clknet_0_clk VGND VGND VPWR VPWR sky130_fd_sc_hd__diode_2
XTAP_TAPCELL_ROW_71_1186 VGND VPWR sky130_fd_sc_hd__tapvpwrvgnd_1
XFILLER_0_47_61 VGND VGND VPWR VPWR sky130_fd_sc_hd__fill_1
X_5085_ registers\[8\]\[10\] registers\[9\]\[10\] registers\[10\]\[10\] registers\[11\]\[10\]
+ _1773_ _1775_ VGND VGND VPWR VPWR _1843_ sky130_fd_sc_hd__mux4_1
XPHY_EDGE_ROW_81_Right_81 VGND VGND VPWR VPWR sky130_fd_sc_hd__decap_3
XANTENNA__4447__S _1031_ VGND VGND VPWR VPWR sky130_fd_sc_hd__diode_2
X_8913_ clknet_leaf_55_clk _0010_ VGND VGND VPWR VPWR registers\[16\]\[17\] sky130_fd_sc_hd__dfxtp_1
XFILLER_0_79_613 VGND VGND VPWR VPWR sky130_fd_sc_hd__decap_3
XTAP_TAPCELL_ROW_27_608 VGND VPWR sky130_fd_sc_hd__tapvpwrvgnd_1
XFILLER_0_79_668 VGND VGND VPWR VPWR sky130_fd_sc_hd__decap_4
XFILLER_0_78_145 VGND VGND VPWR VPWR sky130_fd_sc_hd__fill_2
X_8844_ clknet_leaf_15_clk _0965_ VGND VGND VPWR VPWR registers\[14\]\[12\] sky130_fd_sc_hd__dfxtp_1
XANTENNA__6662__S _3174_ VGND VGND VPWR VPWR sky130_fd_sc_hd__diode_2
XFILLER_0_2_85 VPWR VGND VPWR VGND sky130_ef_sc_hd__decap_12
XFILLER_0_66_307 VGND VGND VPWR VPWR sky130_fd_sc_hd__fill_1
XPHY_EDGE_ROW_56_Left_176 VGND VGND VPWR VPWR sky130_fd_sc_hd__decap_3
XFILLER_0_93_126 VGND VGND VPWR VPWR sky130_fd_sc_hd__fill_2
X_8775_ clknet_leaf_26_clk _0896_ VGND VGND VPWR VPWR registers\[12\]\[7\] sky130_fd_sc_hd__dfxtp_1
X_5987_ _2394_ VGND VGND VPWR VPWR _2707_ sky130_fd_sc_hd__buf_2
X_4938_ _1694_ _1697_ _1700_ _1701_ _1702_ VGND VGND VPWR VPWR _1703_ sky130_fd_sc_hd__a221o_1
XFILLER_0_19_234 VGND VGND VPWR VPWR sky130_fd_sc_hd__fill_2
X_7726_ registers\[24\]\[31\] _3499_ _3756_ VGND VGND VPWR VPWR _3791_ sky130_fd_sc_hd__mux2_1
X_7657_ _3133_ registers\[23\]\[31\] _3719_ VGND VGND VPWR VPWR _3754_ sky130_fd_sc_hd__mux2_1
X_4869_ registers\[4\]\[0\] registers\[5\]\[0\] registers\[6\]\[0\] registers\[7\]\[0\]
+ _1617_ _1618_ VGND VGND VPWR VPWR _1637_ sky130_fd_sc_hd__mux4_1
XFILLER_0_117_486 VGND VGND VPWR VPWR sky130_fd_sc_hd__decap_3
XFILLER_0_117_475 VGND VGND VPWR VPWR sky130_fd_sc_hd__fill_2
X_6608_ registers\[0\]\[4\] _2970_ _3175_ VGND VGND VPWR VPWR _3180_ sky130_fd_sc_hd__mux2_1
XFILLER_0_105_604 VGND VGND VPWR VPWR sky130_fd_sc_hd__decap_8
XPHY_EDGE_ROW_90_Right_90 VGND VGND VPWR VPWR sky130_fd_sc_hd__decap_3
XFILLER_0_7_684 VGND VGND VPWR VPWR sky130_fd_sc_hd__fill_2
XFILLER_0_7_673 VGND VGND VPWR VPWR sky130_fd_sc_hd__fill_2
XFILLER_0_104_114 VGND VGND VPWR VPWR sky130_fd_sc_hd__fill_2
X_7588_ _3717_ VGND VGND VPWR VPWR _0215_ sky130_fd_sc_hd__clkbuf_1
XANTENNA__5450__S0 _2076_ VGND VGND VPWR VPWR sky130_fd_sc_hd__diode_2
X_6539_ _3142_ VGND VGND VPWR VPWR _0765_ sky130_fd_sc_hd__clkbuf_1
X_9327_ clknet_leaf_48_clk _0424_ VGND VGND VPWR VPWR registers\[2\]\[15\] sky130_fd_sc_hd__dfxtp_1
XPHY_EDGE_ROW_65_Left_185 VGND VGND VPWR VPWR sky130_fd_sc_hd__decap_3
X_9258_ clknet_leaf_38_clk _0355_ VGND VGND VPWR VPWR registers\[27\]\[10\] sky130_fd_sc_hd__dfxtp_1
XFILLER_0_30_465 VGND VGND VPWR VPWR sky130_fd_sc_hd__fill_2
XFILLER_0_100_331 VGND VGND VPWR VPWR sky130_fd_sc_hd__fill_2
X_9189_ clknet_leaf_26_clk _0286_ VGND VGND VPWR VPWR registers\[25\]\[5\] sky130_fd_sc_hd__dfxtp_1
X_8209_ _4047_ VGND VGND VPWR VPWR _0506_ sky130_fd_sc_hd__clkbuf_1
XFILLER_0_100_375 VGND VGND VPWR VPWR sky130_fd_sc_hd__fill_2
XTAP_TAPCELL_ROW_7_355 VGND VPWR sky130_fd_sc_hd__tapvpwrvgnd_1
XTAP_TAPCELL_ROW_7_344 VGND VPWR sky130_fd_sc_hd__tapvpwrvgnd_1
XTAP_TAPCELL_ROW_89_1414 VGND VPWR sky130_fd_sc_hd__tapvpwrvgnd_1
XANTENNA__6083__A1 _2490_ VGND VGND VPWR VPWR sky130_fd_sc_hd__diode_2
XANTENNA__4357__S _1148_ VGND VGND VPWR VPWR sky130_fd_sc_hd__diode_2
XPHY_EDGE_ROW_74_Left_194 VGND VGND VPWR VPWR sky130_fd_sc_hd__decap_3
XANTENNA__7668__S _3757_ VGND VGND VPWR VPWR sky130_fd_sc_hd__diode_2
XFILLER_0_43_19 VGND VGND VPWR VPWR sky130_fd_sc_hd__decap_4
XANTENNA__6572__S _3159_ VGND VGND VPWR VPWR sky130_fd_sc_hd__diode_2
XFILLER_0_97_465 VGND VGND VPWR VPWR sky130_fd_sc_hd__fill_2
XFILLER_0_57_318 VGND VGND VPWR VPWR sky130_fd_sc_hd__decap_3
XANTENNA__5269__S0 _1968_ VGND VGND VPWR VPWR sky130_fd_sc_hd__diode_2
XFILLER_0_85_638 VGND VGND VPWR VPWR sky130_fd_sc_hd__fill_2
XTAP_TAPCELL_ROW_54_961 VGND VPWR sky130_fd_sc_hd__tapvpwrvgnd_1
XANTENNA__5594__B1 _2328_ VGND VGND VPWR VPWR sky130_fd_sc_hd__diode_2
XANTENNA__8499__S _4200_ VGND VGND VPWR VPWR sky130_fd_sc_hd__diode_2
XANTENNA__4492__S1 _1204_ VGND VGND VPWR VPWR sky130_fd_sc_hd__diode_2
XFILLER_0_65_384 VGND VGND VPWR VPWR sky130_fd_sc_hd__fill_2
XFILLER_0_108_475 VGND VGND VPWR VPWR sky130_fd_sc_hd__fill_1
XFILLER_0_53_557 VGND VGND VPWR VPWR sky130_fd_sc_hd__decap_3
XANTENNA__5897__A1 _2399_ VGND VGND VPWR VPWR sky130_fd_sc_hd__diode_2
XANTENNA__5441__S0 _1758_ VGND VGND VPWR VPWR sky130_fd_sc_hd__diode_2
XFILLER_0_33_281 VGND VGND VPWR VPWR sky130_fd_sc_hd__decap_3
XFILLER_0_104_681 VGND VGND VPWR VPWR sky130_fd_sc_hd__fill_1
XFILLER_0_68_27 VGND VGND VPWR VPWR sky130_fd_sc_hd__fill_1
XFILLER_0_0_304 VGND VGND VPWR VPWR sky130_fd_sc_hd__fill_2
XFILLER_0_21_432 VGND VGND VPWR VPWR sky130_fd_sc_hd__fill_2
XANTENNA__6747__S _3250_ VGND VGND VPWR VPWR sky130_fd_sc_hd__diode_2
XFILLER_0_0_359 VGND VGND VPWR VPWR sky130_fd_sc_hd__decap_3
XFILLER_0_84_15 VGND VGND VPWR VPWR sky130_fd_sc_hd__fill_2
XFILLER_0_17_42 VGND VGND VPWR VPWR sky130_fd_sc_hd__decap_4
XANTENNA__6482__S _3090_ VGND VGND VPWR VPWR sky130_fd_sc_hd__diode_2
XTAP_TAPCELL_ROW_109_1672 VGND VPWR sky130_fd_sc_hd__tapvpwrvgnd_1
X_5910_ _2287_ _2291_ net113 VGND VGND VPWR VPWR _2634_ sky130_fd_sc_hd__mux2_1
XANTENNA__5887__A _1866_ VGND VGND VPWR VPWR sky130_fd_sc_hd__diode_2
X_6890_ _3331_ VGND VGND VPWR VPWR _0927_ sky130_fd_sc_hd__clkbuf_1
X_5841_ _1108_ _2317_ VGND VGND VPWR VPWR _2569_ sky130_fd_sc_hd__or2_1
XFILLER_0_76_638 VGND VGND VPWR VPWR sky130_fd_sc_hd__fill_2
XFILLER_0_29_521 VGND VGND VPWR VPWR sky130_fd_sc_hd__fill_2
XFILLER_0_119_729 VGND VGND VPWR VPWR sky130_fd_sc_hd__decap_4
XFILLER_0_91_608 VGND VGND VPWR VPWR sky130_fd_sc_hd__decap_8
X_5772_ _2399_ _2489_ _2502_ VGND VGND VPWR VPWR net76 sky130_fd_sc_hd__o21ai_1
X_8560_ clknet_leaf_63_clk _0681_ VGND VGND VPWR VPWR registers\[19\]\[16\] sky130_fd_sc_hd__dfxtp_1
XFILLER_0_56_340 VGND VGND VPWR VPWR sky130_fd_sc_hd__fill_2
X_8491_ _4196_ VGND VGND VPWR VPWR _0639_ sky130_fd_sc_hd__clkbuf_1
XANTENNA__4483__S1 _1113_ VGND VGND VPWR VPWR sky130_fd_sc_hd__diode_2
XFILLER_0_44_524 VGND VGND VPWR VPWR sky130_fd_sc_hd__fill_2
X_4723_ _1389_ _1498_ _1109_ VGND VGND VPWR VPWR _1499_ sky130_fd_sc_hd__o21ai_1
XFILLER_0_17_716 VPWR VGND VPWR VGND sky130_ef_sc_hd__decap_12
X_7511_ _3123_ registers\[21\]\[26\] _3670_ VGND VGND VPWR VPWR _3677_ sky130_fd_sc_hd__mux2_1
XFILLER_0_44_557 VGND VGND VPWR VPWR sky130_fd_sc_hd__fill_2
X_7442_ _3640_ VGND VGND VPWR VPWR _0146_ sky130_fd_sc_hd__clkbuf_1
XTAP_TAPCELL_ROW_32_677 VGND VPWR sky130_fd_sc_hd__tapvpwrvgnd_1
XFILLER_0_114_412 VGND VGND VPWR VPWR sky130_fd_sc_hd__decap_8
XFILLER_0_71_376 VGND VGND VPWR VPWR sky130_fd_sc_hd__fill_2
XFILLER_0_44_579 VGND VGND VPWR VPWR sky130_fd_sc_hd__fill_2
XANTENNA__5432__S0 _2027_ VGND VGND VPWR VPWR sky130_fd_sc_hd__diode_2
X_4654_ _1321_ VGND VGND VPWR VPWR _1434_ sky130_fd_sc_hd__buf_4
XANTENNA__4235__S1 _1027_ VGND VGND VPWR VPWR sky130_fd_sc_hd__diode_2
XFILLER_0_32_719 VGND VGND VPWR VPWR sky130_fd_sc_hd__decap_8
X_4585_ registers\[0\]\[17\] registers\[1\]\[17\] registers\[2\]\[17\] registers\[3\]\[17\]
+ _1201_ _1204_ VGND VGND VPWR VPWR _1368_ sky130_fd_sc_hd__mux4_1
X_7373_ _3603_ VGND VGND VPWR VPWR _0114_ sky130_fd_sc_hd__clkbuf_1
XFILLER_0_101_117 VGND VGND VPWR VPWR sky130_fd_sc_hd__fill_1
XTAP_TAPCELL_ROW_73_1204 VGND VPWR sky130_fd_sc_hd__tapvpwrvgnd_1
XANTENNA__5127__A _1882_ VGND VGND VPWR VPWR sky130_fd_sc_hd__diode_2
X_9112_ clknet_leaf_86_clk _0209_ VGND VGND VPWR VPWR registers\[22\]\[24\] sky130_fd_sc_hd__dfxtp_1
X_6324_ registers\[19\]\[21\] _3006_ _3004_ VGND VGND VPWR VPWR _3007_ sky130_fd_sc_hd__mux2_1
X_9043_ clknet_leaf_46_clk _0140_ VGND VGND VPWR VPWR registers\[20\]\[19\] sky130_fd_sc_hd__dfxtp_1
X_6255_ net12 net11 net13 VGND VGND VPWR VPWR _2959_ sky130_fd_sc_hd__or3b_4
X_5206_ _1955_ _1956_ _1746_ VGND VGND VPWR VPWR _1957_ sky130_fd_sc_hd__mux2_1
X_6186_ _2359_ _2317_ VGND VGND VPWR VPWR _2894_ sky130_fd_sc_hd__or2_1
XTAP_TAPCELL_ROW_4_314 VGND VPWR sky130_fd_sc_hd__tapvpwrvgnd_1
X_5137_ registers\[12\]\[13\] registers\[13\]\[13\] registers\[14\]\[13\] registers\[15\]\[13\]
+ _1742_ _1743_ VGND VGND VPWR VPWR _1892_ sky130_fd_sc_hd__mux4_1
XFILLER_0_98_229 VGND VGND VPWR VPWR sky130_fd_sc_hd__decap_4
X_5068_ registers\[4\]\[9\] registers\[5\]\[9\] registers\[6\]\[9\] registers\[7\]\[9\]
+ _1762_ _1764_ VGND VGND VPWR VPWR _1827_ sky130_fd_sc_hd__mux4_1
XANTENNA__7488__S _3659_ VGND VGND VPWR VPWR sky130_fd_sc_hd__diode_2
XANTENNA__6392__S _3041_ VGND VGND VPWR VPWR sky130_fd_sc_hd__diode_2
XTAP_TAPCELL_ROW_84_1355 VGND VPWR sky130_fd_sc_hd__tapvpwrvgnd_1
XFILLER_0_67_638 VGND VGND VPWR VPWR sky130_fd_sc_hd__fill_2
XPHY_EDGE_ROW_0_Right_0 VGND VGND VPWR VPWR sky130_fd_sc_hd__decap_3
X_8827_ clknet_leaf_102_clk _0948_ VGND VGND VPWR VPWR registers\[13\]\[27\] sky130_fd_sc_hd__dfxtp_1
XTAP_TAPCELL_ROW_51_920 VGND VPWR sky130_fd_sc_hd__tapvpwrvgnd_1
X_8758_ clknet_leaf_95_clk _0879_ VGND VGND VPWR VPWR registers\[11\]\[22\] sky130_fd_sc_hd__dfxtp_1
XFILLER_0_75_660 VPWR VGND VPWR VGND sky130_ef_sc_hd__decap_12
XFILLER_0_47_384 VGND VGND VPWR VPWR sky130_fd_sc_hd__fill_2
X_7709_ _3782_ VGND VGND VPWR VPWR _0271_ sky130_fd_sc_hd__clkbuf_1
XFILLER_0_117_261 VGND VGND VPWR VPWR sky130_fd_sc_hd__decap_4
XFILLER_0_90_630 VGND VGND VPWR VPWR sky130_fd_sc_hd__fill_1
X_8689_ clknet_leaf_63_clk _0810_ VGND VGND VPWR VPWR registers\[0\]\[17\] sky130_fd_sc_hd__dfxtp_1
XANTENNA__8112__S _3995_ VGND VGND VPWR VPWR sky130_fd_sc_hd__diode_2
XFILLER_0_15_281 VGND VGND VPWR VPWR sky130_fd_sc_hd__decap_4
XANTENNA__4551__B2 _1153_ VGND VGND VPWR VPWR sky130_fd_sc_hd__diode_2
XTAP_TAPCELL_ROW_95_1495 VGND VPWR sky130_fd_sc_hd__tapvpwrvgnd_1
XFILLER_0_101_673 VGND VGND VPWR VPWR sky130_fd_sc_hd__decap_8
XANTENNA__6567__S _3148_ VGND VGND VPWR VPWR sky130_fd_sc_hd__diode_2
XFILLER_0_101_695 VPWR VGND VPWR VGND sky130_ef_sc_hd__decap_12
XANTENNA_input33_A wd3[25] VGND VGND VPWR VPWR sky130_fd_sc_hd__diode_2
XPHY_EDGE_ROW_82_Left_202 VGND VGND VPWR VPWR sky130_fd_sc_hd__decap_3
XFILLER_0_85_413 VGND VGND VPWR VPWR sky130_fd_sc_hd__decap_6
XFILLER_0_58_627 VGND VGND VPWR VPWR sky130_fd_sc_hd__decap_3
XFILLER_0_57_126 VGND VGND VPWR VPWR sky130_fd_sc_hd__fill_1
XFILLER_0_57_159 VGND VGND VPWR VPWR sky130_fd_sc_hd__decap_3
XFILLER_0_93_490 VGND VGND VPWR VPWR sky130_fd_sc_hd__decap_3
XPHY_EDGE_ROW_91_Left_211 VGND VGND VPWR VPWR sky130_fd_sc_hd__decap_3
XANTENNA__7308__A1 _3491_ VGND VGND VPWR VPWR sky130_fd_sc_hd__diode_2
XFILLER_0_26_524 VGND VGND VPWR VPWR sky130_fd_sc_hd__fill_2
XFILLER_0_80_151 VGND VGND VPWR VPWR sky130_fd_sc_hd__decap_3
XANTENNA__4550__S _1131_ VGND VGND VPWR VPWR sky130_fd_sc_hd__diode_2
XANTENNA__5414__S0 _2072_ VGND VGND VPWR VPWR sky130_fd_sc_hd__diode_2
XFILLER_0_110_56 VGND VGND VPWR VPWR sky130_fd_sc_hd__fill_2
X_4370_ _1159_ _1164_ _1143_ VGND VGND VPWR VPWR _1165_ sky130_fd_sc_hd__a21oi_1
XFILLER_0_95_14 VGND VGND VPWR VPWR sky130_fd_sc_hd__fill_2
XFILLER_0_1_657 VGND VGND VPWR VPWR sky130_fd_sc_hd__fill_1
XANTENNA__7492__A0 _3104_ VGND VGND VPWR VPWR sky130_fd_sc_hd__diode_2
XFILLER_0_0_178 VGND VGND VPWR VPWR sky130_fd_sc_hd__fill_1
X_6040_ _2365_ _2369_ VGND VGND VPWR VPWR _2757_ sky130_fd_sc_hd__nand2_1
XFILLER_0_28_85 VGND VGND VPWR VPWR sky130_fd_sc_hd__fill_2
X_7991_ _3931_ VGND VGND VPWR VPWR _0404_ sky130_fd_sc_hd__clkbuf_1
XFILLER_0_88_251 VGND VGND VPWR VPWR sky130_fd_sc_hd__fill_1
XANTENNA__6506__A net33 VGND VGND VPWR VPWR sky130_fd_sc_hd__diode_2
X_6942_ _3358_ VGND VGND VPWR VPWR _0952_ sky130_fd_sc_hd__clkbuf_1
XTAP_TAPCELL_ROW_37_736 VGND VPWR sky130_fd_sc_hd__tapvpwrvgnd_1
X_6873_ registers\[12\]\[31\] _3026_ _3287_ VGND VGND VPWR VPWR _3322_ sky130_fd_sc_hd__mux2_1
XFILLER_0_119_537 VGND VGND VPWR VPWR sky130_fd_sc_hd__decap_8
X_8612_ clknet_leaf_28_clk _0733_ VGND VGND VPWR VPWR registers\[29\]\[4\] sky130_fd_sc_hd__dfxtp_1
X_5824_ _2477_ _2521_ _2519_ _2529_ _2523_ VGND VGND VPWR VPWR _2552_ sky130_fd_sc_hd__a221o_1
XFILLER_0_48_159 VGND VGND VPWR VPWR sky130_fd_sc_hd__fill_1
XFILLER_0_8_201 VGND VGND VPWR VPWR sky130_fd_sc_hd__decap_6
XFILLER_0_9_724 VGND VGND VPWR VPWR sky130_fd_sc_hd__decap_4
XTAP_TAPCELL_ROW_17_482 VGND VPWR sky130_fd_sc_hd__tapvpwrvgnd_1
XANTENNA__4456__S1 _1203_ VGND VGND VPWR VPWR sky130_fd_sc_hd__diode_2
XFILLER_0_64_619 VGND VGND VPWR VPWR sky130_fd_sc_hd__fill_2
XFILLER_0_57_671 VGND VGND VPWR VPWR sky130_fd_sc_hd__fill_1
XFILLER_0_8_245 VGND VGND VPWR VPWR sky130_fd_sc_hd__fill_2
XFILLER_0_91_449 VGND VGND VPWR VPWR sky130_fd_sc_hd__fill_1
X_5755_ _1166_ _2485_ VGND VGND VPWR VPWR _2486_ sky130_fd_sc_hd__xnor2_1
XFILLER_0_72_630 VGND VGND VPWR VPWR sky130_fd_sc_hd__fill_2
X_8543_ _4223_ VGND VGND VPWR VPWR _0664_ sky130_fd_sc_hd__clkbuf_1
XFILLER_0_8_267 VGND VGND VPWR VPWR sky130_fd_sc_hd__fill_2
XFILLER_0_115_721 VGND VGND VPWR VPWR sky130_fd_sc_hd__decap_6
XFILLER_0_97_3 VGND VGND VPWR VPWR sky130_fd_sc_hd__fill_2
X_5686_ _2276_ VGND VGND VPWR VPWR _2420_ sky130_fd_sc_hd__clkbuf_4
X_4706_ _1159_ _1482_ _1143_ VGND VGND VPWR VPWR _1483_ sky130_fd_sc_hd__a21oi_1
X_8474_ registers\[8\]\[31\] net40 _4152_ VGND VGND VPWR VPWR _4187_ sky130_fd_sc_hd__mux2_1
XFILLER_0_32_516 VGND VGND VPWR VPWR sky130_fd_sc_hd__fill_2
XFILLER_0_114_253 VGND VGND VPWR VPWR sky130_fd_sc_hd__decap_4
X_7425_ _3631_ VGND VGND VPWR VPWR _0138_ sky130_fd_sc_hd__clkbuf_1
XFILLER_0_72_696 VGND VGND VPWR VPWR sky130_fd_sc_hd__fill_2
XFILLER_0_44_398 VGND VGND VPWR VPWR sky130_fd_sc_hd__fill_2
XANTENNA__5405__S0 _2072_ VGND VGND VPWR VPWR sky130_fd_sc_hd__diode_2
X_4637_ registers\[20\]\[20\] registers\[21\]\[20\] registers\[22\]\[20\] registers\[23\]\[20\]
+ _1415_ _1416_ VGND VGND VPWR VPWR _1417_ sky130_fd_sc_hd__mux4_1
XANTENNA__4533__A1 _1143_ VGND VGND VPWR VPWR sky130_fd_sc_hd__diode_2
XFILLER_0_71_195 VGND VGND VPWR VPWR sky130_fd_sc_hd__decap_4
X_7356_ _3594_ VGND VGND VPWR VPWR _0106_ sky130_fd_sc_hd__clkbuf_1
X_4568_ _1346_ _1349_ _1351_ _1153_ VGND VGND VPWR VPWR _1352_ sky130_fd_sc_hd__o211a_1
XFILLER_0_12_262 VGND VGND VPWR VPWR sky130_fd_sc_hd__decap_4
X_7287_ registers\[18\]\[17\] _3470_ _3550_ VGND VGND VPWR VPWR _3558_ sky130_fd_sc_hd__mux2_1
X_6307_ net23 VGND VGND VPWR VPWR _2995_ sky130_fd_sc_hd__buf_2
X_4499_ _1286_ VGND VGND VPWR VPWR net116 sky130_fd_sc_hd__inv_2
XANTENNA__6286__A1 _2980_ VGND VGND VPWR VPWR sky130_fd_sc_hd__diode_2
XFILLER_0_40_593 VGND VGND VPWR VPWR sky130_fd_sc_hd__fill_1
XFILLER_0_110_470 VGND VGND VPWR VPWR sky130_fd_sc_hd__decap_3
X_6238_ _2911_ _2919_ VGND VGND VPWR VPWR _2944_ sky130_fd_sc_hd__nand2_1
X_9026_ clknet_leaf_1_clk _0123_ VGND VGND VPWR VPWR registers\[20\]\[2\] sky130_fd_sc_hd__dfxtp_1
XANTENNA__4392__S0 _1125_ VGND VGND VPWR VPWR sky130_fd_sc_hd__diode_2
XFILLER_0_85_80 VGND VGND VPWR VPWR sky130_fd_sc_hd__fill_2
X_6169_ _2865_ _2870_ _2878_ _2429_ VGND VGND VPWR VPWR net67 sky130_fd_sc_hd__a22oi_1
XFILLER_0_99_505 VGND VGND VPWR VPWR sky130_fd_sc_hd__fill_1
Xclkbuf_leaf_96_clk clknet_4_9_0_clk VGND VGND VPWR VPWR clknet_leaf_96_clk sky130_fd_sc_hd__clkbuf_8
XFILLER_0_95_700 VGND VGND VPWR VPWR sky130_fd_sc_hd__fill_1
XANTENNA__8107__S _3984_ VGND VGND VPWR VPWR sky130_fd_sc_hd__diode_2
XANTENNA__4695__S1 _1324_ VGND VGND VPWR VPWR sky130_fd_sc_hd__diode_2
XANTENNA__7946__S _3901_ VGND VGND VPWR VPWR sky130_fd_sc_hd__diode_2
XFILLER_0_75_490 VGND VGND VPWR VPWR sky130_fd_sc_hd__decap_3
XFILLER_0_54_129 VGND VGND VPWR VPWR sky130_fd_sc_hd__fill_2
XFILLER_0_118_581 VGND VGND VPWR VPWR sky130_fd_sc_hd__fill_1
XTAP_TAPCELL_ROW_97_1524 VGND VPWR sky130_fd_sc_hd__tapvpwrvgnd_1
Xclkbuf_leaf_20_clk clknet_4_1_0_clk VGND VGND VPWR VPWR clknet_leaf_20_clk sky130_fd_sc_hd__clkbuf_8
XFILLER_0_63_663 VGND VGND VPWR VPWR sky130_fd_sc_hd__decap_3
XFILLER_0_23_505 VGND VGND VPWR VPWR sky130_fd_sc_hd__fill_2
XFILLER_0_23_527 VGND VGND VPWR VPWR sky130_fd_sc_hd__fill_2
XFILLER_0_23_538 VGND VGND VPWR VPWR sky130_fd_sc_hd__fill_1
XANTENNA__5990__A net88 VGND VGND VPWR VPWR sky130_fd_sc_hd__diode_2
XANTENNA__7710__A1 _3483_ VGND VGND VPWR VPWR sky130_fd_sc_hd__diode_2
XANTENNA__5721__B1 _2317_ VGND VGND VPWR VPWR sky130_fd_sc_hd__diode_2
XANTENNA_clkbuf_4_12_0_clk_A clknet_0_clk VGND VGND VPWR VPWR sky130_fd_sc_hd__diode_2
XFILLER_0_101_481 VGND VGND VPWR VPWR sky130_fd_sc_hd__decap_4
XANTENNA__4383__S0 _1160_ VGND VGND VPWR VPWR sky130_fd_sc_hd__diode_2
Xclkbuf_leaf_87_clk clknet_4_8_0_clk VGND VGND VPWR VPWR clknet_leaf_87_clk sky130_fd_sc_hd__clkbuf_8
XANTENNA__6326__A net30 VGND VGND VPWR VPWR sky130_fd_sc_hd__diode_2
XTAP_TAPCELL_ROW_106_1642 VGND VPWR sky130_fd_sc_hd__tapvpwrvgnd_1
XTAP_TAPCELL_ROW_106_1631 VGND VPWR sky130_fd_sc_hd__tapvpwrvgnd_1
XFILLER_0_98_593 VGND VGND VPWR VPWR sky130_fd_sc_hd__decap_8
XFILLER_0_98_582 VGND VGND VPWR VPWR sky130_fd_sc_hd__fill_2
XFILLER_0_81_27 VGND VGND VPWR VPWR sky130_fd_sc_hd__fill_2
XANTENNA__4686__S1 _1419_ VGND VGND VPWR VPWR sky130_fd_sc_hd__diode_2
XANTENNA__5230__A _1979_ VGND VGND VPWR VPWR sky130_fd_sc_hd__diode_2
XTAP_TAPCELL_ROW_34_706 VGND VPWR sky130_fd_sc_hd__tapvpwrvgnd_1
XANTENNA__6760__S _3261_ VGND VGND VPWR VPWR sky130_fd_sc_hd__diode_2
XFILLER_0_85_243 VGND VGND VPWR VPWR sky130_fd_sc_hd__fill_2
XFILLER_0_85_221 VGND VGND VPWR VPWR sky130_fd_sc_hd__fill_1
XANTENNA__7856__S _3851_ VGND VGND VPWR VPWR sky130_fd_sc_hd__diode_2
XFILLER_0_14_54 VGND VGND VPWR VPWR sky130_fd_sc_hd__decap_3
XFILLER_0_85_276 VGND VGND VPWR VPWR sky130_fd_sc_hd__fill_2
XFILLER_0_73_427 VGND VGND VPWR VPWR sky130_fd_sc_hd__fill_2
XFILLER_0_73_405 VGND VGND VPWR VPWR sky130_fd_sc_hd__fill_2
XFILLER_0_46_619 VGND VGND VPWR VPWR sky130_fd_sc_hd__fill_2
XANTENNA__4438__S1 _1054_ VGND VGND VPWR VPWR sky130_fd_sc_hd__diode_2
XFILLER_0_116_529 VGND VGND VPWR VPWR sky130_fd_sc_hd__decap_3
XFILLER_0_73_449 VGND VGND VPWR VPWR sky130_fd_sc_hd__fill_2
XFILLER_0_54_641 VGND VGND VPWR VPWR sky130_fd_sc_hd__decap_3
XFILLER_0_38_181 VGND VGND VPWR VPWR sky130_fd_sc_hd__decap_4
XTAP_TAPCELL_ROW_14_441 VGND VPWR sky130_fd_sc_hd__tapvpwrvgnd_1
X_5540_ net15 VGND VGND VPWR VPWR _2276_ sky130_fd_sc_hd__buf_2
XFILLER_0_54_663 VGND VGND VPWR VPWR sky130_fd_sc_hd__fill_2
Xclkbuf_leaf_11_clk clknet_4_3_0_clk VGND VGND VPWR VPWR clknet_leaf_11_clk sky130_fd_sc_hd__clkbuf_8
XFILLER_0_38_192 VGND VGND VPWR VPWR sky130_fd_sc_hd__fill_1
XANTENNA__7157__A net32 VGND VGND VPWR VPWR sky130_fd_sc_hd__diode_2
XFILLER_0_26_365 VGND VGND VPWR VPWR sky130_fd_sc_hd__decap_4
X_5471_ _1396_ _1414_ _2205_ _2206_ VGND VGND VPWR VPWR _2207_ sky130_fd_sc_hd__and4_1
XFILLER_0_5_259 VGND VGND VPWR VPWR sky130_fd_sc_hd__fill_2
XFILLER_0_112_713 VPWR VGND VPWR VGND sky130_ef_sc_hd__decap_12
X_7210_ _3517_ VGND VGND VPWR VPWR _0037_ sky130_fd_sc_hd__clkbuf_1
X_4422_ _1212_ _1213_ _1031_ VGND VGND VPWR VPWR _1214_ sky130_fd_sc_hd__mux2_1
XTAP_TAPCELL_ROW_117_1782 VGND VPWR sky130_fd_sc_hd__tapvpwrvgnd_1
X_8190_ registers\[9\]\[25\] _3487_ _4031_ VGND VGND VPWR VPWR _4037_ sky130_fd_sc_hd__mux2_1
X_4353_ _1116_ VGND VGND VPWR VPWR _1148_ sky130_fd_sc_hd__buf_4
X_7141_ net26 VGND VGND VPWR VPWR _3474_ sky130_fd_sc_hd__buf_2
XANTENNA__4610__S1 _1391_ VGND VGND VPWR VPWR sky130_fd_sc_hd__diode_2
XFILLER_0_39_84 VGND VGND VPWR VPWR sky130_fd_sc_hd__fill_2
XFILLER_0_1_498 VGND VGND VPWR VPWR sky130_fd_sc_hd__decap_3
X_7072_ _3428_ VGND VGND VPWR VPWR _1012_ sky130_fd_sc_hd__clkbuf_1
X_4284_ _1031_ _1081_ VGND VGND VPWR VPWR _1082_ sky130_fd_sc_hd__or2_1
X_6023_ _1979_ _2740_ VGND VGND VPWR VPWR _2741_ sky130_fd_sc_hd__xnor2_1
XANTENNA__6935__S _3346_ VGND VGND VPWR VPWR sky130_fd_sc_hd__diode_2
Xclkbuf_leaf_78_clk clknet_4_10_0_clk VGND VGND VPWR VPWR clknet_leaf_78_clk sky130_fd_sc_hd__clkbuf_8
XFILLER_0_55_61 VGND VGND VPWR VPWR sky130_fd_sc_hd__fill_2
XTAP_TAPCELL_ROW_68_1147 VGND VPWR sky130_fd_sc_hd__tapvpwrvgnd_1
X_7974_ _3922_ VGND VGND VPWR VPWR _0396_ sky130_fd_sc_hd__clkbuf_1
XFILLER_0_55_83 VGND VGND VPWR VPWR sky130_fd_sc_hd__fill_2
X_6925_ _3117_ registers\[13\]\[23\] _3346_ VGND VGND VPWR VPWR _3350_ sky130_fd_sc_hd__mux2_1
XFILLER_0_12_3 VGND VGND VPWR VPWR sky130_fd_sc_hd__decap_4
XANTENNA__4677__S1 _1434_ VGND VGND VPWR VPWR sky130_fd_sc_hd__diode_2
XTAP_TAPCELL_ROW_81_1314 VGND VPWR sky130_fd_sc_hd__tapvpwrvgnd_1
XFILLER_0_119_345 VGND VGND VPWR VPWR sky130_fd_sc_hd__fill_1
XANTENNA__4429__S1 _1202_ VGND VGND VPWR VPWR sky130_fd_sc_hd__diode_2
X_6856_ _3313_ VGND VGND VPWR VPWR _0911_ sky130_fd_sc_hd__clkbuf_1
XFILLER_0_36_118 VGND VGND VPWR VPWR sky130_fd_sc_hd__fill_1
XFILLER_0_91_235 VGND VGND VPWR VPWR sky130_fd_sc_hd__fill_2
X_5807_ _2295_ _2439_ _2535_ VGND VGND VPWR VPWR _2536_ sky130_fd_sc_hd__o21a_1
X_6787_ registers\[11\]\[23\] _3010_ _3272_ VGND VGND VPWR VPWR _3276_ sky130_fd_sc_hd__mux2_1
XFILLER_0_17_321 VGND VGND VPWR VPWR sky130_fd_sc_hd__fill_2
XFILLER_0_119_389 VGND VGND VPWR VPWR sky130_fd_sc_hd__decap_3
X_5738_ _2416_ _2469_ _2352_ VGND VGND VPWR VPWR _2470_ sky130_fd_sc_hd__mux2_1
XFILLER_0_45_663 VGND VGND VPWR VPWR sky130_fd_sc_hd__fill_2
X_8526_ registers\[4\]\[23\] net31 _4211_ VGND VGND VPWR VPWR _4215_ sky130_fd_sc_hd__mux2_1
X_5669_ _2295_ VGND VGND VPWR VPWR _2403_ sky130_fd_sc_hd__clkbuf_4
X_8457_ _4178_ VGND VGND VPWR VPWR _0623_ sky130_fd_sc_hd__clkbuf_1
XTAP_TAPCELL_ROW_79_1287 VGND VPWR sky130_fd_sc_hd__tapvpwrvgnd_1
X_7408_ _3622_ VGND VGND VPWR VPWR _0130_ sky130_fd_sc_hd__clkbuf_1
X_8388_ registers\[5\]\[22\] _3481_ _4139_ VGND VGND VPWR VPWR _4142_ sky130_fd_sc_hd__mux2_1
XFILLER_0_4_292 VGND VGND VPWR VPWR sky130_fd_sc_hd__fill_2
XTAP_TAPCELL_ROW_92_1454 VGND VPWR sky130_fd_sc_hd__tapvpwrvgnd_1
X_7339_ _3585_ VGND VGND VPWR VPWR _0098_ sky130_fd_sc_hd__clkbuf_1
XANTENNA__7006__S _3383_ VGND VGND VPWR VPWR sky130_fd_sc_hd__diode_2
XANTENNA__6259__A1 _2958_ VGND VGND VPWR VPWR sky130_fd_sc_hd__diode_2
X_9009_ clknet_leaf_49_clk _0106_ VGND VGND VPWR VPWR registers\[1\]\[17\] sky130_fd_sc_hd__dfxtp_1
Xclkbuf_leaf_69_clk clknet_4_11_0_clk VGND VGND VPWR VPWR clknet_leaf_69_clk sky130_fd_sc_hd__clkbuf_8
XANTENNA__5482__A2 _2216_ VGND VGND VPWR VPWR sky130_fd_sc_hd__diode_2
XFILLER_0_99_379 VGND VGND VPWR VPWR sky130_fd_sc_hd__decap_3
XANTENNA__5050__A _1705_ VGND VGND VPWR VPWR sky130_fd_sc_hd__diode_2
XANTENNA__4668__S1 _1428_ VGND VGND VPWR VPWR sky130_fd_sc_hd__diode_2
XANTENNA__7676__S _3757_ VGND VGND VPWR VPWR sky130_fd_sc_hd__diode_2
XANTENNA__5985__A net120 VGND VGND VPWR VPWR sky130_fd_sc_hd__diode_2
XANTENNA__6580__S _3159_ VGND VGND VPWR VPWR sky130_fd_sc_hd__diode_2
XFILLER_0_83_703 VPWR VGND VPWR VGND sky130_ef_sc_hd__decap_12
XFILLER_0_67_276 VGND VGND VPWR VPWR sky130_fd_sc_hd__fill_2
XFILLER_0_55_449 VGND VGND VPWR VPWR sky130_fd_sc_hd__fill_2
XFILLER_0_27_129 VGND VGND VPWR VPWR sky130_fd_sc_hd__fill_2
XTAP_TAPCELL_ROW_101_1572 VGND VPWR sky130_fd_sc_hd__tapvpwrvgnd_1
XTAP_TAPCELL_ROW_11_400 VGND VPWR sky130_fd_sc_hd__tapvpwrvgnd_1
Xclkload17 clknet_leaf_4_clk VGND VGND VPWR VPWR clkload17/Y sky130_fd_sc_hd__clkinv_1
XFILLER_0_35_151 VGND VGND VPWR VPWR sky130_fd_sc_hd__fill_1
XFILLER_0_106_573 VGND VGND VPWR VPWR sky130_fd_sc_hd__fill_1
Xclkload39 clknet_leaf_18_clk VGND VGND VPWR VPWR clkload39/Y sky130_fd_sc_hd__clkinvlp_2
Xclkload28 clknet_leaf_21_clk VGND VGND VPWR VPWR clkload28/Y sky130_fd_sc_hd__clkinvlp_4
XFILLER_0_11_508 VGND VGND VPWR VPWR sky130_fd_sc_hd__decap_6
XANTENNA__5458__C1 _1960_ VGND VGND VPWR VPWR sky130_fd_sc_hd__diode_2
XANTENNA__4356__S0 _1111_ VGND VGND VPWR VPWR sky130_fd_sc_hd__diode_2
XANTENNA__6755__S _3250_ VGND VGND VPWR VPWR sky130_fd_sc_hd__diode_2
Xclkbuf_leaf_0_clk clknet_4_0_0_clk VGND VGND VPWR VPWR clknet_leaf_0_clk sky130_fd_sc_hd__clkbuf_8
XANTENNA__6056__A _2011_ VGND VGND VPWR VPWR sky130_fd_sc_hd__diode_2
XTAP_TAPCELL_ROW_19_500 VGND VPWR sky130_fd_sc_hd__tapvpwrvgnd_1
XTAP_TAPCELL_ROW_19_511 VGND VPWR sky130_fd_sc_hd__tapvpwrvgnd_1
XFILLER_0_116_66 VGND VGND VPWR VPWR sky130_fd_sc_hd__fill_1
XTAP_TAPCELL_ROW_47_875 VGND VPWR sky130_fd_sc_hd__tapvpwrvgnd_1
XTAP_TAPCELL_ROW_47_864 VGND VPWR sky130_fd_sc_hd__tapvpwrvgnd_1
X_4971_ registers\[12\]\[5\] registers\[13\]\[5\] registers\[14\]\[5\] registers\[15\]\[5\]
+ _1731_ _1691_ VGND VGND VPWR VPWR _1734_ sky130_fd_sc_hd__mux4_1
X_7690_ _3772_ VGND VGND VPWR VPWR _0262_ sky130_fd_sc_hd__clkbuf_1
X_6710_ registers\[10\]\[19\] _3001_ _3225_ VGND VGND VPWR VPWR _3235_ sky130_fd_sc_hd__mux2_1
XANTENNA__8175__A1 _3472_ VGND VGND VPWR VPWR sky130_fd_sc_hd__diode_2
XFILLER_0_19_608 VGND VGND VPWR VPWR sky130_fd_sc_hd__fill_1
XTAP_TAPCELL_ROW_63_1077 VGND VPWR sky130_fd_sc_hd__tapvpwrvgnd_1
X_6641_ _3174_ VGND VGND VPWR VPWR _3197_ sky130_fd_sc_hd__clkbuf_8
XTAP_TAPCELL_ROW_119_1800 VGND VPWR sky130_fd_sc_hd__tapvpwrvgnd_1
XFILLER_0_116_326 VGND VGND VPWR VPWR sky130_fd_sc_hd__fill_2
X_9360_ clknet_leaf_64_clk _0457_ VGND VGND VPWR VPWR registers\[30\]\[16\] sky130_fd_sc_hd__dfxtp_1
XTAP_TAPCELL_ROW_119_1822 VGND VPWR sky130_fd_sc_hd__tapvpwrvgnd_1
XTAP_TAPCELL_ROW_119_1811 VGND VPWR sky130_fd_sc_hd__tapvpwrvgnd_1
X_8311_ _2999_ registers\[31\]\[18\] _4092_ VGND VGND VPWR VPWR _4101_ sky130_fd_sc_hd__mux2_1
XFILLER_0_54_471 VGND VGND VPWR VPWR sky130_fd_sc_hd__decap_4
X_6572_ registers\[7\]\[20\] _3003_ _3159_ VGND VGND VPWR VPWR _3160_ sky130_fd_sc_hd__mux2_1
X_9291_ clknet_leaf_56_clk _0388_ VGND VGND VPWR VPWR registers\[28\]\[11\] sky130_fd_sc_hd__dfxtp_1
X_5523_ _2182_ _2213_ VGND VGND VPWR VPWR _2259_ sky130_fd_sc_hd__or2_1
X_8242_ _4064_ VGND VGND VPWR VPWR _0522_ sky130_fd_sc_hd__clkbuf_1
XFILLER_0_42_688 VPWR VGND VPWR VGND sky130_ef_sc_hd__decap_12
XFILLER_0_41_165 VGND VGND VPWR VPWR sky130_fd_sc_hd__decap_3
X_5454_ _2081_ _2190_ _2019_ VGND VGND VPWR VPWR _2191_ sky130_fd_sc_hd__a21o_1
XANTENNA__8210__S _4045_ VGND VGND VPWR VPWR sky130_fd_sc_hd__diode_2
X_8173_ registers\[9\]\[17\] _3470_ _4020_ VGND VGND VPWR VPWR _4028_ sky130_fd_sc_hd__mux2_1
X_4405_ _1197_ VGND VGND VPWR VPWR _1198_ sky130_fd_sc_hd__clkbuf_8
XANTENNA__4595__S0 _1338_ VGND VGND VPWR VPWR sky130_fd_sc_hd__diode_2
X_5385_ _2020_ VGND VGND VPWR VPWR _2126_ sky130_fd_sc_hd__buf_4
XFILLER_0_112_587 VGND VGND VPWR VPWR sky130_fd_sc_hd__fill_1
X_4336_ _1131_ VGND VGND VPWR VPWR _1132_ sky130_fd_sc_hd__clkbuf_8
X_7124_ registers\[16\]\[13\] _3462_ _3456_ VGND VGND VPWR VPWR _3463_ sky130_fd_sc_hd__mux2_1
XFILLER_0_5_30 VGND VGND VPWR VPWR sky130_fd_sc_hd__fill_2
X_7055_ _3419_ VGND VGND VPWR VPWR _1004_ sky130_fd_sc_hd__clkbuf_1
X_4267_ registers\[4\]\[1\] registers\[5\]\[1\] registers\[6\]\[1\] registers\[7\]\[1\]
+ _1060_ _1061_ VGND VGND VPWR VPWR _1066_ sky130_fd_sc_hd__mux4_1
X_6006_ _2723_ _2724_ _2352_ VGND VGND VPWR VPWR _2725_ sky130_fd_sc_hd__mux2_1
XANTENNA__4898__S1 _1618_ VGND VGND VPWR VPWR sky130_fd_sc_hd__diode_2
XFILLER_0_96_327 VGND VGND VPWR VPWR sky130_fd_sc_hd__decap_3
XFILLER_0_96_305 VGND VGND VPWR VPWR sky130_fd_sc_hd__decap_3
XANTENNA__6413__A1 _3016_ VGND VGND VPWR VPWR sky130_fd_sc_hd__diode_2
X_7957_ _2985_ registers\[28\]\[11\] _3912_ VGND VGND VPWR VPWR _3914_ sky130_fd_sc_hd__mux2_1
XFILLER_0_89_390 VGND VGND VPWR VPWR sky130_fd_sc_hd__fill_2
XANTENNA__7496__S _3659_ VGND VGND VPWR VPWR sky130_fd_sc_hd__diode_2
X_7888_ _3877_ VGND VGND VPWR VPWR _0355_ sky130_fd_sc_hd__clkbuf_1
X_6908_ _3100_ registers\[13\]\[15\] _3335_ VGND VGND VPWR VPWR _3341_ sky130_fd_sc_hd__mux2_1
XFILLER_0_119_153 VGND VGND VPWR VPWR sky130_fd_sc_hd__decap_4
X_6839_ _3304_ VGND VGND VPWR VPWR _0903_ sky130_fd_sc_hd__clkbuf_1
XFILLER_0_92_577 VGND VGND VPWR VPWR sky130_fd_sc_hd__decap_3
XFILLER_0_80_717 VGND VGND VPWR VPWR sky130_fd_sc_hd__fill_2
XFILLER_0_52_408 VGND VGND VPWR VPWR sky130_fd_sc_hd__decap_8
XFILLER_0_17_140 VGND VGND VPWR VPWR sky130_fd_sc_hd__fill_2
XFILLER_0_119_197 VPWR VGND VPWR VGND sky130_ef_sc_hd__decap_12
X_9558_ clknet_leaf_95_clk _0655_ VGND VGND VPWR VPWR registers\[4\]\[22\] sky130_fd_sc_hd__dfxtp_1
XFILLER_0_18_696 VGND VGND VPWR VPWR sky130_fd_sc_hd__decap_4
X_8509_ registers\[4\]\[15\] net22 _4200_ VGND VGND VPWR VPWR _4206_ sky130_fd_sc_hd__mux2_1
X_9489_ clknet_leaf_63_clk _0586_ VGND VGND VPWR VPWR registers\[5\]\[17\] sky130_fd_sc_hd__dfxtp_1
XFILLER_0_60_430 VGND VGND VPWR VPWR sky130_fd_sc_hd__fill_2
XFILLER_0_32_132 VGND VGND VPWR VPWR sky130_fd_sc_hd__fill_2
XFILLER_0_33_655 VGND VGND VPWR VPWR sky130_fd_sc_hd__fill_2
XFILLER_0_103_543 VGND VGND VPWR VPWR sky130_fd_sc_hd__decap_3
XANTENNA__8120__S _3995_ VGND VGND VPWR VPWR sky130_fd_sc_hd__diode_2
XFILLER_0_32_165 VGND VGND VPWR VPWR sky130_fd_sc_hd__decap_4
XFILLER_0_20_349 VGND VGND VPWR VPWR sky130_fd_sc_hd__fill_1
XFILLER_0_1_3 VPWR VGND VPWR VGND sky130_ef_sc_hd__decap_12
XANTENNA__4889__S1 _1629_ VGND VGND VPWR VPWR sky130_fd_sc_hd__diode_2
XANTENNA__6652__A1 _3014_ VGND VGND VPWR VPWR sky130_fd_sc_hd__diode_2
XFILLER_0_87_316 VGND VGND VPWR VPWR sky130_fd_sc_hd__fill_2
XANTENNA_clkbuf_leaf_64_clk_A clknet_4_14_0_clk VGND VGND VPWR VPWR sky130_fd_sc_hd__diode_2
XTAP_TAPCELL_ROW_103_1601 VGND VPWR sky130_fd_sc_hd__tapvpwrvgnd_1
XFILLER_0_99_198 VGND VGND VPWR VPWR sky130_fd_sc_hd__fill_2
XFILLER_0_62_29 VGND VGND VPWR VPWR sky130_fd_sc_hd__decap_6
XFILLER_0_83_500 VGND VGND VPWR VPWR sky130_fd_sc_hd__fill_2
XTAP_TAPCELL_ROW_44_834 VGND VPWR sky130_fd_sc_hd__tapvpwrvgnd_1
XFILLER_0_28_405 VPWR VGND VPWR VGND sky130_ef_sc_hd__decap_12
XFILLER_0_83_544 VGND VGND VPWR VPWR sky130_fd_sc_hd__fill_2
XANTENNA__5066__S1 _1821_ VGND VGND VPWR VPWR sky130_fd_sc_hd__diode_2
XANTENNA_clkbuf_leaf_79_clk_A clknet_4_10_0_clk VGND VGND VPWR VPWR sky130_fd_sc_hd__diode_2
XFILLER_0_36_460 VGND VGND VPWR VPWR sky130_fd_sc_hd__decap_4
XFILLER_0_36_471 VGND VGND VPWR VPWR sky130_fd_sc_hd__decap_4
XANTENNA__5654__S _1072_ VGND VGND VPWR VPWR sky130_fd_sc_hd__diode_2
XFILLER_0_11_55 VGND VGND VPWR VPWR sky130_fd_sc_hd__fill_1
XFILLER_0_23_110 VGND VGND VPWR VPWR sky130_fd_sc_hd__fill_2
XFILLER_0_51_463 VGND VGND VPWR VPWR sky130_fd_sc_hd__fill_2
XFILLER_0_11_77 VGND VGND VPWR VPWR sky130_fd_sc_hd__fill_2
XANTENNA__5143__A1 _1771_ VGND VGND VPWR VPWR sky130_fd_sc_hd__diode_2
XFILLER_0_11_327 VGND VGND VPWR VPWR sky130_fd_sc_hd__fill_2
XANTENNA__4577__S0 _1160_ VGND VGND VPWR VPWR sky130_fd_sc_hd__diode_2
XTAP_TAPCELL_ROW_114_1741 VGND VPWR sky130_fd_sc_hd__tapvpwrvgnd_1
X_5170_ registers\[0\]\[15\] registers\[1\]\[15\] registers\[2\]\[15\] registers\[3\]\[15\]
+ _1742_ _1743_ VGND VGND VPWR VPWR _1923_ sky130_fd_sc_hd__mux4_1
XANTENNA_clkbuf_leaf_17_clk_A clknet_4_6_0_clk VGND VGND VPWR VPWR sky130_fd_sc_hd__diode_2
XANTENNA__8093__A0 _2985_ VGND VGND VPWR VPWR sky130_fd_sc_hd__diode_2
XANTENNA__6485__S _3090_ VGND VGND VPWR VPWR sky130_fd_sc_hd__diode_2
XANTENNA__7840__A0 _3110_ VGND VGND VPWR VPWR sky130_fd_sc_hd__diode_2
Xinput4 a1[3] VGND VGND VPWR VPWR net4 sky130_fd_sc_hd__clkbuf_2
XFILLER_0_78_305 VGND VGND VPWR VPWR sky130_fd_sc_hd__decap_3
X_8860_ clknet_leaf_105_clk _0981_ VGND VGND VPWR VPWR registers\[14\]\[28\] sky130_fd_sc_hd__dfxtp_1
XANTENNA__8396__A1 _3489_ VGND VGND VPWR VPWR sky130_fd_sc_hd__diode_2
XFILLER_0_36_85 VGND VGND VPWR VPWR sky130_fd_sc_hd__decap_4
X_7811_ _3836_ VGND VGND VPWR VPWR _0319_ sky130_fd_sc_hd__clkbuf_1
XTAP_TAPCELL_ROW_65_1106 VGND VPWR sky130_fd_sc_hd__tapvpwrvgnd_1
X_8791_ clknet_leaf_73_clk _0912_ VGND VGND VPWR VPWR registers\[12\]\[23\] sky130_fd_sc_hd__dfxtp_1
XANTENNA__8148__A1 _3445_ VGND VGND VPWR VPWR sky130_fd_sc_hd__diode_2
X_4954_ _1714_ _1717_ VGND VGND VPWR VPWR _1718_ sky130_fd_sc_hd__nand2_1
XANTENNA__4501__S0 _1167_ VGND VGND VPWR VPWR sky130_fd_sc_hd__diode_2
X_7742_ _3081_ registers\[25\]\[6\] _3793_ VGND VGND VPWR VPWR _3800_ sky130_fd_sc_hd__mux2_1
XFILLER_0_86_360 VGND VGND VPWR VPWR sky130_fd_sc_hd__fill_1
XFILLER_0_74_522 VGND VGND VPWR VPWR sky130_fd_sc_hd__fill_2
XFILLER_0_19_449 VGND VGND VPWR VPWR sky130_fd_sc_hd__fill_2
XFILLER_0_116_101 VGND VGND VPWR VPWR sky130_fd_sc_hd__fill_2
X_9412_ clknet_leaf_30_clk _0509_ VGND VGND VPWR VPWR registers\[6\]\[4\] sky130_fd_sc_hd__dfxtp_1
X_7673_ _3763_ VGND VGND VPWR VPWR _0254_ sky130_fd_sc_hd__clkbuf_1
XFILLER_0_62_717 VGND VGND VPWR VPWR sky130_fd_sc_hd__fill_2
X_4885_ registers\[12\]\[1\] registers\[13\]\[1\] registers\[14\]\[1\] registers\[15\]\[1\]
+ _1628_ _1629_ VGND VGND VPWR VPWR _1652_ sky130_fd_sc_hd__mux4_1
XTAP_TAPCELL_ROW_22_539 VGND VPWR sky130_fd_sc_hd__tapvpwrvgnd_1
X_6624_ _3188_ VGND VGND VPWR VPWR _0804_ sky130_fd_sc_hd__clkbuf_1
XFILLER_0_15_611 VGND VGND VPWR VPWR sky130_fd_sc_hd__fill_2
XANTENNA_clkbuf_4_0_0_clk_A clknet_0_clk VGND VGND VPWR VPWR sky130_fd_sc_hd__diode_2
XFILLER_0_34_419 VGND VGND VPWR VPWR sky130_fd_sc_hd__fill_1
X_6555_ registers\[7\]\[12\] _2987_ _3148_ VGND VGND VPWR VPWR _3151_ sky130_fd_sc_hd__mux2_1
XFILLER_0_61_238 VGND VGND VPWR VPWR sky130_fd_sc_hd__fill_2
XFILLER_0_6_376 VGND VGND VPWR VPWR sky130_fd_sc_hd__decap_8
XFILLER_0_6_365 VGND VGND VPWR VPWR sky130_fd_sc_hd__fill_2
XFILLER_0_15_633 VGND VGND VPWR VPWR sky130_fd_sc_hd__decap_3
X_9343_ clknet_leaf_99_clk _0440_ VGND VGND VPWR VPWR registers\[2\]\[31\] sky130_fd_sc_hd__dfxtp_1
X_5506_ _2084_ _2214_ VGND VGND VPWR VPWR _2242_ sky130_fd_sc_hd__or2_1
X_9274_ clknet_leaf_77_clk _0371_ VGND VGND VPWR VPWR registers\[27\]\[26\] sky130_fd_sc_hd__dfxtp_1
XFILLER_0_112_340 VGND VGND VPWR VPWR sky130_fd_sc_hd__decap_3
XTAP_TAPCELL_ROW_76_1246 VGND VPWR sky130_fd_sc_hd__tapvpwrvgnd_1
X_8225_ _4055_ VGND VGND VPWR VPWR _0514_ sky130_fd_sc_hd__clkbuf_1
X_6486_ _3107_ VGND VGND VPWR VPWR _0747_ sky130_fd_sc_hd__clkbuf_1
X_5437_ _1856_ _2174_ VGND VGND VPWR VPWR _2175_ sky130_fd_sc_hd__and2_1
XFILLER_0_100_546 VGND VGND VPWR VPWR sky130_fd_sc_hd__fill_2
X_8156_ registers\[9\]\[9\] _3453_ _4009_ VGND VGND VPWR VPWR _4019_ sky130_fd_sc_hd__mux2_1
X_5368_ registers\[4\]\[26\] registers\[5\]\[26\] registers\[6\]\[26\] registers\[7\]\[26\]
+ _2097_ _2109_ VGND VGND VPWR VPWR _2110_ sky130_fd_sc_hd__mux4_1
X_4319_ registers\[16\]\[4\] registers\[17\]\[4\] registers\[18\]\[4\] registers\[19\]\[4\]
+ _1111_ _1113_ VGND VGND VPWR VPWR _1115_ sky130_fd_sc_hd__mux4_1
X_7107_ net46 VGND VGND VPWR VPWR _3451_ sky130_fd_sc_hd__buf_2
XFILLER_0_77_92 VPWR VGND VPWR VGND sky130_ef_sc_hd__decap_12
XANTENNA__8084__A0 _2976_ VGND VGND VPWR VPWR sky130_fd_sc_hd__diode_2
X_8087_ _3982_ VGND VGND VPWR VPWR _0449_ sky130_fd_sc_hd__clkbuf_1
X_5299_ registers\[0\]\[22\] registers\[1\]\[22\] registers\[2\]\[22\] registers\[3\]\[22\]
+ _1798_ _1799_ VGND VGND VPWR VPWR _2045_ sky130_fd_sc_hd__mux4_1
XFILLER_0_10_393 VGND VGND VPWR VPWR sky130_fd_sc_hd__fill_2
XANTENNA__4908__S _1631_ VGND VGND VPWR VPWR sky130_fd_sc_hd__diode_2
X_7038_ _3092_ registers\[15\]\[11\] _3409_ VGND VGND VPWR VPWR _3411_ sky130_fd_sc_hd__mux2_1
XFILLER_0_97_636 VGND VGND VPWR VPWR sky130_fd_sc_hd__fill_1
XFILLER_0_97_669 VGND VGND VPWR VPWR sky130_fd_sc_hd__decap_3
XFILLER_0_96_124 VGND VGND VPWR VPWR sky130_fd_sc_hd__decap_4
XTAP_TAPCELL_ROW_87_1386 VGND VPWR sky130_fd_sc_hd__tapvpwrvgnd_1
XTAP_TAPCELL_ROW_2_286 VGND VPWR sky130_fd_sc_hd__tapvpwrvgnd_1
X_8989_ clknet_leaf_106_clk _0086_ VGND VGND VPWR VPWR registers\[18\]\[29\] sky130_fd_sc_hd__dfxtp_1
XFILLER_0_96_179 VGND VGND VPWR VPWR sky130_fd_sc_hd__fill_2
XFILLER_0_65_500 VGND VGND VPWR VPWR sky130_fd_sc_hd__fill_2
XFILLER_0_77_393 VGND VGND VPWR VPWR sky130_fd_sc_hd__decap_4
XFILLER_0_80_514 VGND VGND VPWR VPWR sky130_fd_sc_hd__fill_2
XFILLER_0_65_577 VGND VGND VPWR VPWR sky130_fd_sc_hd__fill_2
XFILLER_0_52_205 VGND VGND VPWR VPWR sky130_fd_sc_hd__fill_2
XFILLER_0_107_156 VGND VGND VPWR VPWR sky130_fd_sc_hd__decap_3
XFILLER_0_18_493 VGND VGND VPWR VPWR sky130_fd_sc_hd__fill_2
XFILLER_0_107_189 VGND VGND VPWR VPWR sky130_fd_sc_hd__fill_1
XFILLER_0_21_603 VGND VGND VPWR VPWR sky130_fd_sc_hd__fill_2
XANTENNA__5125__A1 _1754_ VGND VGND VPWR VPWR sky130_fd_sc_hd__diode_2
XFILLER_0_21_625 VGND VGND VPWR VPWR sky130_fd_sc_hd__fill_2
XFILLER_0_21_636 VGND VGND VPWR VPWR sky130_fd_sc_hd__decap_6
XANTENNA__4559__S0 _1320_ VGND VGND VPWR VPWR sky130_fd_sc_hd__diode_2
XANTENNA__5220__S1 _1969_ VGND VGND VPWR VPWR sky130_fd_sc_hd__diode_2
XANTENNA__4818__S _1421_ VGND VGND VPWR VPWR sky130_fd_sc_hd__diode_2
XFILLER_0_88_603 VGND VGND VPWR VPWR sky130_fd_sc_hd__fill_2
XANTENNA_clkload9_A clknet_4_10_0_clk VGND VGND VPWR VPWR sky130_fd_sc_hd__diode_2
XANTENNA__8025__S _3948_ VGND VGND VPWR VPWR sky130_fd_sc_hd__diode_2
XANTENNA__4939__A1 _1677_ VGND VGND VPWR VPWR sky130_fd_sc_hd__diode_2
XFILLER_0_56_533 VGND VGND VPWR VPWR sky130_fd_sc_hd__fill_2
XANTENNA__7889__A0 _3092_ VGND VGND VPWR VPWR sky130_fd_sc_hd__diode_2
XFILLER_0_22_43 VGND VGND VPWR VPWR sky130_fd_sc_hd__fill_2
XFILLER_0_71_514 VGND VGND VPWR VPWR sky130_fd_sc_hd__fill_2
XTAP_TAPCELL_ROW_60_1036 VGND VPWR sky130_fd_sc_hd__tapvpwrvgnd_1
X_4670_ _1381_ _1448_ VGND VGND VPWR VPWR _1449_ sky130_fd_sc_hd__nand2_1
XFILLER_0_28_279 VGND VGND VPWR VPWR sky130_fd_sc_hd__fill_2
X_6340_ _3017_ VGND VGND VPWR VPWR _0691_ sky130_fd_sc_hd__clkbuf_1
X_6271_ registers\[19\]\[4\] _2970_ _2962_ VGND VGND VPWR VPWR _2971_ sky130_fd_sc_hd__mux2_1
XFILLER_0_12_669 VGND VGND VPWR VPWR sky130_fd_sc_hd__fill_2
X_8010_ registers\[2\]\[4\] _3443_ _3937_ VGND VGND VPWR VPWR _3942_ sky130_fd_sc_hd__mux2_1
XPHY_EDGE_ROW_102_Left_222 VGND VGND VPWR VPWR sky130_fd_sc_hd__decap_3
XANTENNA__5211__S1 _1821_ VGND VGND VPWR VPWR sky130_fd_sc_hd__diode_2
XFILLER_0_51_7 VGND VGND VPWR VPWR sky130_fd_sc_hd__fill_1
X_5222_ _1970_ _1971_ _1856_ VGND VGND VPWR VPWR _1972_ sky130_fd_sc_hd__mux2_1
X_5153_ _1905_ _1906_ _1682_ VGND VGND VPWR VPWR _1907_ sky130_fd_sc_hd__mux2_1
XANTENNA__4728__S _1421_ VGND VGND VPWR VPWR sky130_fd_sc_hd__diode_2
XTAP_TAPCELL_ROW_71_1187 VGND VPWR sky130_fd_sc_hd__tapvpwrvgnd_1
XTAP_TAPCELL_ROW_71_1176 VGND VPWR sky130_fd_sc_hd__tapvpwrvgnd_1
XANTENNA__6616__A1 _2978_ VGND VGND VPWR VPWR sky130_fd_sc_hd__diode_2
XANTENNA__5413__A _2152_ VGND VGND VPWR VPWR sky130_fd_sc_hd__diode_2
XANTENNA__6509__A net34 VGND VGND VPWR VPWR sky130_fd_sc_hd__diode_2
X_5084_ _1838_ _1841_ _1714_ VGND VGND VPWR VPWR _1842_ sky130_fd_sc_hd__mux2_1
XANTENNA__8369__A1 _3462_ VGND VGND VPWR VPWR sky130_fd_sc_hd__diode_2
X_8912_ clknet_leaf_61_clk _0009_ VGND VGND VPWR VPWR registers\[16\]\[16\] sky130_fd_sc_hd__dfxtp_1
X_8843_ clknet_leaf_53_clk _0964_ VGND VGND VPWR VPWR registers\[14\]\[11\] sky130_fd_sc_hd__dfxtp_1
XFILLER_0_78_113 VGND VGND VPWR VPWR sky130_fd_sc_hd__fill_2
XTAP_TAPCELL_ROW_27_609 VGND VPWR sky130_fd_sc_hd__tapvpwrvgnd_1
XFILLER_0_94_606 VGND VGND VPWR VPWR sky130_fd_sc_hd__fill_2
XFILLER_0_2_97 VPWR VGND VPWR VGND sky130_ef_sc_hd__decap_12
XPHY_EDGE_ROW_111_Left_231 VGND VGND VPWR VPWR sky130_fd_sc_hd__decap_3
X_8774_ clknet_leaf_32_clk _0895_ VGND VGND VPWR VPWR registers\[12\]\[6\] sky130_fd_sc_hd__dfxtp_1
XFILLER_0_94_639 VGND VGND VPWR VPWR sky130_fd_sc_hd__decap_4
XFILLER_0_93_138 VGND VGND VPWR VPWR sky130_fd_sc_hd__fill_2
X_5986_ _2203_ _2208_ _2483_ _2514_ VGND VGND VPWR VPWR _2706_ sky130_fd_sc_hd__nor4_4
XFILLER_0_86_190 VGND VGND VPWR VPWR sky130_fd_sc_hd__fill_2
X_4937_ net5 VGND VGND VPWR VPWR _1702_ sky130_fd_sc_hd__clkbuf_8
XFILLER_0_47_544 VGND VGND VPWR VPWR sky130_fd_sc_hd__fill_2
XANTENNA__7774__S _3815_ VGND VGND VPWR VPWR sky130_fd_sc_hd__diode_2
X_7725_ _3790_ VGND VGND VPWR VPWR _0279_ sky130_fd_sc_hd__clkbuf_1
X_7656_ _3753_ VGND VGND VPWR VPWR _0247_ sky130_fd_sc_hd__clkbuf_1
XFILLER_0_7_652 VGND VGND VPWR VPWR sky130_fd_sc_hd__fill_2
X_4868_ net4 VGND VGND VPWR VPWR _1636_ sky130_fd_sc_hd__inv_2
XFILLER_0_35_717 VGND VGND VPWR VPWR sky130_fd_sc_hd__fill_2
X_6607_ _3179_ VGND VGND VPWR VPWR _0796_ sky130_fd_sc_hd__clkbuf_1
XANTENNA__4789__S0 _1550_ VGND VGND VPWR VPWR sky130_fd_sc_hd__diode_2
XFILLER_0_117_498 VGND VGND VPWR VPWR sky130_fd_sc_hd__fill_2
X_9326_ clknet_leaf_39_clk _0423_ VGND VGND VPWR VPWR registers\[2\]\[14\] sky130_fd_sc_hd__dfxtp_1
X_7587_ _3131_ registers\[22\]\[30\] _3683_ VGND VGND VPWR VPWR _3717_ sky130_fd_sc_hd__mux2_1
X_4799_ registers\[20\]\[29\] registers\[21\]\[29\] registers\[22\]\[29\] registers\[23\]\[29\]
+ _1555_ _1556_ VGND VGND VPWR VPWR _1570_ sky130_fd_sc_hd__mux4_1
XFILLER_0_15_441 VGND VGND VPWR VPWR sky130_fd_sc_hd__fill_1
XFILLER_0_15_463 VGND VGND VPWR VPWR sky130_fd_sc_hd__fill_2
XANTENNA__5450__S1 _2026_ VGND VGND VPWR VPWR sky130_fd_sc_hd__diode_2
X_6538_ registers\[7\]\[4\] _2970_ _3137_ VGND VGND VPWR VPWR _3142_ sky130_fd_sc_hd__mux2_1
XFILLER_0_15_474 VGND VGND VPWR VPWR sky130_fd_sc_hd__fill_2
XFILLER_0_15_485 VGND VGND VPWR VPWR sky130_fd_sc_hd__decap_4
X_6469_ net20 VGND VGND VPWR VPWR _3096_ sky130_fd_sc_hd__clkbuf_2
X_9257_ clknet_leaf_8_clk _0354_ VGND VGND VPWR VPWR registers\[27\]\[9\] sky130_fd_sc_hd__dfxtp_1
XFILLER_0_100_321 VGND VGND VPWR VPWR sky130_fd_sc_hd__fill_1
X_9188_ clknet_leaf_28_clk _0285_ VGND VGND VPWR VPWR registers\[25\]\[4\] sky130_fd_sc_hd__dfxtp_1
X_8208_ registers\[6\]\[1\] _3437_ _4045_ VGND VGND VPWR VPWR _4047_ sky130_fd_sc_hd__mux2_1
XFILLER_0_100_365 VGND VGND VPWR VPWR sky130_fd_sc_hd__decap_3
X_8139_ _4010_ VGND VGND VPWR VPWR _0473_ sky130_fd_sc_hd__clkbuf_1
XTAP_TAPCELL_ROW_7_356 VGND VPWR sky130_fd_sc_hd__tapvpwrvgnd_1
XTAP_TAPCELL_ROW_7_345 VGND VPWR sky130_fd_sc_hd__tapvpwrvgnd_1
XPHY_EDGE_ROW_102_Right_102 VGND VGND VPWR VPWR sky130_fd_sc_hd__decap_3
XFILLER_0_100_387 VGND VGND VPWR VPWR sky130_fd_sc_hd__decap_3
XTAP_TAPCELL_ROW_89_1415 VGND VPWR sky130_fd_sc_hd__tapvpwrvgnd_1
XANTENNA__6083__A2 _2560_ VGND VGND VPWR VPWR sky130_fd_sc_hd__diode_2
XANTENNA__4713__S0 _1418_ VGND VGND VPWR VPWR sky130_fd_sc_hd__diode_2
XANTENNA__6853__S _3310_ VGND VGND VPWR VPWR sky130_fd_sc_hd__diode_2
XFILLER_0_97_422 VGND VGND VPWR VPWR sky130_fd_sc_hd__fill_2
XFILLER_0_85_617 VGND VGND VPWR VPWR sky130_fd_sc_hd__decap_4
XANTENNA__5269__S1 _1969_ VGND VGND VPWR VPWR sky130_fd_sc_hd__diode_2
XFILLER_0_97_499 VGND VGND VPWR VPWR sky130_fd_sc_hd__fill_2
XFILLER_0_97_488 VGND VGND VPWR VPWR sky130_fd_sc_hd__fill_2
XFILLER_0_85_628 VGND VGND VPWR VPWR sky130_fd_sc_hd__decap_3
XFILLER_0_84_127 VGND VGND VPWR VPWR sky130_fd_sc_hd__fill_2
XTAP_TAPCELL_ROW_54_962 VGND VPWR sky130_fd_sc_hd__tapvpwrvgnd_1
XANTENNA__5594__A1 _2321_ VGND VGND VPWR VPWR sky130_fd_sc_hd__diode_2
XFILLER_0_38_544 VGND VGND VPWR VPWR sky130_fd_sc_hd__fill_2
XFILLER_0_38_533 VGND VGND VPWR VPWR sky130_fd_sc_hd__fill_2
XFILLER_0_26_706 VGND VGND VPWR VPWR sky130_fd_sc_hd__decap_4
XFILLER_0_53_525 VGND VGND VPWR VPWR sky130_fd_sc_hd__fill_2
XFILLER_0_53_514 VGND VGND VPWR VPWR sky130_fd_sc_hd__fill_2
XFILLER_0_53_503 VGND VGND VPWR VPWR sky130_fd_sc_hd__fill_1
XFILLER_0_80_322 VGND VGND VPWR VPWR sky130_fd_sc_hd__decap_6
XANTENNA__8532__A1 net34 VGND VGND VPWR VPWR sky130_fd_sc_hd__diode_2
XANTENNA__5441__S1 _1760_ VGND VGND VPWR VPWR sky130_fd_sc_hd__diode_2
XFILLER_0_18_290 VGND VGND VPWR VPWR sky130_fd_sc_hd__fill_2
XANTENNA__7099__A1 _3445_ VGND VGND VPWR VPWR sky130_fd_sc_hd__diode_2
XANTENNA__4402__A _1153_ VGND VGND VPWR VPWR sky130_fd_sc_hd__diode_2
XFILLER_0_21_411 VGND VGND VPWR VPWR sky130_fd_sc_hd__fill_2
XFILLER_0_33_271 VGND VGND VPWR VPWR sky130_fd_sc_hd__decap_3
XFILLER_0_68_39 VGND VGND VPWR VPWR sky130_fd_sc_hd__decap_6
XFILLER_0_33_293 VGND VGND VPWR VPWR sky130_fd_sc_hd__decap_4
XTAP_TAPCELL_ROW_111_1700 VGND VPWR sky130_fd_sc_hd__tapvpwrvgnd_1
XFILLER_0_21_477 VGND VGND VPWR VPWR sky130_fd_sc_hd__fill_2
XANTENNA__4952__S0 _1690_ VGND VGND VPWR VPWR sky130_fd_sc_hd__diode_2
XANTENNA__6329__A net31 VGND VGND VPWR VPWR sky130_fd_sc_hd__diode_2
XANTENNA__4704__S0 _1415_ VGND VGND VPWR VPWR sky130_fd_sc_hd__diode_2
XTAP_TAPCELL_ROW_109_1673 VGND VPWR sky130_fd_sc_hd__tapvpwrvgnd_1
XFILLER_0_88_477 VGND VGND VPWR VPWR sky130_fd_sc_hd__decap_6
X_5840_ _2263_ _2567_ VGND VGND VPWR VPWR _2568_ sky130_fd_sc_hd__or2_1
XANTENNA__5034__B1 _1702_ VGND VGND VPWR VPWR sky130_fd_sc_hd__diode_2
XFILLER_0_75_105 VGND VGND VPWR VPWR sky130_fd_sc_hd__fill_1
XANTENNA__6064__A _2011_ VGND VGND VPWR VPWR sky130_fd_sc_hd__diode_2
XFILLER_0_118_218 VGND VGND VPWR VPWR sky130_fd_sc_hd__fill_1
X_5771_ _2200_ _2492_ _2497_ _2498_ _2501_ VGND VGND VPWR VPWR _2502_ sky130_fd_sc_hd__o221a_1
XFILLER_0_75_149 VGND VGND VPWR VPWR sky130_fd_sc_hd__fill_2
X_8490_ registers\[4\]\[6\] net44 _4189_ VGND VGND VPWR VPWR _4196_ sky130_fd_sc_hd__mux2_1
X_7510_ _3676_ VGND VGND VPWR VPWR _0178_ sky130_fd_sc_hd__clkbuf_1
X_4722_ _1496_ _1497_ _1386_ VGND VGND VPWR VPWR _1498_ sky130_fd_sc_hd__mux2_1
XFILLER_0_99_7 VGND VGND VPWR VPWR sky130_fd_sc_hd__fill_2
XFILLER_0_71_333 VGND VGND VPWR VPWR sky130_fd_sc_hd__fill_1
X_7441_ registers\[20\]\[25\] _3487_ _3634_ VGND VGND VPWR VPWR _3640_ sky130_fd_sc_hd__mux2_1
XTAP_TAPCELL_ROW_32_678 VGND VPWR sky130_fd_sc_hd__tapvpwrvgnd_1
Xinput40 wd3[31] VGND VGND VPWR VPWR net40 sky130_fd_sc_hd__clkbuf_2
X_4653_ _1320_ VGND VGND VPWR VPWR _1433_ sky130_fd_sc_hd__clkbuf_8
XFILLER_0_4_633 VGND VGND VPWR VPWR sky130_fd_sc_hd__fill_2
XFILLER_0_4_611 VGND VGND VPWR VPWR sky130_fd_sc_hd__fill_2
XANTENNA__4312__A _1108_ VGND VGND VPWR VPWR sky130_fd_sc_hd__diode_2
XFILLER_0_102_608 VGND VGND VPWR VPWR sky130_fd_sc_hd__decap_8
X_4584_ registers\[4\]\[17\] registers\[5\]\[17\] registers\[6\]\[17\] registers\[7\]\[17\]
+ _1201_ _1204_ VGND VGND VPWR VPWR _1367_ sky130_fd_sc_hd__mux4_1
XANTENNA__5432__S1 _2028_ VGND VGND VPWR VPWR sky130_fd_sc_hd__diode_2
X_7372_ registers\[1\]\[25\] _3487_ _3597_ VGND VGND VPWR VPWR _3603_ sky130_fd_sc_hd__mux2_1
XTAP_TAPCELL_ROW_73_1205 VGND VPWR sky130_fd_sc_hd__tapvpwrvgnd_1
X_9111_ clknet_leaf_70_clk _0208_ VGND VGND VPWR VPWR registers\[22\]\[23\] sky130_fd_sc_hd__dfxtp_1
X_6323_ net29 VGND VGND VPWR VPWR _3006_ sky130_fd_sc_hd__buf_2
XFILLER_0_24_293 VGND VGND VPWR VPWR sky130_fd_sc_hd__fill_1
XANTENNA__5196__S0 _1757_ VGND VGND VPWR VPWR sky130_fd_sc_hd__diode_2
XFILLER_0_110_641 VGND VGND VPWR VPWR sky130_fd_sc_hd__decap_3
X_9042_ clknet_leaf_72_clk _0139_ VGND VGND VPWR VPWR registers\[20\]\[18\] sky130_fd_sc_hd__dfxtp_1
XFILLER_0_12_477 VGND VGND VPWR VPWR sky130_fd_sc_hd__decap_6
X_6254_ net16 VGND VGND VPWR VPWR _2958_ sky130_fd_sc_hd__buf_2
X_5205_ registers\[0\]\[17\] registers\[1\]\[17\] registers\[2\]\[17\] registers\[3\]\[17\]
+ _1742_ _1743_ VGND VGND VPWR VPWR _1956_ sky130_fd_sc_hd__mux4_1
XANTENNA__4943__S0 _1705_ VGND VGND VPWR VPWR sky130_fd_sc_hd__diode_2
X_6185_ _2422_ _2886_ _2893_ VGND VGND VPWR VPWR net68 sky130_fd_sc_hd__o21a_1
XTAP_TAPCELL_ROW_4_315 VGND VPWR sky130_fd_sc_hd__tapvpwrvgnd_1
X_5136_ registers\[8\]\[13\] registers\[9\]\[13\] registers\[10\]\[13\] registers\[11\]\[13\]
+ _1742_ _1743_ VGND VGND VPWR VPWR _1891_ sky130_fd_sc_hd__mux4_1
XANTENNA__7262__A1 _3445_ VGND VGND VPWR VPWR sky130_fd_sc_hd__diode_2
XFILLER_0_74_60 VGND VGND VPWR VPWR sky130_fd_sc_hd__decap_4
XANTENNA__7769__S _3804_ VGND VGND VPWR VPWR sky130_fd_sc_hd__diode_2
X_5067_ _1822_ _1823_ _1824_ _1825_ _1809_ _1701_ VGND VGND VPWR VPWR _1826_ sky130_fd_sc_hd__mux4_2
XANTENNA__6673__S _3214_ VGND VGND VPWR VPWR sky130_fd_sc_hd__diode_2
XFILLER_0_67_606 VGND VGND VPWR VPWR sky130_fd_sc_hd__fill_2
XFILLER_0_94_414 VGND VGND VPWR VPWR sky130_fd_sc_hd__fill_2
XTAP_TAPCELL_ROW_84_1356 VGND VPWR sky130_fd_sc_hd__tapvpwrvgnd_1
XTAP_TAPCELL_ROW_84_1345 VGND VPWR sky130_fd_sc_hd__tapvpwrvgnd_1
XFILLER_0_79_499 VGND VGND VPWR VPWR sky130_fd_sc_hd__fill_2
X_8826_ clknet_leaf_85_clk _0947_ VGND VGND VPWR VPWR registers\[13\]\[26\] sky130_fd_sc_hd__dfxtp_1
XFILLER_0_109_229 VGND VGND VPWR VPWR sky130_fd_sc_hd__fill_2
X_5969_ _2307_ _2667_ VGND VGND VPWR VPWR _2689_ sky130_fd_sc_hd__or2_1
XTAP_TAPCELL_ROW_51_921 VGND VPWR sky130_fd_sc_hd__tapvpwrvgnd_1
X_8757_ clknet_leaf_84_clk _0878_ VGND VGND VPWR VPWR registers\[11\]\[21\] sky130_fd_sc_hd__dfxtp_1
XFILLER_0_81_108 VGND VGND VPWR VPWR sky130_fd_sc_hd__fill_2
XANTENNA__4921__S _1682_ VGND VGND VPWR VPWR sky130_fd_sc_hd__diode_2
X_7708_ registers\[24\]\[22\] _3481_ _3779_ VGND VGND VPWR VPWR _3782_ sky130_fd_sc_hd__mux2_1
X_8688_ clknet_leaf_64_clk _0809_ VGND VGND VPWR VPWR registers\[0\]\[16\] sky130_fd_sc_hd__dfxtp_1
XFILLER_0_35_525 VGND VGND VPWR VPWR sky130_fd_sc_hd__fill_2
XFILLER_0_90_664 VGND VGND VPWR VPWR sky130_fd_sc_hd__decap_4
X_7639_ _3115_ registers\[23\]\[22\] _3742_ VGND VGND VPWR VPWR _3745_ sky130_fd_sc_hd__mux2_1
XANTENNA__6848__S _3299_ VGND VGND VPWR VPWR sky130_fd_sc_hd__diode_2
X_9309_ clknet_leaf_102_clk _0406_ VGND VGND VPWR VPWR registers\[28\]\[29\] sky130_fd_sc_hd__dfxtp_1
XANTENNA__8278__A0 _2966_ VGND VGND VPWR VPWR sky130_fd_sc_hd__diode_2
XFILLER_0_30_230 VGND VGND VPWR VPWR sky130_fd_sc_hd__decap_4
XTAP_TAPCELL_ROW_95_1496 VGND VPWR sky130_fd_sc_hd__tapvpwrvgnd_1
XANTENNA__5187__S0 _1748_ VGND VGND VPWR VPWR sky130_fd_sc_hd__diode_2
XANTENNA__4934__S0 _1678_ VGND VGND VPWR VPWR sky130_fd_sc_hd__diode_2
XANTENNA_input26_A wd3[19] VGND VGND VPWR VPWR sky130_fd_sc_hd__diode_2
XANTENNA__5093__A1_N _1741_ VGND VGND VPWR VPWR sky130_fd_sc_hd__diode_2
XANTENNA__5199__S _1714_ VGND VGND VPWR VPWR sky130_fd_sc_hd__diode_2
XFILLER_0_97_296 VGND VGND VPWR VPWR sky130_fd_sc_hd__fill_2
XANTENNA__5111__S0 _1798_ VGND VGND VPWR VPWR sky130_fd_sc_hd__diode_2
XANTENNA__8303__S _4092_ VGND VGND VPWR VPWR sky130_fd_sc_hd__diode_2
XFILLER_0_38_374 VGND VGND VPWR VPWR sky130_fd_sc_hd__fill_2
XANTENNA__4775__C1 _1109_ VGND VGND VPWR VPWR sky130_fd_sc_hd__diode_2
XANTENNA__8505__A1 net20 VGND VGND VPWR VPWR sky130_fd_sc_hd__diode_2
XANTENNA__5319__A1 _1677_ VGND VGND VPWR VPWR sky130_fd_sc_hd__diode_2
XFILLER_0_80_141 VGND VGND VPWR VPWR sky130_fd_sc_hd__fill_1
XFILLER_0_80_163 VGND VGND VPWR VPWR sky130_fd_sc_hd__fill_2
XFILLER_0_41_539 VGND VGND VPWR VPWR sky130_fd_sc_hd__fill_2
XANTENNA__5414__S1 _2073_ VGND VGND VPWR VPWR sky130_fd_sc_hd__diode_2
XFILLER_0_111_416 VGND VGND VPWR VPWR sky130_fd_sc_hd__fill_2
XFILLER_0_1_614 VGND VGND VPWR VPWR sky130_fd_sc_hd__fill_2
XANTENNA__6819__A1 _2972_ VGND VGND VPWR VPWR sky130_fd_sc_hd__diode_2
XFILLER_0_0_113 VPWR VGND VPWR VGND sky130_ef_sc_hd__decap_12
XFILLER_0_1_636 VGND VGND VPWR VPWR sky130_fd_sc_hd__fill_2
XFILLER_0_119_11 VGND VGND VPWR VPWR sky130_fd_sc_hd__fill_2
XANTENNA__5178__S0 _1763_ VGND VGND VPWR VPWR sky130_fd_sc_hd__diode_2
XANTENNA__6059__A _1995_ VGND VGND VPWR VPWR sky130_fd_sc_hd__diode_2
XANTENNA__4278__S _1030_ VGND VGND VPWR VPWR sky130_fd_sc_hd__diode_2
XFILLER_0_28_64 VGND VGND VPWR VPWR sky130_fd_sc_hd__decap_3
XANTENNA__7244__A1 _3495_ VGND VGND VPWR VPWR sky130_fd_sc_hd__diode_2
XANTENNA__7589__S _3683_ VGND VGND VPWR VPWR sky130_fd_sc_hd__diode_2
X_7990_ _3018_ registers\[28\]\[27\] _3923_ VGND VGND VPWR VPWR _3931_ sky130_fd_sc_hd__mux2_1
XTAP_TAPCELL_ROW_37_737 VGND VPWR sky130_fd_sc_hd__tapvpwrvgnd_1
XANTENNA__5350__S0 _2027_ VGND VGND VPWR VPWR sky130_fd_sc_hd__diode_2
X_6941_ _3133_ registers\[13\]\[31\] _3323_ VGND VGND VPWR VPWR _3358_ sky130_fd_sc_hd__mux2_1
X_6872_ _3321_ VGND VGND VPWR VPWR _0919_ sky130_fd_sc_hd__clkbuf_1
XFILLER_0_49_639 VGND VGND VPWR VPWR sky130_fd_sc_hd__decap_8
XFILLER_0_49_617 VGND VGND VPWR VPWR sky130_fd_sc_hd__fill_2
XFILLER_0_44_85 VGND VGND VPWR VPWR sky130_fd_sc_hd__fill_2
XFILLER_0_119_516 VGND VGND VPWR VPWR sky130_fd_sc_hd__decap_8
XFILLER_0_119_505 VGND VGND VPWR VPWR sky130_fd_sc_hd__decap_8
XANTENNA__5102__S0 _1773_ VGND VGND VPWR VPWR sky130_fd_sc_hd__diode_2
X_5823_ _2549_ _2550_ VGND VGND VPWR VPWR _2551_ sky130_fd_sc_hd__or2_1
X_8611_ clknet_leaf_22_clk _0732_ VGND VGND VPWR VPWR registers\[29\]\[3\] sky130_fd_sc_hd__dfxtp_1
XFILLER_0_9_703 VGND VGND VPWR VPWR sky130_fd_sc_hd__decap_3
X_8542_ registers\[4\]\[31\] net40 _4188_ VGND VGND VPWR VPWR _4223_ sky130_fd_sc_hd__mux2_1
XTAP_TAPCELL_ROW_17_483 VGND VPWR sky130_fd_sc_hd__tapvpwrvgnd_1
XFILLER_0_29_374 VGND VGND VPWR VPWR sky130_fd_sc_hd__fill_2
X_5754_ net139 _2483_ _2484_ VGND VGND VPWR VPWR _2485_ sky130_fd_sc_hd__o21a_1
XFILLER_0_8_279 VGND VGND VPWR VPWR sky130_fd_sc_hd__fill_2
X_5685_ _2353_ _2416_ _2418_ VGND VGND VPWR VPWR _2419_ sky130_fd_sc_hd__a21oi_2
XFILLER_0_72_664 VGND VGND VPWR VPWR sky130_fd_sc_hd__fill_1
X_8473_ _4186_ VGND VGND VPWR VPWR _0631_ sky130_fd_sc_hd__clkbuf_1
X_4705_ _1480_ _1481_ _1421_ VGND VGND VPWR VPWR _1482_ sky130_fd_sc_hd__mux2_1
X_7424_ registers\[20\]\[17\] _3470_ _3623_ VGND VGND VPWR VPWR _3631_ sky130_fd_sc_hd__mux2_1
X_4636_ _1128_ VGND VGND VPWR VPWR _1416_ sky130_fd_sc_hd__buf_4
XANTENNA__5405__S1 _2073_ VGND VGND VPWR VPWR sky130_fd_sc_hd__diode_2
XFILLER_0_114_276 VGND VGND VPWR VPWR sky130_fd_sc_hd__decap_3
X_7355_ registers\[1\]\[17\] _3470_ _3586_ VGND VGND VPWR VPWR _3594_ sky130_fd_sc_hd__mux2_1
XFILLER_0_12_230 VGND VGND VPWR VPWR sky130_fd_sc_hd__decap_4
XANTENNA__5730__B2 _2321_ VGND VGND VPWR VPWR sky130_fd_sc_hd__diode_2
X_4567_ _1132_ _1350_ VGND VGND VPWR VPWR _1351_ sky130_fd_sc_hd__or2_1
X_6306_ _2994_ VGND VGND VPWR VPWR _0680_ sky130_fd_sc_hd__clkbuf_1
XFILLER_0_69_82 VGND VGND VPWR VPWR sky130_fd_sc_hd__fill_1
XFILLER_0_8_85 VGND VGND VPWR VPWR sky130_fd_sc_hd__fill_2
X_7286_ _3557_ VGND VGND VPWR VPWR _0073_ sky130_fd_sc_hd__clkbuf_1
X_4498_ _1109_ _1277_ _1285_ VGND VGND VPWR VPWR _1286_ sky130_fd_sc_hd__o21ai_4
XFILLER_0_12_274 VGND VGND VPWR VPWR sky130_fd_sc_hd__fill_2
XANTENNA__4916__S0 _1678_ VGND VGND VPWR VPWR sky130_fd_sc_hd__diode_2
X_6237_ _2909_ VGND VGND VPWR VPWR _2943_ sky130_fd_sc_hd__inv_2
X_9025_ clknet_leaf_108_clk _0122_ VGND VGND VPWR VPWR registers\[20\]\[1\] sky130_fd_sc_hd__dfxtp_1
X_6168_ _2874_ _2877_ VGND VGND VPWR VPWR _2878_ sky130_fd_sc_hd__xnor2_1
XANTENNA__4392__S1 _1127_ VGND VGND VPWR VPWR sky130_fd_sc_hd__diode_2
X_5119_ registers\[8\]\[12\] registers\[9\]\[12\] registers\[10\]\[12\] registers\[11\]\[12\]
+ _1762_ _1764_ VGND VGND VPWR VPWR _1875_ sky130_fd_sc_hd__mux4_1
XANTENNA__7499__S _3670_ VGND VGND VPWR VPWR sky130_fd_sc_hd__diode_2
X_6099_ _2498_ _2811_ VGND VGND VPWR VPWR _2812_ sky130_fd_sc_hd__nor2_1
XFILLER_0_39_105 VGND VGND VPWR VPWR sky130_fd_sc_hd__fill_1
X_8809_ clknet_leaf_19_clk _0930_ VGND VGND VPWR VPWR registers\[13\]\[9\] sky130_fd_sc_hd__dfxtp_1
XFILLER_0_39_138 VGND VGND VPWR VPWR sky130_fd_sc_hd__decap_4
XFILLER_0_39_127 VGND VGND VPWR VPWR sky130_fd_sc_hd__fill_2
XANTENNA__4651__S _1386_ VGND VGND VPWR VPWR sky130_fd_sc_hd__diode_2
XFILLER_0_94_288 VGND VGND VPWR VPWR sky130_fd_sc_hd__fill_2
XANTENNA__6432__A net27 VGND VGND VPWR VPWR sky130_fd_sc_hd__diode_2
XTAP_TAPCELL_ROW_97_1514 VGND VPWR sky130_fd_sc_hd__tapvpwrvgnd_1
XFILLER_0_35_333 VGND VGND VPWR VPWR sky130_fd_sc_hd__decap_3
XTAP_TAPCELL_ROW_97_1525 VGND VPWR sky130_fd_sc_hd__tapvpwrvgnd_1
XFILLER_0_90_494 VGND VGND VPWR VPWR sky130_fd_sc_hd__fill_2
XANTENNA__5048__A _1752_ VGND VGND VPWR VPWR sky130_fd_sc_hd__diode_2
XFILLER_0_23_517 VGND VGND VPWR VPWR sky130_fd_sc_hd__fill_2
XANTENNA__6578__S _3159_ VGND VGND VPWR VPWR sky130_fd_sc_hd__diode_2
XANTENNA__4887__A _1634_ VGND VGND VPWR VPWR sky130_fd_sc_hd__diode_2
XFILLER_0_31_594 VGND VGND VPWR VPWR sky130_fd_sc_hd__decap_4
XANTENNA__4907__S0 _1642_ VGND VGND VPWR VPWR sky130_fd_sc_hd__diode_2
XFILLER_0_65_18 VGND VGND VPWR VPWR sky130_fd_sc_hd__fill_1
XANTENNA__4383__S1 _1161_ VGND VGND VPWR VPWR sky130_fd_sc_hd__diode_2
XANTENNA__7226__A1 _3476_ VGND VGND VPWR VPWR sky130_fd_sc_hd__diode_2
XANTENNA__5511__A _2118_ VGND VGND VPWR VPWR sky130_fd_sc_hd__diode_2
XANTENNA__7202__S _3503_ VGND VGND VPWR VPWR sky130_fd_sc_hd__diode_2
XFILLER_0_86_701 VGND VGND VPWR VPWR sky130_fd_sc_hd__decap_6
XANTENNA__6985__A0 _3108_ VGND VGND VPWR VPWR sky130_fd_sc_hd__diode_2
XTAP_TAPCELL_ROW_106_1643 VGND VPWR sky130_fd_sc_hd__tapvpwrvgnd_1
XTAP_TAPCELL_ROW_106_1632 VGND VPWR sky130_fd_sc_hd__tapvpwrvgnd_1
XFILLER_0_105_24 VGND VGND VPWR VPWR sky130_fd_sc_hd__decap_8
XFILLER_0_86_723 VGND VGND VPWR VPWR sky130_fd_sc_hd__fill_2
XFILLER_0_85_211 VGND VGND VPWR VPWR sky130_fd_sc_hd__fill_2
XFILLER_0_81_39 VGND VGND VPWR VPWR sky130_fd_sc_hd__fill_2
XTAP_TAPCELL_ROW_34_707 VGND VPWR sky130_fd_sc_hd__tapvpwrvgnd_1
XFILLER_0_14_33 VGND VGND VPWR VPWR sky130_fd_sc_hd__decap_3
XANTENNA__5657__S _1108_ VGND VGND VPWR VPWR sky130_fd_sc_hd__diode_2
XFILLER_0_14_66 VGND VGND VPWR VPWR sky130_fd_sc_hd__fill_2
XANTENNA__8033__S _3948_ VGND VGND VPWR VPWR sky130_fd_sc_hd__diode_2
XFILLER_0_45_119 VGND VGND VPWR VPWR sky130_fd_sc_hd__fill_2
XFILLER_0_14_88 VGND VGND VPWR VPWR sky130_fd_sc_hd__fill_2
XTAP_TAPCELL_ROW_14_442 VGND VPWR sky130_fd_sc_hd__tapvpwrvgnd_1
XFILLER_0_26_344 VGND VGND VPWR VPWR sky130_fd_sc_hd__fill_2
XANTENNA__7872__S _3865_ VGND VGND VPWR VPWR sky130_fd_sc_hd__diode_2
X_5470_ net120 net121 VGND VGND VPWR VPWR _2206_ sky130_fd_sc_hd__nor2_1
XFILLER_0_112_725 VGND VGND VPWR VPWR sky130_fd_sc_hd__fill_1
XFILLER_0_111_202 VGND VGND VPWR VPWR sky130_fd_sc_hd__decap_4
XFILLER_0_100_3 VGND VGND VPWR VPWR sky130_fd_sc_hd__fill_2
X_4421_ registers\[16\]\[8\] registers\[17\]\[8\] registers\[18\]\[8\] registers\[19\]\[8\]
+ _1053_ _1054_ VGND VGND VPWR VPWR _1213_ sky130_fd_sc_hd__mux4_1
XANTENNA__6488__S _3090_ VGND VGND VPWR VPWR sky130_fd_sc_hd__diode_2
XTAP_TAPCELL_ROW_117_1783 VGND VPWR sky130_fd_sc_hd__tapvpwrvgnd_1
XFILLER_0_111_279 VGND VGND VPWR VPWR sky130_fd_sc_hd__fill_1
X_4352_ registers\[16\]\[5\] registers\[17\]\[5\] registers\[18\]\[5\] registers\[19\]\[5\]
+ _1111_ _1113_ VGND VGND VPWR VPWR _1147_ sky130_fd_sc_hd__mux4_1
X_7140_ _3473_ VGND VGND VPWR VPWR _0011_ sky130_fd_sc_hd__clkbuf_1
X_7071_ _3125_ registers\[15\]\[27\] _3420_ VGND VGND VPWR VPWR _3428_ sky130_fd_sc_hd__mux2_1
X_4283_ registers\[4\]\[2\] registers\[5\]\[2\] registers\[6\]\[2\] registers\[7\]\[2\]
+ _1026_ _1027_ VGND VGND VPWR VPWR _1081_ sky130_fd_sc_hd__mux4_1
X_6022_ net122 _2739_ VGND VGND VPWR VPWR _2740_ sky130_fd_sc_hd__xnor2_2
XANTENNA__7217__A1 _3468_ VGND VGND VPWR VPWR sky130_fd_sc_hd__diode_2
XANTENNA__8208__S _4045_ VGND VGND VPWR VPWR sky130_fd_sc_hd__diode_2
XANTENNA__5228__B1 _1977_ VGND VGND VPWR VPWR sky130_fd_sc_hd__diode_2
XFILLER_0_89_550 VGND VGND VPWR VPWR sky130_fd_sc_hd__decap_8
XTAP_TAPCELL_ROW_68_1137 VGND VPWR sky130_fd_sc_hd__tapvpwrvgnd_1
X_7973_ _3001_ registers\[28\]\[19\] _3912_ VGND VGND VPWR VPWR _3922_ sky130_fd_sc_hd__mux2_1
XFILLER_0_89_561 VGND VGND VPWR VPWR sky130_fd_sc_hd__decap_4
XTAP_TAPCELL_ROW_68_1148 VGND VPWR sky130_fd_sc_hd__tapvpwrvgnd_1
XFILLER_0_49_414 VGND VGND VPWR VPWR sky130_fd_sc_hd__fill_2
X_6924_ _3349_ VGND VGND VPWR VPWR _0943_ sky130_fd_sc_hd__clkbuf_1
XTAP_TAPCELL_ROW_81_1315 VGND VPWR sky130_fd_sc_hd__tapvpwrvgnd_1
XFILLER_0_76_211 VGND VGND VPWR VPWR sky130_fd_sc_hd__decap_4
XFILLER_0_9_500 VGND VGND VPWR VPWR sky130_fd_sc_hd__fill_2
XFILLER_0_119_324 VGND VGND VPWR VPWR sky130_fd_sc_hd__fill_2
XFILLER_0_119_335 VGND VGND VPWR VPWR sky130_fd_sc_hd__fill_1
XANTENNA__4471__S _1116_ VGND VGND VPWR VPWR sky130_fd_sc_hd__diode_2
XFILLER_0_71_61 VGND VGND VPWR VPWR sky130_fd_sc_hd__fill_1
XFILLER_0_64_417 VGND VGND VPWR VPWR sky130_fd_sc_hd__decap_3
X_6855_ registers\[12\]\[22\] _3008_ _3310_ VGND VGND VPWR VPWR _3313_ sky130_fd_sc_hd__mux2_1
XFILLER_0_91_225 VGND VGND VPWR VPWR sky130_fd_sc_hd__fill_1
X_5806_ _2295_ _2442_ VGND VGND VPWR VPWR _2535_ sky130_fd_sc_hd__nand2_1
XFILLER_0_71_94 VGND VGND VPWR VPWR sky130_fd_sc_hd__decap_3
XFILLER_0_64_439 VGND VGND VPWR VPWR sky130_fd_sc_hd__fill_2
X_6786_ _3275_ VGND VGND VPWR VPWR _0879_ sky130_fd_sc_hd__clkbuf_1
XANTENNA__5951__A1 _2362_ VGND VGND VPWR VPWR sky130_fd_sc_hd__diode_2
X_5737_ _2312_ _2303_ VGND VGND VPWR VPWR _2469_ sky130_fd_sc_hd__or2_1
X_8525_ _4214_ VGND VGND VPWR VPWR _0655_ sky130_fd_sc_hd__clkbuf_1
XFILLER_0_44_141 VGND VGND VPWR VPWR sky130_fd_sc_hd__fill_2
XFILLER_0_9_588 VGND VGND VPWR VPWR sky130_fd_sc_hd__fill_2
XANTENNA__5951__B2 _1145_ VGND VGND VPWR VPWR sky130_fd_sc_hd__diode_2
X_8456_ registers\[8\]\[22\] net30 _4175_ VGND VGND VPWR VPWR _4178_ sky130_fd_sc_hd__mux2_1
XANTENNA__7782__S _3815_ VGND VGND VPWR VPWR sky130_fd_sc_hd__diode_2
XFILLER_0_115_574 VGND VGND VPWR VPWR sky130_fd_sc_hd__decap_4
X_5668_ _2282_ _2289_ _2307_ VGND VGND VPWR VPWR _2402_ sky130_fd_sc_hd__mux2_1
XFILLER_0_60_645 VGND VGND VPWR VPWR sky130_fd_sc_hd__fill_2
X_7407_ registers\[20\]\[9\] _3453_ _3612_ VGND VGND VPWR VPWR _3622_ sky130_fd_sc_hd__mux2_1
XANTENNA__6900__A0 _3092_ VGND VGND VPWR VPWR sky130_fd_sc_hd__diode_2
X_5599_ _1929_ _2215_ _2219_ VGND VGND VPWR VPWR _2334_ sky130_fd_sc_hd__o21ai_1
XTAP_TAPCELL_ROW_79_1288 VGND VPWR sky130_fd_sc_hd__tapvpwrvgnd_1
XFILLER_0_60_689 VGND VGND VPWR VPWR sky130_fd_sc_hd__decap_8
X_4619_ registers\[28\]\[19\] registers\[29\]\[19\] registers\[30\]\[19\] registers\[31\]\[19\]
+ _1338_ _1339_ VGND VGND VPWR VPWR _1400_ sky130_fd_sc_hd__mux4_1
XANTENNA__6398__S _3041_ VGND VGND VPWR VPWR sky130_fd_sc_hd__diode_2
XANTENNA__7083__A _3434_ VGND VGND VPWR VPWR sky130_fd_sc_hd__diode_2
X_8387_ _4141_ VGND VGND VPWR VPWR _0590_ sky130_fd_sc_hd__clkbuf_1
X_7338_ registers\[1\]\[9\] _3453_ _3575_ VGND VGND VPWR VPWR _3585_ sky130_fd_sc_hd__mux2_1
XFILLER_0_13_583 VGND VGND VPWR VPWR sky130_fd_sc_hd__fill_2
XFILLER_0_96_80 VGND VGND VPWR VPWR sky130_fd_sc_hd__fill_2
XTAP_TAPCELL_ROW_92_1455 VGND VPWR sky130_fd_sc_hd__tapvpwrvgnd_1
X_7269_ _3548_ VGND VGND VPWR VPWR _0065_ sky130_fd_sc_hd__clkbuf_1
X_9008_ clknet_leaf_65_clk _0105_ VGND VGND VPWR VPWR registers\[1\]\[16\] sky130_fd_sc_hd__dfxtp_1
XFILLER_0_99_325 VGND VGND VPWR VPWR sky130_fd_sc_hd__decap_8
XANTENNA__4690__A1 _1372_ VGND VGND VPWR VPWR sky130_fd_sc_hd__diode_2
XANTENNA__4646__S _1379_ VGND VGND VPWR VPWR sky130_fd_sc_hd__diode_2
XANTENNA__8118__S _3995_ VGND VGND VPWR VPWR sky130_fd_sc_hd__diode_2
XFILLER_0_87_509 VGND VGND VPWR VPWR sky130_fd_sc_hd__fill_2
XANTENNA__7957__S _3912_ VGND VGND VPWR VPWR sky130_fd_sc_hd__diode_2
XFILLER_0_68_723 VGND VGND VPWR VPWR sky130_fd_sc_hd__fill_2
XFILLER_0_68_701 VGND VGND VPWR VPWR sky130_fd_sc_hd__decap_4
XANTENNA__6861__S _3310_ VGND VGND VPWR VPWR sky130_fd_sc_hd__diode_2
XFILLER_0_83_715 VGND VGND VPWR VPWR sky130_fd_sc_hd__decap_6
XANTENNA__4381__S _1122_ VGND VGND VPWR VPWR sky130_fd_sc_hd__diode_2
XFILLER_0_82_203 VGND VGND VPWR VPWR sky130_fd_sc_hd__fill_2
XANTENNA__6162__A _2515_ VGND VGND VPWR VPWR sky130_fd_sc_hd__diode_2
XTAP_TAPCELL_ROW_101_1573 VGND VPWR sky130_fd_sc_hd__tapvpwrvgnd_1
XANTENNA__5942__A1 net85 VGND VGND VPWR VPWR sky130_fd_sc_hd__diode_2
XTAP_TAPCELL_ROW_11_401 VGND VPWR sky130_fd_sc_hd__tapvpwrvgnd_1
XFILLER_0_36_697 VGND VGND VPWR VPWR sky130_fd_sc_hd__decap_3
XFILLER_0_90_280 VGND VGND VPWR VPWR sky130_fd_sc_hd__decap_4
Xclkload29 clknet_leaf_22_clk VGND VGND VPWR VPWR clkload29/X sky130_fd_sc_hd__clkbuf_4
Xclkload18 clknet_leaf_108_clk VGND VGND VPWR VPWR clkload18/Y sky130_fd_sc_hd__clkinvlp_4
XANTENNA__7695__A1 _3468_ VGND VGND VPWR VPWR sky130_fd_sc_hd__diode_2
XANTENNA__4410__A _1202_ VGND VGND VPWR VPWR sky130_fd_sc_hd__diode_2
XANTENNA__5506__A _2084_ VGND VGND VPWR VPWR sky130_fd_sc_hd__diode_2
XANTENNA__7447__A1 _3493_ VGND VGND VPWR VPWR sky130_fd_sc_hd__diode_2
XFILLER_0_31_391 VGND VGND VPWR VPWR sky130_fd_sc_hd__fill_1
XANTENNA__4356__S1 _1113_ VGND VGND VPWR VPWR sky130_fd_sc_hd__diode_2
XFILLER_0_92_27 VGND VGND VPWR VPWR sky130_fd_sc_hd__fill_1
XFILLER_0_92_49 VGND VGND VPWR VPWR sky130_fd_sc_hd__decap_3
XANTENNA__5305__S0 _1883_ VGND VGND VPWR VPWR sky130_fd_sc_hd__diode_2
XTAP_TAPCELL_ROW_19_501 VGND VPWR sky130_fd_sc_hd__tapvpwrvgnd_1
XTAP_TAPCELL_ROW_19_512 VGND VPWR sky130_fd_sc_hd__tapvpwrvgnd_1
XTAP_TAPCELL_ROW_47_865 VGND VPWR sky130_fd_sc_hd__tapvpwrvgnd_1
X_4970_ _1631_ _1732_ VGND VGND VPWR VPWR _1733_ sky130_fd_sc_hd__or2_1
XTAP_TAPCELL_ROW_47_876 VGND VPWR sky130_fd_sc_hd__tapvpwrvgnd_1
XFILLER_0_74_726 VGND VGND VPWR VPWR sky130_fd_sc_hd__fill_2
XFILLER_0_73_225 VGND VGND VPWR VPWR sky130_fd_sc_hd__fill_1
X_6640_ _3196_ VGND VGND VPWR VPWR _0812_ sky130_fd_sc_hd__clkbuf_1
XFILLER_0_18_119 VGND VGND VPWR VPWR sky130_fd_sc_hd__fill_2
XTAP_TAPCELL_ROW_119_1801 VGND VPWR sky130_fd_sc_hd__tapvpwrvgnd_1
XTAP_TAPCELL_ROW_63_1078 VGND VPWR sky130_fd_sc_hd__tapvpwrvgnd_1
X_6571_ _3136_ VGND VGND VPWR VPWR _3159_ sky130_fd_sc_hd__clkbuf_8
XANTENNA__5394__C1 _1960_ VGND VGND VPWR VPWR sky130_fd_sc_hd__diode_2
XTAP_TAPCELL_ROW_119_1823 VGND VPWR sky130_fd_sc_hd__tapvpwrvgnd_1
XTAP_TAPCELL_ROW_119_1812 VGND VPWR sky130_fd_sc_hd__tapvpwrvgnd_1
X_8310_ _4100_ VGND VGND VPWR VPWR _0554_ sky130_fd_sc_hd__clkbuf_1
X_5522_ _2253_ _2257_ VGND VGND VPWR VPWR _2258_ sky130_fd_sc_hd__or2_1
X_9290_ clknet_leaf_39_clk _0387_ VGND VGND VPWR VPWR registers\[28\]\[10\] sky130_fd_sc_hd__dfxtp_1
XFILLER_0_81_7 VGND VGND VPWR VPWR sky130_fd_sc_hd__fill_2
XFILLER_0_42_645 VGND VGND VPWR VPWR sky130_fd_sc_hd__fill_2
XFILLER_0_14_325 VGND VGND VPWR VPWR sky130_fd_sc_hd__fill_1
X_8241_ registers\[6\]\[17\] _3470_ _4056_ VGND VGND VPWR VPWR _4064_ sky130_fd_sc_hd__mux2_1
X_5453_ registers\[0\]\[31\] registers\[1\]\[31\] registers\[2\]\[31\] registers\[3\]\[31\]
+ _2126_ _2127_ VGND VGND VPWR VPWR _2190_ sky130_fd_sc_hd__mux4_1
XFILLER_0_112_577 VGND VGND VPWR VPWR sky130_fd_sc_hd__fill_2
X_4404_ _1196_ VGND VGND VPWR VPWR _1197_ sky130_fd_sc_hd__clkbuf_8
XANTENNA__5697__B1 _2394_ VGND VGND VPWR VPWR sky130_fd_sc_hd__diode_2
X_8172_ _4027_ VGND VGND VPWR VPWR _0489_ sky130_fd_sc_hd__clkbuf_1
XANTENNA__4320__A _1030_ VGND VGND VPWR VPWR sky130_fd_sc_hd__diode_2
X_5384_ _2121_ _2122_ _2123_ _2124_ _2076_ _2026_ VGND VGND VPWR VPWR _2125_ sky130_fd_sc_hd__mux4_2
X_7123_ net20 VGND VGND VPWR VPWR _3462_ sky130_fd_sc_hd__buf_2
X_4335_ net6 VGND VGND VPWR VPWR _1131_ sky130_fd_sc_hd__buf_4
XANTENNA__4595__S1 _1339_ VGND VGND VPWR VPWR sky130_fd_sc_hd__diode_2
XFILLER_0_1_274 VGND VGND VPWR VPWR sky130_fd_sc_hd__decap_4
XANTENNA__6946__S _3361_ VGND VGND VPWR VPWR sky130_fd_sc_hd__diode_2
XFILLER_0_5_53 VGND VGND VPWR VPWR sky130_fd_sc_hd__decap_3
X_7054_ _3108_ registers\[15\]\[19\] _3409_ VGND VGND VPWR VPWR _3419_ sky130_fd_sc_hd__mux2_1
X_4266_ net6 _1064_ net7 VGND VGND VPWR VPWR _1065_ sky130_fd_sc_hd__o21a_1
X_6005_ _2333_ _2366_ VGND VGND VPWR VPWR _2724_ sky130_fd_sc_hd__nand2_1
XFILLER_0_66_83 VGND VGND VPWR VPWR sky130_fd_sc_hd__fill_1
XFILLER_0_69_509 VGND VGND VPWR VPWR sky130_fd_sc_hd__decap_3
XANTENNA__6681__S _3214_ VGND VGND VPWR VPWR sky130_fd_sc_hd__diode_2
XANTENNA__4990__A _1682_ VGND VGND VPWR VPWR sky130_fd_sc_hd__diode_2
XFILLER_0_96_317 VGND VGND VPWR VPWR sky130_fd_sc_hd__decap_4
X_7956_ _3913_ VGND VGND VPWR VPWR _0387_ sky130_fd_sc_hd__clkbuf_1
XFILLER_0_96_339 VGND VGND VPWR VPWR sky130_fd_sc_hd__fill_1
X_7887_ _3089_ registers\[27\]\[10\] _3876_ VGND VGND VPWR VPWR _3877_ sky130_fd_sc_hd__mux2_1
X_6907_ _3340_ VGND VGND VPWR VPWR _0935_ sky130_fd_sc_hd__clkbuf_1
X_6838_ registers\[12\]\[14\] _2991_ _3299_ VGND VGND VPWR VPWR _3304_ sky130_fd_sc_hd__mux2_1
XFILLER_0_107_316 VGND VGND VPWR VPWR sky130_fd_sc_hd__decap_4
XFILLER_0_92_545 VGND VGND VPWR VPWR sky130_fd_sc_hd__decap_3
XFILLER_0_18_642 VGND VGND VPWR VPWR sky130_fd_sc_hd__fill_2
X_9557_ clknet_leaf_83_clk _0654_ VGND VGND VPWR VPWR registers\[4\]\[21\] sky130_fd_sc_hd__dfxtp_1
X_6769_ _3266_ VGND VGND VPWR VPWR _0871_ sky130_fd_sc_hd__clkbuf_1
X_8508_ _4205_ VGND VGND VPWR VPWR _0647_ sky130_fd_sc_hd__clkbuf_1
XANTENNA__4283__S0 _1026_ VGND VGND VPWR VPWR sky130_fd_sc_hd__diode_2
XFILLER_0_103_500 VGND VGND VPWR VPWR sky130_fd_sc_hd__fill_2
XFILLER_0_72_291 VGND VGND VPWR VPWR sky130_fd_sc_hd__fill_2
X_9488_ clknet_leaf_65_clk _0585_ VGND VGND VPWR VPWR registers\[5\]\[16\] sky130_fd_sc_hd__dfxtp_1
XFILLER_0_32_122 VGND VGND VPWR VPWR sky130_fd_sc_hd__fill_1
XFILLER_0_115_393 VGND VGND VPWR VPWR sky130_fd_sc_hd__fill_1
XFILLER_0_115_371 VGND VGND VPWR VPWR sky130_fd_sc_hd__fill_2
XFILLER_0_103_522 VGND VGND VPWR VPWR sky130_fd_sc_hd__fill_2
X_8439_ registers\[8\]\[14\] net21 _4164_ VGND VGND VPWR VPWR _4169_ sky130_fd_sc_hd__mux2_1
XFILLER_0_33_667 VGND VGND VPWR VPWR sky130_fd_sc_hd__decap_3
XANTENNA__7017__S _3398_ VGND VGND VPWR VPWR sky130_fd_sc_hd__diode_2
XANTENNA__4230__A net6 VGND VGND VPWR VPWR sky130_fd_sc_hd__diode_2
XANTENNA__5760__S net135 VGND VGND VPWR VPWR sky130_fd_sc_hd__diode_2
XANTENNA__5061__A _1690_ VGND VGND VPWR VPWR sky130_fd_sc_hd__diode_2
XFILLER_0_87_328 VGND VGND VPWR VPWR sky130_fd_sc_hd__fill_2
XANTENNA__7687__S _3768_ VGND VGND VPWR VPWR sky130_fd_sc_hd__diode_2
XFILLER_0_62_19 VGND VGND VPWR VPWR sky130_fd_sc_hd__fill_2
XTAP_TAPCELL_ROW_103_1602 VGND VPWR sky130_fd_sc_hd__tapvpwrvgnd_1
XFILLER_0_68_575 VGND VGND VPWR VPWR sky130_fd_sc_hd__fill_1
XTAP_TAPCELL_ROW_44_835 VGND VPWR sky130_fd_sc_hd__tapvpwrvgnd_1
XANTENNA__4405__A _1197_ VGND VGND VPWR VPWR sky130_fd_sc_hd__diode_2
XFILLER_0_28_417 VGND VGND VPWR VPWR sky130_fd_sc_hd__decap_3
XFILLER_0_71_707 VPWR VGND VPWR VGND sky130_ef_sc_hd__decap_12
XTAP_TAPCELL_ROW_24_570 VGND VPWR sky130_fd_sc_hd__tapvpwrvgnd_1
XFILLER_0_24_601 VGND VGND VPWR VPWR sky130_fd_sc_hd__decap_4
XFILLER_0_63_291 VGND VGND VPWR VPWR sky130_fd_sc_hd__decap_8
XANTENNA__8311__S _4092_ VGND VGND VPWR VPWR sky130_fd_sc_hd__diode_2
XANTENNA__6620__A _3174_ VGND VGND VPWR VPWR sky130_fd_sc_hd__diode_2
XFILLER_0_23_122 VGND VGND VPWR VPWR sky130_fd_sc_hd__decap_3
XFILLER_0_36_483 VGND VGND VPWR VPWR sky130_fd_sc_hd__decap_4
XPHY_EDGE_ROW_116_Right_116 VGND VGND VPWR VPWR sky130_fd_sc_hd__decap_3
XFILLER_0_51_475 VGND VGND VPWR VPWR sky130_fd_sc_hd__fill_2
XFILLER_0_51_453 VGND VGND VPWR VPWR sky130_fd_sc_hd__decap_3
XFILLER_0_11_89 VGND VGND VPWR VPWR sky130_fd_sc_hd__decap_4
XFILLER_0_23_144 VGND VGND VPWR VPWR sky130_fd_sc_hd__decap_4
XANTENNA__4577__S1 _1161_ VGND VGND VPWR VPWR sky130_fd_sc_hd__diode_2
XTAP_TAPCELL_ROW_114_1742 VGND VPWR sky130_fd_sc_hd__tapvpwrvgnd_1
XANTENNA__6766__S _3261_ VGND VGND VPWR VPWR sky130_fd_sc_hd__diode_2
Xinput5 a1[4] VGND VGND VPWR VPWR net5 sky130_fd_sc_hd__clkbuf_4
XFILLER_0_36_42 VGND VGND VPWR VPWR sky130_fd_sc_hd__fill_2
X_7810_ _3081_ registers\[26\]\[6\] _3829_ VGND VGND VPWR VPWR _3836_ sky130_fd_sc_hd__mux2_1
XANTENNA__7597__S _3720_ VGND VGND VPWR VPWR sky130_fd_sc_hd__diode_2
XTAP_TAPCELL_ROW_65_1107 VGND VPWR sky130_fd_sc_hd__tapvpwrvgnd_1
XFILLER_0_59_531 VGND VGND VPWR VPWR sky130_fd_sc_hd__fill_2
XFILLER_0_59_520 VGND VGND VPWR VPWR sky130_fd_sc_hd__fill_2
X_8790_ clknet_leaf_95_clk _0911_ VGND VGND VPWR VPWR registers\[12\]\[22\] sky130_fd_sc_hd__dfxtp_1
X_4953_ _1715_ _1716_ _1689_ VGND VGND VPWR VPWR _1717_ sky130_fd_sc_hd__mux2_1
XANTENNA__4501__S1 _1168_ VGND VGND VPWR VPWR sky130_fd_sc_hd__diode_2
X_7741_ _3799_ VGND VGND VPWR VPWR _0286_ sky130_fd_sc_hd__clkbuf_1
XANTENNA__4315__A _1110_ VGND VGND VPWR VPWR sky130_fd_sc_hd__diode_2
X_7672_ registers\[24\]\[5\] _3445_ _3757_ VGND VGND VPWR VPWR _3763_ sky130_fd_sc_hd__mux2_1
XFILLER_0_86_394 VGND VGND VPWR VPWR sky130_fd_sc_hd__fill_2
X_6623_ registers\[0\]\[11\] _2985_ _3186_ VGND VGND VPWR VPWR _3188_ sky130_fd_sc_hd__mux2_1
X_9411_ clknet_leaf_22_clk _0508_ VGND VGND VPWR VPWR registers\[6\]\[3\] sky130_fd_sc_hd__dfxtp_1
X_4884_ registers\[8\]\[1\] registers\[9\]\[1\] registers\[10\]\[1\] registers\[11\]\[1\]
+ _1628_ _1629_ VGND VGND VPWR VPWR _1651_ sky130_fd_sc_hd__mux4_1
XFILLER_0_74_589 VGND VGND VPWR VPWR sky130_fd_sc_hd__fill_2
XFILLER_0_74_578 VGND VGND VPWR VPWR sky130_fd_sc_hd__fill_2
XANTENNA__4265__S0 _1039_ VGND VGND VPWR VPWR sky130_fd_sc_hd__diode_2
XFILLER_0_34_409 VGND VGND VPWR VPWR sky130_fd_sc_hd__decap_4
XFILLER_0_116_179 VGND VGND VPWR VPWR sky130_fd_sc_hd__decap_6
XFILLER_0_116_157 VGND VGND VPWR VPWR sky130_fd_sc_hd__fill_2
XFILLER_0_104_319 VGND VGND VPWR VPWR sky130_fd_sc_hd__decap_8
X_6554_ _3150_ VGND VGND VPWR VPWR _0772_ sky130_fd_sc_hd__clkbuf_1
X_9342_ clknet_leaf_13_clk _0439_ VGND VGND VPWR VPWR registers\[2\]\[30\] sky130_fd_sc_hd__dfxtp_1
XFILLER_0_6_355 VGND VGND VPWR VPWR sky130_fd_sc_hd__decap_3
XFILLER_0_27_494 VGND VGND VPWR VPWR sky130_fd_sc_hd__fill_2
X_5505_ _2217_ _2240_ VGND VGND VPWR VPWR _2241_ sky130_fd_sc_hd__nand2_1
X_6485_ _3106_ registers\[29\]\[18\] _3090_ VGND VGND VPWR VPWR _3107_ sky130_fd_sc_hd__mux2_1
X_9273_ clknet_leaf_80_clk _0370_ VGND VGND VPWR VPWR registers\[27\]\[25\] sky130_fd_sc_hd__dfxtp_1
XFILLER_0_14_133 VGND VGND VPWR VPWR sky130_fd_sc_hd__decap_6
XFILLER_0_15_656 VGND VGND VPWR VPWR sky130_fd_sc_hd__fill_2
XFILLER_0_112_330 VGND VGND VPWR VPWR sky130_fd_sc_hd__decap_4
XTAP_TAPCELL_ROW_76_1247 VGND VPWR sky130_fd_sc_hd__tapvpwrvgnd_1
X_8224_ registers\[6\]\[9\] _3453_ _4045_ VGND VGND VPWR VPWR _4055_ sky130_fd_sc_hd__mux2_1
X_5436_ registers\[4\]\[30\] registers\[5\]\[30\] registers\[6\]\[30\] registers\[7\]\[30\]
+ _1758_ _1760_ VGND VGND VPWR VPWR _2174_ sky130_fd_sc_hd__mux4_1
XFILLER_0_30_615 VGND VGND VPWR VPWR sky130_fd_sc_hd__fill_2
XFILLER_0_30_626 VGND VGND VPWR VPWR sky130_fd_sc_hd__fill_2
XFILLER_0_30_637 VGND VGND VPWR VPWR sky130_fd_sc_hd__decap_4
XFILLER_0_112_396 VGND VGND VPWR VPWR sky130_fd_sc_hd__fill_2
X_8155_ _4018_ VGND VGND VPWR VPWR _0481_ sky130_fd_sc_hd__clkbuf_1
X_5367_ _1760_ VGND VGND VPWR VPWR _2109_ sky130_fd_sc_hd__clkbuf_4
XANTENNA__7361__A _3574_ VGND VGND VPWR VPWR sky130_fd_sc_hd__diode_2
X_4318_ registers\[20\]\[4\] registers\[21\]\[4\] registers\[22\]\[4\] registers\[23\]\[4\]
+ _1111_ _1113_ VGND VGND VPWR VPWR _1114_ sky130_fd_sc_hd__mux4_1
X_7106_ _3450_ VGND VGND VPWR VPWR _0000_ sky130_fd_sc_hd__clkbuf_1
X_8086_ _2978_ registers\[30\]\[8\] _3973_ VGND VGND VPWR VPWR _3982_ sky130_fd_sc_hd__mux2_1
X_5298_ registers\[4\]\[22\] registers\[5\]\[22\] registers\[6\]\[22\] registers\[7\]\[22\]
+ _1762_ _1764_ VGND VGND VPWR VPWR _2044_ sky130_fd_sc_hd__mux4_1
XANTENNA__6095__B1 _2808_ VGND VGND VPWR VPWR sky130_fd_sc_hd__diode_2
X_7037_ _3410_ VGND VGND VPWR VPWR _0995_ sky130_fd_sc_hd__clkbuf_1
X_4249_ net8 _1033_ _1038_ _1048_ VGND VGND VPWR VPWR _1049_ sky130_fd_sc_hd__a31o_4
XFILLER_0_97_604 VGND VGND VPWR VPWR sky130_fd_sc_hd__fill_1
XFILLER_0_97_659 VGND VGND VPWR VPWR sky130_fd_sc_hd__decap_3
XTAP_TAPCELL_ROW_87_1387 VGND VPWR sky130_fd_sc_hd__tapvpwrvgnd_1
XANTENNA__7300__S _3561_ VGND VGND VPWR VPWR sky130_fd_sc_hd__diode_2
X_8988_ clknet_leaf_104_clk _0085_ VGND VGND VPWR VPWR registers\[18\]\[28\] sky130_fd_sc_hd__dfxtp_1
XTAP_TAPCELL_ROW_2_287 VGND VPWR sky130_fd_sc_hd__tapvpwrvgnd_1
XANTENNA__7595__A0 _3071_ VGND VGND VPWR VPWR sky130_fd_sc_hd__diode_2
XFILLER_0_77_350 VGND VGND VPWR VPWR sky130_fd_sc_hd__fill_2
X_7939_ _3904_ VGND VGND VPWR VPWR _0379_ sky130_fd_sc_hd__clkbuf_1
XANTENNA__4225__A _1024_ VGND VGND VPWR VPWR sky130_fd_sc_hd__diode_2
XFILLER_0_38_726 VGND VGND VPWR VPWR sky130_fd_sc_hd__fill_2
XFILLER_0_107_102 VGND VGND VPWR VPWR sky130_fd_sc_hd__decap_4
XFILLER_0_65_567 VGND VGND VPWR VPWR sky130_fd_sc_hd__fill_1
XFILLER_0_65_545 VGND VGND VPWR VPWR sky130_fd_sc_hd__fill_2
XFILLER_0_37_236 VGND VGND VPWR VPWR sky130_fd_sc_hd__decap_4
XFILLER_0_53_729 VGND VGND VPWR VPWR sky130_fd_sc_hd__fill_1
XANTENNA__4256__S0 _1053_ VGND VGND VPWR VPWR sky130_fd_sc_hd__diode_2
XFILLER_0_60_250 VGND VGND VPWR VPWR sky130_fd_sc_hd__fill_2
XFILLER_0_33_453 VGND VGND VPWR VPWR sky130_fd_sc_hd__fill_2
XFILLER_0_21_615 VGND VGND VPWR VPWR sky130_fd_sc_hd__fill_1
XFILLER_0_33_486 VGND VGND VPWR VPWR sky130_fd_sc_hd__fill_2
XFILLER_0_103_363 VGND VGND VPWR VPWR sky130_fd_sc_hd__fill_2
XFILLER_0_103_352 VGND VGND VPWR VPWR sky130_fd_sc_hd__decap_4
XANTENNA__4559__S1 _1321_ VGND VGND VPWR VPWR sky130_fd_sc_hd__diode_2
XANTENNA__5490__S _1072_ VGND VGND VPWR VPWR sky130_fd_sc_hd__diode_2
XFILLER_0_57_19 VGND VGND VPWR VPWR sky130_fd_sc_hd__fill_2
XANTENNA__6586__S _3159_ VGND VGND VPWR VPWR sky130_fd_sc_hd__diode_2
XTAP_TAPCELL_ROW_29_640 VGND VPWR sky130_fd_sc_hd__tapvpwrvgnd_1
XANTENNA__4495__S0 _1201_ VGND VGND VPWR VPWR sky130_fd_sc_hd__diode_2
XFILLER_0_68_361 VGND VGND VPWR VPWR sky130_fd_sc_hd__decap_3
XFILLER_0_56_501 VGND VGND VPWR VPWR sky130_fd_sc_hd__fill_1
XFILLER_0_113_24 VGND VGND VPWR VPWR sky130_fd_sc_hd__decap_4
XFILLER_0_83_342 VGND VGND VPWR VPWR sky130_fd_sc_hd__decap_3
XFILLER_0_7_108 VGND VGND VPWR VPWR sky130_fd_sc_hd__fill_1
XFILLER_0_22_11 VGND VGND VPWR VPWR sky130_fd_sc_hd__fill_1
XFILLER_0_83_364 VGND VGND VPWR VPWR sky130_fd_sc_hd__decap_8
XFILLER_0_71_526 VGND VGND VPWR VPWR sky130_fd_sc_hd__fill_2
XTAP_TAPCELL_ROW_60_1037 VGND VPWR sky130_fd_sc_hd__tapvpwrvgnd_1
XFILLER_0_56_589 VGND VGND VPWR VPWR sky130_fd_sc_hd__fill_2
XFILLER_0_56_578 VGND VGND VPWR VPWR sky130_fd_sc_hd__fill_2
XFILLER_0_98_26 VGND VGND VPWR VPWR sky130_fd_sc_hd__fill_2
XFILLER_0_83_397 VGND VGND VPWR VPWR sky130_fd_sc_hd__fill_2
XANTENNA__8041__S _3948_ VGND VGND VPWR VPWR sky130_fd_sc_hd__diode_2
XANTENNA__6350__A net39 VGND VGND VPWR VPWR sky130_fd_sc_hd__diode_2
XFILLER_0_22_88 VGND VGND VPWR VPWR sky130_fd_sc_hd__fill_2
XFILLER_0_114_628 VPWR VGND VPWR VGND sky130_ef_sc_hd__decap_12
XANTENNA__4572__B1 _1143_ VGND VGND VPWR VPWR sky130_fd_sc_hd__diode_2
XANTENNA__7880__S _3865_ VGND VGND VPWR VPWR sky130_fd_sc_hd__diode_2
XFILLER_0_3_358 VGND VGND VPWR VPWR sky130_fd_sc_hd__decap_4
XFILLER_0_24_475 VGND VGND VPWR VPWR sky130_fd_sc_hd__fill_1
X_6270_ net42 VGND VGND VPWR VPWR _2970_ sky130_fd_sc_hd__buf_2
X_5221_ registers\[12\]\[18\] registers\[13\]\[18\] registers\[14\]\[18\] registers\[15\]\[18\]
+ _1968_ _1969_ VGND VGND VPWR VPWR _1971_ sky130_fd_sc_hd__mux4_1
X_5152_ registers\[8\]\[14\] registers\[9\]\[14\] registers\[10\]\[14\] registers\[11\]\[14\]
+ _1719_ _1720_ VGND VGND VPWR VPWR _1906_ sky130_fd_sc_hd__mux4_1
XTAP_TAPCELL_ROW_71_1188 VGND VPWR sky130_fd_sc_hd__tapvpwrvgnd_1
XTAP_TAPCELL_ROW_71_1177 VGND VPWR sky130_fd_sc_hd__tapvpwrvgnd_1
XFILLER_0_47_52 VGND VGND VPWR VPWR sky130_fd_sc_hd__fill_2
X_5083_ _1839_ _1840_ _1767_ VGND VGND VPWR VPWR _1841_ sky130_fd_sc_hd__mux2_1
XFILLER_0_79_604 VGND VGND VPWR VPWR sky130_fd_sc_hd__decap_3
X_8911_ clknet_leaf_65_clk _0008_ VGND VGND VPWR VPWR registers\[16\]\[15\] sky130_fd_sc_hd__dfxtp_1
XANTENNA__8216__S _4045_ VGND VGND VPWR VPWR sky130_fd_sc_hd__diode_2
X_8842_ clknet_leaf_35_clk _0963_ VGND VGND VPWR VPWR registers\[14\]\[10\] sky130_fd_sc_hd__dfxtp_1
X_8773_ clknet_leaf_33_clk _0894_ VGND VGND VPWR VPWR registers\[12\]\[5\] sky130_fd_sc_hd__dfxtp_1
XFILLER_0_87_692 VPWR VGND VPWR VGND sky130_ef_sc_hd__decap_12
XFILLER_0_87_670 VGND VGND VPWR VPWR sky130_fd_sc_hd__fill_2
XANTENNA__4486__S0 _1167_ VGND VGND VPWR VPWR sky130_fd_sc_hd__diode_2
X_5985_ net120 VGND VGND VPWR VPWR _2705_ sky130_fd_sc_hd__inv_2
XANTENNA__6244__B _2196_ VGND VGND VPWR VPWR sky130_fd_sc_hd__diode_2
X_7724_ registers\[24\]\[30\] _3497_ _3756_ VGND VGND VPWR VPWR _3790_ sky130_fd_sc_hd__mux2_1
XFILLER_0_47_556 VGND VGND VPWR VPWR sky130_fd_sc_hd__fill_1
X_4936_ _1636_ VGND VGND VPWR VPWR _1701_ sky130_fd_sc_hd__buf_6
X_7655_ _3131_ registers\[23\]\[30\] _3719_ VGND VGND VPWR VPWR _3753_ sky130_fd_sc_hd__mux2_1
XFILLER_0_19_258 VGND VGND VPWR VPWR sky130_fd_sc_hd__decap_4
XFILLER_0_34_206 VGND VGND VPWR VPWR sky130_fd_sc_hd__fill_2
XFILLER_0_35_729 VGND VGND VPWR VPWR sky130_fd_sc_hd__fill_1
X_4867_ _1627_ _1630_ _1633_ _1634_ VGND VGND VPWR VPWR _1635_ sky130_fd_sc_hd__o211a_1
X_6606_ registers\[0\]\[3\] _2968_ _3175_ VGND VGND VPWR VPWR _3179_ sky130_fd_sc_hd__mux2_1
X_7586_ _3716_ VGND VGND VPWR VPWR _0214_ sky130_fd_sc_hd__clkbuf_1
X_9325_ clknet_leaf_52_clk _0422_ VGND VGND VPWR VPWR registers\[2\]\[13\] sky130_fd_sc_hd__dfxtp_1
X_6537_ _3141_ VGND VGND VPWR VPWR _0764_ sky130_fd_sc_hd__clkbuf_1
X_4798_ _1569_ VGND VGND VPWR VPWR net133 sky130_fd_sc_hd__inv_2
XANTENNA__7790__S _3815_ VGND VGND VPWR VPWR sky130_fd_sc_hd__diode_2
X_6468_ _3095_ VGND VGND VPWR VPWR _0741_ sky130_fd_sc_hd__clkbuf_1
XFILLER_0_88_81 VGND VGND VPWR VPWR sky130_fd_sc_hd__decap_3
XANTENNA_clkbuf_leaf_63_clk_A clknet_4_14_0_clk VGND VGND VPWR VPWR sky130_fd_sc_hd__diode_2
XFILLER_0_70_592 VGND VGND VPWR VPWR sky130_fd_sc_hd__fill_2
X_9256_ clknet_leaf_20_clk _0353_ VGND VGND VPWR VPWR registers\[27\]\[8\] sky130_fd_sc_hd__dfxtp_1
X_9187_ clknet_leaf_23_clk _0284_ VGND VGND VPWR VPWR registers\[25\]\[3\] sky130_fd_sc_hd__dfxtp_1
X_6399_ _3051_ VGND VGND VPWR VPWR _0716_ sky130_fd_sc_hd__clkbuf_1
XFILLER_0_2_391 VGND VGND VPWR VPWR sky130_fd_sc_hd__decap_3
X_5419_ _2156_ _2157_ _2081_ VGND VGND VPWR VPWR _2158_ sky130_fd_sc_hd__mux2_1
X_8207_ _4046_ VGND VGND VPWR VPWR _0505_ sky130_fd_sc_hd__clkbuf_1
XFILLER_0_100_355 VGND VGND VPWR VPWR sky130_fd_sc_hd__decap_8
X_8138_ registers\[9\]\[0\] _3433_ _4009_ VGND VGND VPWR VPWR _4010_ sky130_fd_sc_hd__mux2_1
XTAP_TAPCELL_ROW_7_346 VGND VPWR sky130_fd_sc_hd__tapvpwrvgnd_1
XANTENNA_clkbuf_leaf_78_clk_A clknet_4_10_0_clk VGND VGND VPWR VPWR sky130_fd_sc_hd__diode_2
XTAP_TAPCELL_ROW_89_1416 VGND VPWR sky130_fd_sc_hd__tapvpwrvgnd_1
X_8069_ _3972_ VGND VGND VPWR VPWR _3973_ sky130_fd_sc_hd__clkbuf_8
XANTENNA__4713__S1 _1419_ VGND VGND VPWR VPWR sky130_fd_sc_hd__diode_2
XANTENNA__6435__A net38 VGND VGND VPWR VPWR sky130_fd_sc_hd__diode_2
XANTENNA__8126__S _3995_ VGND VGND VPWR VPWR sky130_fd_sc_hd__diode_2
XFILLER_0_69_169 VGND VGND VPWR VPWR sky130_fd_sc_hd__fill_2
XANTENNA__4477__S0 _1197_ VGND VGND VPWR VPWR sky130_fd_sc_hd__diode_2
XFILLER_0_78_681 VGND VGND VPWR VPWR sky130_fd_sc_hd__decap_8
XANTENNA__7965__S _3912_ VGND VGND VPWR VPWR sky130_fd_sc_hd__diode_2
XTAP_TAPCELL_ROW_54_963 VGND VPWR sky130_fd_sc_hd__tapvpwrvgnd_1
XFILLER_0_77_191 VGND VGND VPWR VPWR sky130_fd_sc_hd__decap_3
XANTENNA__6791__A1 _3014_ VGND VGND VPWR VPWR sky130_fd_sc_hd__diode_2
XFILLER_0_93_673 VGND VGND VPWR VPWR sky130_fd_sc_hd__fill_2
XANTENNA_clkbuf_leaf_16_clk_A clknet_4_6_0_clk VGND VGND VPWR VPWR sky130_fd_sc_hd__diode_2
XFILLER_0_38_589 VGND VGND VPWR VPWR sky130_fd_sc_hd__fill_2
XANTENNA__4229__S0 _1026_ VGND VGND VPWR VPWR sky130_fd_sc_hd__diode_2
XFILLER_0_26_729 VGND VGND VPWR VPWR sky130_fd_sc_hd__fill_1
XFILLER_0_108_477 VGND VGND VPWR VPWR sky130_fd_sc_hd__fill_1
XANTENNA__7740__A0 _3079_ VGND VGND VPWR VPWR sky130_fd_sc_hd__diode_2
XFILLER_0_68_29 VGND VGND VPWR VPWR sky130_fd_sc_hd__decap_4
XFILLER_0_68_18 VGND VGND VPWR VPWR sky130_fd_sc_hd__fill_2
XFILLER_0_0_328 VGND VGND VPWR VPWR sky130_fd_sc_hd__fill_2
XFILLER_0_21_423 VGND VGND VPWR VPWR sky130_fd_sc_hd__fill_2
XTAP_TAPCELL_ROW_111_1701 VGND VPWR sky130_fd_sc_hd__tapvpwrvgnd_1
XANTENNA__4829__S _1346_ VGND VGND VPWR VPWR sky130_fd_sc_hd__diode_2
XANTENNA__7205__S _3514_ VGND VGND VPWR VPWR sky130_fd_sc_hd__diode_2
Xclkbuf_4_9_0_clk clknet_0_clk VGND VGND VPWR VPWR clknet_4_9_0_clk sky130_fd_sc_hd__clkbuf_8
XANTENNA__4952__S1 _1692_ VGND VGND VPWR VPWR sky130_fd_sc_hd__diode_2
XFILLER_0_17_11 VGND VGND VPWR VPWR sky130_fd_sc_hd__fill_1
XFILLER_0_17_22 VGND VGND VPWR VPWR sky130_fd_sc_hd__fill_2
XANTENNA__4704__S1 _1416_ VGND VGND VPWR VPWR sky130_fd_sc_hd__diode_2
XTAP_TAPCELL_ROW_109_1674 VGND VPWR sky130_fd_sc_hd__tapvpwrvgnd_1
XANTENNA__8220__A1 _3449_ VGND VGND VPWR VPWR sky130_fd_sc_hd__diode_2
XANTENNA__5034__A1 _1701_ VGND VGND VPWR VPWR sky130_fd_sc_hd__diode_2
XFILLER_0_75_117 VGND VGND VPWR VPWR sky130_fd_sc_hd__decap_6
XFILLER_0_69_681 VGND VGND VPWR VPWR sky130_fd_sc_hd__fill_2
X_5770_ net138 _2499_ _2500_ _2317_ VGND VGND VPWR VPWR _2501_ sky130_fd_sc_hd__a211o_1
XFILLER_0_68_191 VGND VGND VPWR VPWR sky130_fd_sc_hd__fill_2
XFILLER_0_8_406 VGND VGND VPWR VPWR sky130_fd_sc_hd__fill_2
XFILLER_0_29_545 VGND VGND VPWR VPWR sky130_fd_sc_hd__fill_2
X_4721_ registers\[12\]\[24\] registers\[13\]\[24\] registers\[14\]\[24\] registers\[15\]\[24\]
+ _1404_ _1405_ VGND VGND VPWR VPWR _1497_ sky130_fd_sc_hd__mux4_1
XFILLER_0_16_206 VGND VGND VPWR VPWR sky130_fd_sc_hd__decap_3
XFILLER_0_17_729 VGND VGND VPWR VPWR sky130_fd_sc_hd__fill_1
XFILLER_0_29_578 VGND VGND VPWR VPWR sky130_fd_sc_hd__fill_1
XFILLER_0_44_537 VGND VGND VPWR VPWR sky130_fd_sc_hd__fill_2
X_7440_ _3639_ VGND VGND VPWR VPWR _0145_ sky130_fd_sc_hd__clkbuf_1
XFILLER_0_16_239 VGND VGND VPWR VPWR sky130_fd_sc_hd__fill_2
XANTENNA__6534__A1 _2966_ VGND VGND VPWR VPWR sky130_fd_sc_hd__diode_2
XTAP_TAPCELL_ROW_32_679 VGND VPWR sky130_fd_sc_hd__tapvpwrvgnd_1
X_4652_ _1381_ _1431_ VGND VGND VPWR VPWR _1432_ sky130_fd_sc_hd__nand2_1
Xinput30 wd3[22] VGND VGND VPWR VPWR net30 sky130_fd_sc_hd__buf_2
XFILLER_0_3_111 VGND VGND VPWR VPWR sky130_fd_sc_hd__fill_1
Xinput41 wd3[3] VGND VGND VPWR VPWR net41 sky130_fd_sc_hd__clkbuf_2
XANTENNA__5742__C1 _2420_ VGND VGND VPWR VPWR sky130_fd_sc_hd__diode_2
X_4583_ _1362_ _1363_ _1365_ _1153_ VGND VGND VPWR VPWR _1366_ sky130_fd_sc_hd__o211a_1
XFILLER_0_52_581 VGND VGND VPWR VPWR sky130_fd_sc_hd__fill_2
XANTENNA__4640__S0 _1418_ VGND VGND VPWR VPWR sky130_fd_sc_hd__diode_2
X_7371_ _3602_ VGND VGND VPWR VPWR _0113_ sky130_fd_sc_hd__clkbuf_1
X_9110_ clknet_leaf_94_clk _0207_ VGND VGND VPWR VPWR registers\[22\]\[22\] sky130_fd_sc_hd__dfxtp_1
XTAP_TAPCELL_ROW_73_1206 VGND VPWR sky130_fd_sc_hd__tapvpwrvgnd_1
X_6322_ _3005_ VGND VGND VPWR VPWR _0685_ sky130_fd_sc_hd__clkbuf_1
X_9041_ clknet_leaf_55_clk _0138_ VGND VGND VPWR VPWR registers\[20\]\[17\] sky130_fd_sc_hd__dfxtp_1
X_6253_ _2399_ _2951_ _2957_ VGND VGND VPWR VPWR net73 sky130_fd_sc_hd__o21ai_1
XFILLER_0_12_489 VGND VGND VPWR VPWR sky130_fd_sc_hd__fill_2
XFILLER_0_110_664 VGND VGND VPWR VPWR sky130_fd_sc_hd__fill_2
XANTENNA__5196__S1 _1814_ VGND VGND VPWR VPWR sky130_fd_sc_hd__diode_2
XANTENNA__7115__S _3456_ VGND VGND VPWR VPWR sky130_fd_sc_hd__diode_2
X_5204_ registers\[4\]\[17\] registers\[5\]\[17\] registers\[6\]\[17\] registers\[7\]\[17\]
+ _1820_ _1821_ VGND VGND VPWR VPWR _1955_ sky130_fd_sc_hd__mux4_1
XANTENNA__8039__A1 _3472_ VGND VGND VPWR VPWR sky130_fd_sc_hd__diode_2
XANTENNA__5424__A _2026_ VGND VGND VPWR VPWR sky130_fd_sc_hd__diode_2
XFILLER_0_110_686 VGND VGND VPWR VPWR sky130_fd_sc_hd__decap_3
XANTENNA__4943__S1 _1706_ VGND VGND VPWR VPWR sky130_fd_sc_hd__diode_2
X_6184_ _2619_ _2766_ _2892_ VGND VGND VPWR VPWR _2893_ sky130_fd_sc_hd__o21ai_1
XTAP_TAPCELL_ROW_4_305 VGND VPWR sky130_fd_sc_hd__tapvpwrvgnd_1
XANTENNA__6954__S _3361_ VGND VGND VPWR VPWR sky130_fd_sc_hd__diode_2
X_5135_ _1886_ _1889_ _1687_ VGND VGND VPWR VPWR _1890_ sky130_fd_sc_hd__mux2_1
XTAP_TAPCELL_ROW_4_316 VGND VPWR sky130_fd_sc_hd__tapvpwrvgnd_1
XANTENNA__7798__A0 _3065_ VGND VGND VPWR VPWR sky130_fd_sc_hd__diode_2
X_5066_ registers\[20\]\[9\] registers\[21\]\[9\] registers\[22\]\[9\] registers\[23\]\[9\]
+ _1820_ _1821_ VGND VGND VPWR VPWR _1825_ sky130_fd_sc_hd__mux4_1
XANTENNA__5229__A1_N _1960_ VGND VGND VPWR VPWR sky130_fd_sc_hd__diode_2
XFILLER_0_74_94 VGND VGND VPWR VPWR sky130_fd_sc_hd__decap_3
XANTENNA__6255__A net12 VGND VGND VPWR VPWR sky130_fd_sc_hd__diode_2
XTAP_TAPCELL_ROW_84_1357 VGND VPWR sky130_fd_sc_hd__tapvpwrvgnd_1
XTAP_TAPCELL_ROW_84_1346 VGND VPWR sky130_fd_sc_hd__tapvpwrvgnd_1
X_8825_ clknet_leaf_81_clk _0946_ VGND VGND VPWR VPWR registers\[13\]\[25\] sky130_fd_sc_hd__dfxtp_1
X_5968_ _2221_ _2283_ VGND VGND VPWR VPWR _2688_ sky130_fd_sc_hd__nand2_1
XFILLER_0_94_459 VGND VGND VPWR VPWR sky130_fd_sc_hd__fill_2
XFILLER_0_66_128 VGND VGND VPWR VPWR sky130_fd_sc_hd__fill_2
XTAP_TAPCELL_ROW_51_922 VGND VPWR sky130_fd_sc_hd__tapvpwrvgnd_1
XFILLER_0_47_320 VGND VGND VPWR VPWR sky130_fd_sc_hd__fill_2
X_8756_ clknet_leaf_84_clk _0877_ VGND VGND VPWR VPWR registers\[11\]\[20\] sky130_fd_sc_hd__dfxtp_1
XFILLER_0_75_673 VGND VGND VPWR VPWR sky130_fd_sc_hd__fill_2
X_4919_ registers\[28\]\[3\] registers\[29\]\[3\] registers\[30\]\[3\] registers\[31\]\[3\]
+ _1678_ _1679_ VGND VGND VPWR VPWR _1684_ sky130_fd_sc_hd__mux4_1
X_7707_ _3781_ VGND VGND VPWR VPWR _0270_ sky130_fd_sc_hd__clkbuf_1
XFILLER_0_90_643 VGND VGND VPWR VPWR sky130_fd_sc_hd__fill_1
XFILLER_0_90_610 VGND VGND VPWR VPWR sky130_fd_sc_hd__decap_3
X_8687_ clknet_leaf_47_clk _0808_ VGND VGND VPWR VPWR registers\[0\]\[15\] sky130_fd_sc_hd__dfxtp_1
X_5899_ _1286_ _2622_ VGND VGND VPWR VPWR _2623_ sky130_fd_sc_hd__xnor2_1
XANTENNA__7086__A net27 VGND VGND VPWR VPWR sky130_fd_sc_hd__diode_2
XFILLER_0_35_537 VGND VGND VPWR VPWR sky130_fd_sc_hd__fill_2
XFILLER_0_90_676 VPWR VGND VPWR VGND sky130_ef_sc_hd__decap_12
XFILLER_0_90_654 VGND VGND VPWR VPWR sky130_fd_sc_hd__decap_3
X_7638_ _3744_ VGND VGND VPWR VPWR _0238_ sky130_fd_sc_hd__clkbuf_1
XFILLER_0_105_469 VGND VGND VPWR VPWR sky130_fd_sc_hd__decap_6
XFILLER_0_43_570 VGND VGND VPWR VPWR sky130_fd_sc_hd__decap_3
X_7569_ _3113_ registers\[22\]\[21\] _3706_ VGND VGND VPWR VPWR _3708_ sky130_fd_sc_hd__mux2_1
XFILLER_0_43_592 VGND VGND VPWR VPWR sky130_fd_sc_hd__fill_2
X_9308_ clknet_leaf_88_clk _0405_ VGND VGND VPWR VPWR registers\[28\]\[28\] sky130_fd_sc_hd__dfxtp_1
XFILLER_0_101_642 VGND VGND VPWR VPWR sky130_fd_sc_hd__fill_2
XTAP_TAPCELL_ROW_95_1497 VGND VPWR sky130_fd_sc_hd__tapvpwrvgnd_1
X_9239_ clknet_leaf_70_clk _0336_ VGND VGND VPWR VPWR registers\[26\]\[23\] sky130_fd_sc_hd__dfxtp_1
XANTENNA__7025__S _3398_ VGND VGND VPWR VPWR sky130_fd_sc_hd__diode_2
XFILLER_0_100_141 VGND VGND VPWR VPWR sky130_fd_sc_hd__fill_2
XANTENNA__5187__S1 _1749_ VGND VGND VPWR VPWR sky130_fd_sc_hd__diode_2
XANTENNA__5334__A _2026_ VGND VGND VPWR VPWR sky130_fd_sc_hd__diode_2
XANTENNA__4934__S1 _1679_ VGND VGND VPWR VPWR sky130_fd_sc_hd__diode_2
XFILLER_0_89_209 VGND VGND VPWR VPWR sky130_fd_sc_hd__decap_4
XANTENNA__4384__S _1140_ VGND VGND VPWR VPWR sky130_fd_sc_hd__diode_2
XANTENNA_input19_A wd3[12] VGND VGND VPWR VPWR sky130_fd_sc_hd__diode_2
XFILLER_0_97_242 VGND VGND VPWR VPWR sky130_fd_sc_hd__fill_1
XFILLER_0_97_220 VGND VGND VPWR VPWR sky130_fd_sc_hd__fill_2
XANTENNA__7695__S _3768_ VGND VGND VPWR VPWR sky130_fd_sc_hd__diode_2
XANTENNA__7961__A0 _2989_ VGND VGND VPWR VPWR sky130_fd_sc_hd__diode_2
XANTENNA__5111__S1 _1799_ VGND VGND VPWR VPWR sky130_fd_sc_hd__diode_2
XFILLER_0_66_651 VGND VGND VPWR VPWR sky130_fd_sc_hd__decap_3
XFILLER_0_26_504 VGND VGND VPWR VPWR sky130_fd_sc_hd__fill_2
XFILLER_0_108_230 VGND VGND VPWR VPWR sky130_fd_sc_hd__decap_4
XFILLER_0_81_621 VGND VGND VPWR VPWR sky130_fd_sc_hd__decap_3
XANTENNA__5509__A _2136_ VGND VGND VPWR VPWR sky130_fd_sc_hd__diode_2
XANTENNA__4870__S0 _1617_ VGND VGND VPWR VPWR sky130_fd_sc_hd__diode_2
XFILLER_0_26_537 VGND VGND VPWR VPWR sky130_fd_sc_hd__fill_2
XFILLER_0_81_654 VGND VGND VPWR VPWR sky130_fd_sc_hd__fill_1
XFILLER_0_53_367 VGND VGND VPWR VPWR sky130_fd_sc_hd__decap_4
XFILLER_0_53_389 VGND VGND VPWR VPWR sky130_fd_sc_hd__decap_3
XFILLER_0_0_125 VPWR VGND VPWR VGND sky130_ef_sc_hd__decap_12
XANTENNA_output87_A net87 VGND VGND VPWR VPWR sky130_fd_sc_hd__diode_2
XANTENNA__5178__S1 _1765_ VGND VGND VPWR VPWR sky130_fd_sc_hd__diode_2
XANTENNA__6774__S _3261_ VGND VGND VPWR VPWR sky130_fd_sc_hd__diode_2
XANTENNA__8441__A1 net22 VGND VGND VPWR VPWR sky130_fd_sc_hd__diode_2
XFILLER_0_89_732 VGND VGND VPWR VPWR sky130_fd_sc_hd__fill_1
XFILLER_0_89_710 VGND VGND VPWR VPWR sky130_fd_sc_hd__fill_1
X_6940_ _3357_ VGND VGND VPWR VPWR _0951_ sky130_fd_sc_hd__clkbuf_1
XTAP_TAPCELL_ROW_37_738 VGND VPWR sky130_fd_sc_hd__tapvpwrvgnd_1
XANTENNA__5350__S1 _2028_ VGND VGND VPWR VPWR sky130_fd_sc_hd__diode_2
XFILLER_0_88_264 VGND VGND VPWR VPWR sky130_fd_sc_hd__fill_2
X_6871_ registers\[12\]\[30\] _3024_ _3287_ VGND VGND VPWR VPWR _3321_ sky130_fd_sc_hd__mux2_1
XFILLER_0_48_117 VGND VGND VPWR VPWR sky130_fd_sc_hd__decap_4
XANTENNA__5102__S1 _1775_ VGND VGND VPWR VPWR sky130_fd_sc_hd__diode_2
XANTENNA__6755__A1 _2978_ VGND VGND VPWR VPWR sky130_fd_sc_hd__diode_2
XFILLER_0_76_448 VGND VGND VPWR VPWR sky130_fd_sc_hd__fill_2
X_5822_ _1819_ _2548_ VGND VGND VPWR VPWR _2550_ sky130_fd_sc_hd__and2_1
XANTENNA__7952__A0 _2980_ VGND VGND VPWR VPWR sky130_fd_sc_hd__diode_2
XFILLER_0_48_128 VGND VGND VPWR VPWR sky130_fd_sc_hd__fill_2
X_8610_ clknet_leaf_0_clk _0731_ VGND VGND VPWR VPWR registers\[29\]\[2\] sky130_fd_sc_hd__dfxtp_1
X_5753_ _2328_ net14 VGND VGND VPWR VPWR _2484_ sky130_fd_sc_hd__nand2_2
XFILLER_0_57_673 VGND VGND VPWR VPWR sky130_fd_sc_hd__decap_4
XFILLER_0_56_150 VGND VGND VPWR VPWR sky130_fd_sc_hd__fill_2
X_8541_ _4222_ VGND VGND VPWR VPWR _0663_ sky130_fd_sc_hd__clkbuf_1
XFILLER_0_8_214 VGND VGND VPWR VPWR sky130_fd_sc_hd__decap_3
XTAP_TAPCELL_ROW_17_484 VGND VPWR sky130_fd_sc_hd__tapvpwrvgnd_1
XFILLER_0_84_470 VGND VGND VPWR VPWR sky130_fd_sc_hd__decap_4
XFILLER_0_60_52 VGND VGND VPWR VPWR sky130_fd_sc_hd__decap_6
XFILLER_0_56_183 VGND VGND VPWR VPWR sky130_fd_sc_hd__fill_2
XFILLER_0_44_323 VGND VGND VPWR VPWR sky130_fd_sc_hd__fill_1
X_4704_ registers\[0\]\[23\] registers\[1\]\[23\] registers\[2\]\[23\] registers\[3\]\[23\]
+ _1415_ _1416_ VGND VGND VPWR VPWR _1481_ sky130_fd_sc_hd__mux4_1
XFILLER_0_29_386 VGND VGND VPWR VPWR sky130_fd_sc_hd__fill_1
X_5684_ _2307_ _2417_ VGND VGND VPWR VPWR _2418_ sky130_fd_sc_hd__nor2_1
XFILLER_0_71_131 VGND VGND VPWR VPWR sky130_fd_sc_hd__decap_3
X_8472_ registers\[8\]\[30\] net39 _4152_ VGND VGND VPWR VPWR _4186_ sky130_fd_sc_hd__mux2_1
XFILLER_0_44_345 VGND VGND VPWR VPWR sky130_fd_sc_hd__fill_2
X_4635_ _1160_ VGND VGND VPWR VPWR _1415_ sky130_fd_sc_hd__clkbuf_8
XFILLER_0_72_676 VGND VGND VPWR VPWR sky130_fd_sc_hd__fill_2
XFILLER_0_71_164 VGND VGND VPWR VPWR sky130_fd_sc_hd__fill_2
X_7423_ _3630_ VGND VGND VPWR VPWR _0137_ sky130_fd_sc_hd__clkbuf_1
XFILLER_0_4_442 VGND VGND VPWR VPWR sky130_fd_sc_hd__fill_2
XFILLER_0_25_570 VGND VGND VPWR VPWR sky130_fd_sc_hd__fill_2
X_4566_ registers\[8\]\[16\] registers\[9\]\[16\] registers\[10\]\[16\] registers\[11\]\[16\]
+ _1126_ _1128_ VGND VGND VPWR VPWR _1350_ sky130_fd_sc_hd__mux4_1
X_7354_ _3593_ VGND VGND VPWR VPWR _0105_ sky130_fd_sc_hd__clkbuf_1
XFILLER_0_13_732 VGND VGND VPWR VPWR sky130_fd_sc_hd__fill_1
XFILLER_0_25_592 VGND VGND VPWR VPWR sky130_fd_sc_hd__decap_8
XANTENNA__7634__A _3719_ VGND VGND VPWR VPWR sky130_fd_sc_hd__diode_2
X_6305_ registers\[19\]\[15\] _2993_ _2983_ VGND VGND VPWR VPWR _2994_ sky130_fd_sc_hd__mux2_1
XFILLER_0_12_253 VGND VGND VPWR VPWR sky130_fd_sc_hd__decap_4
XFILLER_0_100_80 VGND VGND VPWR VPWR sky130_fd_sc_hd__fill_2
X_7285_ registers\[18\]\[16\] _3468_ _3550_ VGND VGND VPWR VPWR _3557_ sky130_fd_sc_hd__mux2_1
X_4497_ _1279_ _1281_ _1284_ _1153_ _1142_ VGND VGND VPWR VPWR _1285_ sky130_fd_sc_hd__a221o_1
XFILLER_0_12_286 VGND VGND VPWR VPWR sky130_fd_sc_hd__fill_2
X_9024_ clknet_leaf_111_clk _0121_ VGND VGND VPWR VPWR registers\[20\]\[0\] sky130_fd_sc_hd__dfxtp_1
XANTENNA__4916__S1 _1679_ VGND VGND VPWR VPWR sky130_fd_sc_hd__diode_2
X_6236_ _2940_ _2941_ VGND VGND VPWR VPWR _2942_ sky130_fd_sc_hd__or2_1
X_6167_ _2838_ _2859_ _2876_ VGND VGND VPWR VPWR _2877_ sky130_fd_sc_hd__a21oi_1
X_5118_ registers\[12\]\[12\] registers\[13\]\[12\] registers\[14\]\[12\] registers\[15\]\[12\]
+ _1762_ _1764_ VGND VGND VPWR VPWR _1874_ sky130_fd_sc_hd__mux4_1
X_6098_ _2758_ _2810_ _2460_ VGND VGND VPWR VPWR _2811_ sky130_fd_sc_hd__mux2_1
XANTENNA__5246__A1 _1677_ VGND VGND VPWR VPWR sky130_fd_sc_hd__diode_2
XFILLER_0_79_220 VGND VGND VPWR VPWR sky130_fd_sc_hd__decap_4
X_5049_ _1631_ VGND VGND VPWR VPWR _1809_ sky130_fd_sc_hd__buf_4
XFILLER_0_95_724 VGND VGND VPWR VPWR sky130_fd_sc_hd__decap_4
XFILLER_0_95_713 VGND VGND VPWR VPWR sky130_fd_sc_hd__fill_1
XFILLER_0_79_264 VGND VGND VPWR VPWR sky130_fd_sc_hd__fill_2
X_8808_ clknet_leaf_18_clk _0929_ VGND VGND VPWR VPWR registers\[13\]\[8\] sky130_fd_sc_hd__dfxtp_1
XFILLER_0_94_256 VGND VGND VPWR VPWR sky130_fd_sc_hd__decap_4
XFILLER_0_82_418 VGND VGND VPWR VPWR sky130_fd_sc_hd__fill_2
XFILLER_0_48_673 VPWR VGND VPWR VGND sky130_ef_sc_hd__decap_12
XFILLER_0_82_429 VGND VGND VPWR VPWR sky130_fd_sc_hd__fill_2
XFILLER_0_63_632 VGND VGND VPWR VPWR sky130_fd_sc_hd__fill_2
XFILLER_0_63_621 VGND VGND VPWR VPWR sky130_fd_sc_hd__fill_2
X_8739_ clknet_leaf_6_clk _0860_ VGND VGND VPWR VPWR registers\[11\]\[3\] sky130_fd_sc_hd__dfxtp_1
XFILLER_0_47_161 VGND VGND VPWR VPWR sky130_fd_sc_hd__fill_2
XANTENNA__4852__S0 _1617_ VGND VGND VPWR VPWR sky130_fd_sc_hd__diode_2
XANTENNA__5329__A _1969_ VGND VGND VPWR VPWR sky130_fd_sc_hd__diode_2
XTAP_TAPCELL_ROW_97_1515 VGND VPWR sky130_fd_sc_hd__tapvpwrvgnd_1
XANTENNA__8499__A1 net17 VGND VGND VPWR VPWR sky130_fd_sc_hd__diode_2
XFILLER_0_63_654 VGND VGND VPWR VPWR sky130_fd_sc_hd__decap_6
XANTENNA__4233__A _1025_ VGND VGND VPWR VPWR sky130_fd_sc_hd__diode_2
XTAP_TAPCELL_ROW_97_1526 VGND VPWR sky130_fd_sc_hd__tapvpwrvgnd_1
XANTENNA__6859__S _3310_ VGND VGND VPWR VPWR sky130_fd_sc_hd__diode_2
XFILLER_0_35_389 VGND VGND VPWR VPWR sky130_fd_sc_hd__decap_3
XFILLER_0_62_197 VGND VGND VPWR VPWR sky130_fd_sc_hd__fill_1
XANTENNA__4907__S1 _1643_ VGND VGND VPWR VPWR sky130_fd_sc_hd__diode_2
XANTENNA__5485__A1 _1943_ VGND VGND VPWR VPWR sky130_fd_sc_hd__diode_2
XANTENNA__5511__B _2213_ VGND VGND VPWR VPWR sky130_fd_sc_hd__diode_2
XANTENNA__4408__A _1197_ VGND VGND VPWR VPWR sky130_fd_sc_hd__diode_2
XTAP_TAPCELL_ROW_106_1633 VGND VPWR sky130_fd_sc_hd__tapvpwrvgnd_1
XFILLER_0_98_573 VGND VGND VPWR VPWR sky130_fd_sc_hd__decap_3
XFILLER_0_86_713 VGND VGND VPWR VPWR sky130_fd_sc_hd__fill_1
XFILLER_0_85_201 VGND VGND VPWR VPWR sky130_fd_sc_hd__decap_4
XFILLER_0_58_448 VGND VGND VPWR VPWR sky130_fd_sc_hd__decap_3
XANTENNA__7934__A0 _2958_ VGND VGND VPWR VPWR sky130_fd_sc_hd__diode_2
XANTENNA__5096__S0 _1763_ VGND VGND VPWR VPWR sky130_fd_sc_hd__diode_2
XFILLER_0_105_69 VGND VGND VPWR VPWR sky130_fd_sc_hd__fill_1
XANTENNA__5239__A _1767_ VGND VGND VPWR VPWR sky130_fd_sc_hd__diode_2
XFILLER_0_39_673 VGND VGND VPWR VPWR sky130_fd_sc_hd__fill_1
XFILLER_0_38_172 VGND VGND VPWR VPWR sky130_fd_sc_hd__decap_3
XTAP_TAPCELL_ROW_14_443 VGND VPWR sky130_fd_sc_hd__tapvpwrvgnd_1
XANTENNA__4843__S0 _1427_ VGND VGND VPWR VPWR sky130_fd_sc_hd__diode_2
XFILLER_0_109_561 VGND VGND VPWR VPWR sky130_fd_sc_hd__fill_2
XFILLER_0_54_687 VGND VGND VPWR VPWR sky130_fd_sc_hd__decap_4
XFILLER_0_53_164 VGND VGND VPWR VPWR sky130_fd_sc_hd__fill_2
XFILLER_0_41_304 VGND VGND VPWR VPWR sky130_fd_sc_hd__decap_3
XFILLER_0_14_529 VGND VGND VPWR VPWR sky130_fd_sc_hd__decap_3
X_4420_ registers\[20\]\[8\] registers\[21\]\[8\] registers\[22\]\[8\] registers\[23\]\[8\]
+ _1053_ _1054_ VGND VGND VPWR VPWR _1212_ sky130_fd_sc_hd__mux4_1
XFILLER_0_41_337 VGND VGND VPWR VPWR sky130_fd_sc_hd__decap_4
XTAP_TAPCELL_ROW_117_1784 VGND VPWR sky130_fd_sc_hd__tapvpwrvgnd_1
XFILLER_0_111_225 VGND VGND VPWR VPWR sky130_fd_sc_hd__fill_2
XFILLER_0_1_412 VGND VGND VPWR VPWR sky130_fd_sc_hd__fill_2
X_4351_ registers\[20\]\[5\] registers\[21\]\[5\] registers\[22\]\[5\] registers\[23\]\[5\]
+ _1111_ _1113_ VGND VGND VPWR VPWR _1146_ sky130_fd_sc_hd__mux4_1
XANTENNA__4289__S net6 VGND VGND VPWR VPWR sky130_fd_sc_hd__diode_2
XFILLER_0_39_64 VGND VGND VPWR VPWR sky130_fd_sc_hd__fill_2
X_7070_ _3427_ VGND VGND VPWR VPWR _1011_ sky130_fd_sc_hd__clkbuf_1
X_4282_ _1076_ _1079_ _1034_ VGND VGND VPWR VPWR _1080_ sky130_fd_sc_hd__mux2_2
XANTENNA__5020__S0 _1731_ VGND VGND VPWR VPWR sky130_fd_sc_hd__diode_2
X_6021_ _2205_ _2206_ _2706_ _2394_ VGND VGND VPWR VPWR _2739_ sky130_fd_sc_hd__a31o_1
XANTENNA__5702__A _1676_ VGND VGND VPWR VPWR sky130_fd_sc_hd__diode_2
XANTENNA__8414__A1 net38 VGND VGND VPWR VPWR sky130_fd_sc_hd__diode_2
XANTENNA__5228__A1 _1771_ VGND VGND VPWR VPWR sky130_fd_sc_hd__diode_2
XTAP_TAPCELL_ROW_68_1138 VGND VPWR sky130_fd_sc_hd__tapvpwrvgnd_1
X_7972_ _3921_ VGND VGND VPWR VPWR _0395_ sky130_fd_sc_hd__clkbuf_1
XFILLER_0_55_96 VGND VGND VPWR VPWR sky130_fd_sc_hd__decap_4
XTAP_TAPCELL_ROW_68_1149 VGND VPWR sky130_fd_sc_hd__tapvpwrvgnd_1
X_6923_ _3115_ registers\[13\]\[22\] _3346_ VGND VGND VPWR VPWR _3349_ sky130_fd_sc_hd__mux2_1
XTAP_TAPCELL_ROW_81_1316 VGND VPWR sky130_fd_sc_hd__tapvpwrvgnd_1
XANTENNA__8224__S _4045_ VGND VGND VPWR VPWR sky130_fd_sc_hd__diode_2
XFILLER_0_71_40 VPWR VGND VPWR VGND sky130_ef_sc_hd__decap_12
XFILLER_0_71_73 VGND VGND VPWR VPWR sky130_fd_sc_hd__fill_2
X_6854_ _3312_ VGND VGND VPWR VPWR _0910_ sky130_fd_sc_hd__clkbuf_1
XFILLER_0_107_509 VGND VGND VPWR VPWR sky130_fd_sc_hd__fill_1
X_5805_ _2526_ _2532_ _2533_ VGND VGND VPWR VPWR _2534_ sky130_fd_sc_hd__a21oi_1
XFILLER_0_64_429 VGND VGND VPWR VPWR sky130_fd_sc_hd__decap_4
X_6785_ registers\[11\]\[22\] _3008_ _3272_ VGND VGND VPWR VPWR _3275_ sky130_fd_sc_hd__mux2_1
XANTENNA__4834__S0 _1555_ VGND VGND VPWR VPWR sky130_fd_sc_hd__diode_2
X_5736_ _1108_ _2467_ VGND VGND VPWR VPWR _2468_ sky130_fd_sc_hd__nor2_2
XFILLER_0_45_654 VGND VGND VPWR VPWR sky130_fd_sc_hd__fill_2
XFILLER_0_45_643 VGND VGND VPWR VPWR sky130_fd_sc_hd__decap_3
X_8524_ registers\[4\]\[22\] net30 _4211_ VGND VGND VPWR VPWR _4214_ sky130_fd_sc_hd__mux2_1
XANTENNA__6679__S _3214_ VGND VGND VPWR VPWR sky130_fd_sc_hd__diode_2
X_5667_ _2222_ _2285_ _2307_ VGND VGND VPWR VPWR _2401_ sky130_fd_sc_hd__mux2_1
XFILLER_0_72_473 VGND VGND VPWR VPWR sky130_fd_sc_hd__decap_3
X_8455_ _4177_ VGND VGND VPWR VPWR _0622_ sky130_fd_sc_hd__clkbuf_1
X_4618_ _1397_ _1398_ _1344_ VGND VGND VPWR VPWR _1399_ sky130_fd_sc_hd__mux2_1
XFILLER_0_60_657 VGND VGND VPWR VPWR sky130_fd_sc_hd__fill_2
X_7406_ _3621_ VGND VGND VPWR VPWR _0129_ sky130_fd_sc_hd__clkbuf_1
XFILLER_0_44_197 VGND VGND VPWR VPWR sky130_fd_sc_hd__decap_3
XFILLER_0_4_250 VGND VGND VPWR VPWR sky130_fd_sc_hd__fill_2
X_5598_ _1943_ _2216_ _2217_ VGND VGND VPWR VPWR _2333_ sky130_fd_sc_hd__o21ai_1
XTAP_TAPCELL_ROW_79_1289 VGND VPWR sky130_fd_sc_hd__tapvpwrvgnd_1
X_8386_ registers\[5\]\[21\] _3479_ _4139_ VGND VGND VPWR VPWR _4141_ sky130_fd_sc_hd__mux2_1
X_4549_ registers\[12\]\[15\] registers\[13\]\[15\] registers\[14\]\[15\] registers\[15\]\[15\]
+ _1198_ _1199_ VGND VGND VPWR VPWR _1334_ sky130_fd_sc_hd__mux4_1
X_7337_ _3584_ VGND VGND VPWR VPWR _0097_ sky130_fd_sc_hd__clkbuf_1
XTAP_TAPCELL_ROW_92_1456 VGND VPWR sky130_fd_sc_hd__tapvpwrvgnd_1
X_7268_ registers\[18\]\[8\] _3451_ _3539_ VGND VGND VPWR VPWR _3548_ sky130_fd_sc_hd__mux2_1
XFILLER_0_40_392 VGND VGND VPWR VPWR sky130_fd_sc_hd__fill_2
X_6219_ _2321_ _2925_ _2467_ VGND VGND VPWR VPWR _2926_ sky130_fd_sc_hd__a21o_1
X_9007_ clknet_leaf_48_clk _0104_ VGND VGND VPWR VPWR registers\[1\]\[15\] sky130_fd_sc_hd__dfxtp_1
X_7199_ _3511_ VGND VGND VPWR VPWR _0032_ sky130_fd_sc_hd__clkbuf_1
XFILLER_0_68_713 VGND VGND VPWR VPWR sky130_fd_sc_hd__fill_2
XANTENNA__8134__S _3972_ VGND VGND VPWR VPWR sky130_fd_sc_hd__diode_2
XANTENNA__5078__S0 _1757_ VGND VGND VPWR VPWR sky130_fd_sc_hd__diode_2
XFILLER_0_83_727 VGND VGND VPWR VPWR sky130_fd_sc_hd__fill_1
XANTENNA__7973__S _3912_ VGND VGND VPWR VPWR sky130_fd_sc_hd__diode_2
XFILLER_0_55_429 VGND VGND VPWR VPWR sky130_fd_sc_hd__fill_2
XTAP_TAPCELL_ROW_101_1574 VGND VPWR sky130_fd_sc_hd__tapvpwrvgnd_1
XTAP_TAPCELL_ROW_11_402 VGND VPWR sky130_fd_sc_hd__tapvpwrvgnd_1
XFILLER_0_51_657 VGND VGND VPWR VPWR sky130_fd_sc_hd__decap_6
XFILLER_0_50_101 VGND VGND VPWR VPWR sky130_fd_sc_hd__fill_2
Xclkload19 clknet_leaf_109_clk VGND VGND VPWR VPWR clkload19/Y sky130_fd_sc_hd__clkinvlp_2
XFILLER_0_23_337 VGND VGND VPWR VPWR sky130_fd_sc_hd__fill_2
XFILLER_0_35_197 VGND VGND VPWR VPWR sky130_fd_sc_hd__fill_1
XANTENNA__5250__S0 _1996_ VGND VGND VPWR VPWR sky130_fd_sc_hd__diode_2
XFILLER_0_76_29 VGND VGND VPWR VPWR sky130_fd_sc_hd__decap_4
XANTENNA__5458__B2 _2026_ VGND VGND VPWR VPWR sky130_fd_sc_hd__diode_2
XANTENNA__8309__S _4092_ VGND VGND VPWR VPWR sky130_fd_sc_hd__diode_2
XANTENNA__7213__S _3514_ VGND VGND VPWR VPWR sky130_fd_sc_hd__diode_2
XANTENNA__5305__S1 _1774_ VGND VGND VPWR VPWR sky130_fd_sc_hd__diode_2
XTAP_TAPCELL_ROW_19_502 VGND VPWR sky130_fd_sc_hd__tapvpwrvgnd_1
XTAP_TAPCELL_ROW_47_866 VGND VPWR sky130_fd_sc_hd__tapvpwrvgnd_1
XFILLER_0_25_44 VGND VGND VPWR VPWR sky130_fd_sc_hd__fill_2
XANTENNA__5630__A1 _1979_ VGND VGND VPWR VPWR sky130_fd_sc_hd__diode_2
XFILLER_0_58_201 VGND VGND VPWR VPWR sky130_fd_sc_hd__fill_1
XANTENNA__8044__S _3959_ VGND VGND VPWR VPWR sky130_fd_sc_hd__diode_2
XFILLER_0_25_77 VGND VGND VPWR VPWR sky130_fd_sc_hd__fill_1
XFILLER_0_58_245 VGND VGND VPWR VPWR sky130_fd_sc_hd__fill_1
XANTENNA__6353__A net40 VGND VGND VPWR VPWR sky130_fd_sc_hd__diode_2
XFILLER_0_46_429 VGND VGND VPWR VPWR sky130_fd_sc_hd__decap_3
XFILLER_0_41_21 VGND VGND VPWR VPWR sky130_fd_sc_hd__fill_1
XTAP_TAPCELL_ROW_63_1079 VGND VPWR sky130_fd_sc_hd__tapvpwrvgnd_1
X_6570_ _3158_ VGND VGND VPWR VPWR _0780_ sky130_fd_sc_hd__clkbuf_1
XANTENNA__4816__S0 _1390_ VGND VGND VPWR VPWR sky130_fd_sc_hd__diode_2
XFILLER_0_41_54 VGND VGND VPWR VPWR sky130_fd_sc_hd__fill_2
XTAP_TAPCELL_ROW_119_1824 VGND VPWR sky130_fd_sc_hd__tapvpwrvgnd_1
XTAP_TAPCELL_ROW_119_1813 VGND VPWR sky130_fd_sc_hd__tapvpwrvgnd_1
XTAP_TAPCELL_ROW_119_1802 VGND VPWR sky130_fd_sc_hd__tapvpwrvgnd_1
XFILLER_0_109_391 VGND VGND VPWR VPWR sky130_fd_sc_hd__fill_1
X_5521_ _2196_ _2234_ VGND VGND VPWR VPWR _2257_ sky130_fd_sc_hd__nor2_1
XFILLER_0_42_602 VGND VGND VPWR VPWR sky130_fd_sc_hd__fill_2
XFILLER_0_81_281 VGND VGND VPWR VPWR sky130_fd_sc_hd__fill_2
X_8240_ _4063_ VGND VGND VPWR VPWR _0521_ sky130_fd_sc_hd__clkbuf_1
XANTENNA__8332__A0 _3020_ VGND VGND VPWR VPWR sky130_fd_sc_hd__diode_2
XFILLER_0_26_197 VGND VGND VPWR VPWR sky130_fd_sc_hd__fill_2
XANTENNA__5697__A1 _1049_ VGND VGND VPWR VPWR sky130_fd_sc_hd__diode_2
XFILLER_0_2_721 VPWR VGND VPWR VGND sky130_ef_sc_hd__decap_12
XANTENNA__4601__A _1324_ VGND VGND VPWR VPWR sky130_fd_sc_hd__diode_2
X_5452_ _2076_ _2188_ VGND VGND VPWR VPWR _2189_ sky130_fd_sc_hd__and2_1
X_8171_ registers\[9\]\[16\] _3468_ _4020_ VGND VGND VPWR VPWR _4027_ sky130_fd_sc_hd__mux2_1
X_4403_ _1060_ VGND VGND VPWR VPWR _1196_ sky130_fd_sc_hd__buf_4
XFILLER_0_10_521 VGND VGND VPWR VPWR sky130_fd_sc_hd__fill_2
X_5383_ registers\[20\]\[27\] registers\[21\]\[27\] registers\[22\]\[27\] registers\[23\]\[27\]
+ _2119_ _2120_ VGND VGND VPWR VPWR _2124_ sky130_fd_sc_hd__mux4_1
XFILLER_0_112_589 VGND VGND VPWR VPWR sky130_fd_sc_hd__decap_4
X_4334_ registers\[12\]\[4\] registers\[13\]\[4\] registers\[14\]\[4\] registers\[15\]\[4\]
+ _1126_ _1128_ VGND VGND VPWR VPWR _1130_ sky130_fd_sc_hd__mux4_1
X_7122_ _3461_ VGND VGND VPWR VPWR _0005_ sky130_fd_sc_hd__clkbuf_1
XFILLER_0_50_690 VGND VGND VPWR VPWR sky130_fd_sc_hd__fill_2
XFILLER_0_1_253 VGND VGND VPWR VPWR sky130_fd_sc_hd__decap_3
X_7053_ _3418_ VGND VGND VPWR VPWR _1003_ sky130_fd_sc_hd__clkbuf_1
X_6004_ _2674_ VGND VGND VPWR VPWR _2723_ sky130_fd_sc_hd__inv_2
X_4265_ registers\[8\]\[1\] registers\[9\]\[1\] registers\[10\]\[1\] registers\[11\]\[1\]
+ _1039_ _1040_ VGND VGND VPWR VPWR _1064_ sky130_fd_sc_hd__mux4_1
XFILLER_0_5_76 VGND VGND VPWR VPWR sky130_fd_sc_hd__decap_3
XFILLER_0_10_598 VGND VGND VPWR VPWR sky130_fd_sc_hd__fill_1
XANTENNA_clkload10_A clknet_4_11_0_clk VGND VGND VPWR VPWR sky130_fd_sc_hd__diode_2
XANTENNA__6962__S _3361_ VGND VGND VPWR VPWR sky130_fd_sc_hd__diode_2
X_7955_ _2982_ registers\[28\]\[10\] _3912_ VGND VGND VPWR VPWR _3913_ sky130_fd_sc_hd__mux2_1
X_6906_ _3098_ registers\[13\]\[14\] _3335_ VGND VGND VPWR VPWR _3340_ sky130_fd_sc_hd__mux2_1
XFILLER_0_82_94 VGND VGND VPWR VPWR sky130_fd_sc_hd__fill_2
XFILLER_0_77_543 VGND VGND VPWR VPWR sky130_fd_sc_hd__fill_2
X_7886_ _3864_ VGND VGND VPWR VPWR _3876_ sky130_fd_sc_hd__clkbuf_8
X_6837_ _3303_ VGND VGND VPWR VPWR _0902_ sky130_fd_sc_hd__clkbuf_1
XFILLER_0_49_278 VGND VGND VPWR VPWR sky130_fd_sc_hd__fill_2
XANTENNA__7374__A1 _3489_ VGND VGND VPWR VPWR sky130_fd_sc_hd__diode_2
XFILLER_0_64_237 VPWR VGND VPWR VGND sky130_ef_sc_hd__decap_12
XANTENNA__4807__S0 _1550_ VGND VGND VPWR VPWR sky130_fd_sc_hd__diode_2
X_9556_ clknet_leaf_70_clk _0653_ VGND VGND VPWR VPWR registers\[4\]\[20\] sky130_fd_sc_hd__dfxtp_1
X_6768_ registers\[11\]\[14\] _2991_ _3261_ VGND VGND VPWR VPWR _3266_ sky130_fd_sc_hd__mux2_1
X_8507_ registers\[4\]\[14\] net21 _4200_ VGND VGND VPWR VPWR _4205_ sky130_fd_sc_hd__mux2_1
XFILLER_0_17_164 VGND VGND VPWR VPWR sky130_fd_sc_hd__fill_2
XFILLER_0_18_665 VGND VGND VPWR VPWR sky130_fd_sc_hd__decap_8
XANTENNA__4283__S1 _1027_ VGND VGND VPWR VPWR sky130_fd_sc_hd__diode_2
X_5719_ _2450_ _2451_ _1090_ VGND VGND VPWR VPWR _2452_ sky130_fd_sc_hd__mux2_1
X_6699_ _3229_ VGND VGND VPWR VPWR _0838_ sky130_fd_sc_hd__clkbuf_1
X_9487_ clknet_leaf_48_clk _0584_ VGND VGND VPWR VPWR registers\[5\]\[15\] sky130_fd_sc_hd__dfxtp_1
X_8438_ _4168_ VGND VGND VPWR VPWR _0614_ sky130_fd_sc_hd__clkbuf_1
XFILLER_0_5_581 VGND VGND VPWR VPWR sky130_fd_sc_hd__fill_2
XFILLER_0_33_679 VGND VGND VPWR VPWR sky130_fd_sc_hd__decap_4
XFILLER_0_103_567 VGND VGND VPWR VPWR sky130_fd_sc_hd__fill_1
X_8369_ registers\[5\]\[13\] _3462_ _4128_ VGND VGND VPWR VPWR _4132_ sky130_fd_sc_hd__mux2_1
XANTENNA__5232__S0 _1719_ VGND VGND VPWR VPWR sky130_fd_sc_hd__diode_2
XANTENNA__7033__S _3398_ VGND VGND VPWR VPWR sky130_fd_sc_hd__diode_2
XANTENNA__6438__A net41 VGND VGND VPWR VPWR sky130_fd_sc_hd__diode_2
XANTENNA__4657__S _1346_ VGND VGND VPWR VPWR sky130_fd_sc_hd__diode_2
XANTENNA__5299__S0 _1798_ VGND VGND VPWR VPWR sky130_fd_sc_hd__diode_2
XTAP_TAPCELL_ROW_103_1603 VGND VPWR sky130_fd_sc_hd__tapvpwrvgnd_1
XTAP_TAPCELL_ROW_44_836 VGND VPWR sky130_fd_sc_hd__tapvpwrvgnd_1
XTAP_TAPCELL_ROW_44_825 VGND VPWR sky130_fd_sc_hd__tapvpwrvgnd_1
XFILLER_0_68_598 VGND VGND VPWR VPWR sky130_fd_sc_hd__fill_1
XFILLER_0_68_587 VGND VGND VPWR VPWR sky130_fd_sc_hd__fill_1
XFILLER_0_56_727 VGND VGND VPWR VPWR sky130_fd_sc_hd__decap_3
XTAP_TAPCELL_ROW_24_571 VGND VPWR sky130_fd_sc_hd__tapvpwrvgnd_1
XFILLER_0_83_579 VGND VGND VPWR VPWR sky130_fd_sc_hd__fill_2
XFILLER_0_63_281 VGND VGND VPWR VPWR sky130_fd_sc_hd__decap_4
XFILLER_0_51_421 VGND VGND VPWR VPWR sky130_fd_sc_hd__fill_2
XFILLER_0_11_57 VGND VGND VPWR VPWR sky130_fd_sc_hd__fill_2
XFILLER_0_11_68 VGND VGND VPWR VPWR sky130_fd_sc_hd__fill_2
XFILLER_0_23_178 VGND VGND VPWR VPWR sky130_fd_sc_hd__fill_2
XTAP_TAPCELL_ROW_114_1743 VGND VPWR sky130_fd_sc_hd__tapvpwrvgnd_1
XANTENNA__8039__S _3948_ VGND VGND VPWR VPWR sky130_fd_sc_hd__diode_2
XANTENNA__7878__S _3865_ VGND VGND VPWR VPWR sky130_fd_sc_hd__diode_2
Xinput6 a2[2] VGND VGND VPWR VPWR net6 sky130_fd_sc_hd__buf_4
XTAP_TAPCELL_ROW_65_1108 VGND VPWR sky130_fd_sc_hd__tapvpwrvgnd_1
X_4952_ registers\[12\]\[4\] registers\[13\]\[4\] registers\[14\]\[4\] registers\[15\]\[4\]
+ _1690_ _1692_ VGND VGND VPWR VPWR _1716_ sky130_fd_sc_hd__mux4_1
X_7740_ _3079_ registers\[25\]\[5\] _3793_ VGND VGND VPWR VPWR _3799_ sky130_fd_sc_hd__mux2_1
XFILLER_0_59_543 VGND VGND VPWR VPWR sky130_fd_sc_hd__fill_1
XFILLER_0_52_20 VGND VGND VPWR VPWR sky130_fd_sc_hd__fill_2
XFILLER_0_47_705 VGND VGND VPWR VPWR sky130_fd_sc_hd__decap_3
X_7671_ _3762_ VGND VGND VPWR VPWR _0253_ sky130_fd_sc_hd__clkbuf_1
X_4883_ _1646_ _1649_ _1634_ VGND VGND VPWR VPWR _1650_ sky130_fd_sc_hd__mux2_1
X_6622_ _3187_ VGND VGND VPWR VPWR _0803_ sky130_fd_sc_hd__clkbuf_1
XANTENNA__7907__A _3864_ VGND VGND VPWR VPWR sky130_fd_sc_hd__diode_2
X_9410_ clknet_leaf_4_clk _0507_ VGND VGND VPWR VPWR registers\[6\]\[2\] sky130_fd_sc_hd__dfxtp_1
XFILLER_0_116_136 VGND VGND VPWR VPWR sky130_fd_sc_hd__decap_4
XANTENNA__4265__S1 _1040_ VGND VGND VPWR VPWR sky130_fd_sc_hd__diode_2
XANTENNA__7118__S _3456_ VGND VGND VPWR VPWR sky130_fd_sc_hd__diode_2
X_6553_ registers\[7\]\[11\] _2985_ _3148_ VGND VGND VPWR VPWR _3150_ sky130_fd_sc_hd__mux2_1
XANTENNA__7108__A1 _3451_ VGND VGND VPWR VPWR sky130_fd_sc_hd__diode_2
XFILLER_0_42_421 VGND VGND VPWR VPWR sky130_fd_sc_hd__decap_4
X_9341_ clknet_leaf_108_clk _0438_ VGND VGND VPWR VPWR registers\[2\]\[29\] sky130_fd_sc_hd__dfxtp_1
XFILLER_0_27_484 VGND VGND VPWR VPWR sky130_fd_sc_hd__decap_3
XANTENNA__4331__A _1112_ VGND VGND VPWR VPWR sky130_fd_sc_hd__diode_2
X_5504_ _2101_ _2213_ VGND VGND VPWR VPWR _2240_ sky130_fd_sc_hd__or2_1
X_6484_ net25 VGND VGND VPWR VPWR _3106_ sky130_fd_sc_hd__clkbuf_2
X_9272_ clknet_leaf_86_clk _0369_ VGND VGND VPWR VPWR registers\[27\]\[24\] sky130_fd_sc_hd__dfxtp_1
XFILLER_0_15_668 VGND VGND VPWR VPWR sky130_fd_sc_hd__fill_1
XFILLER_0_30_605 VGND VGND VPWR VPWR sky130_fd_sc_hd__decap_4
X_8223_ _4054_ VGND VGND VPWR VPWR _0513_ sky130_fd_sc_hd__clkbuf_1
XTAP_TAPCELL_ROW_76_1248 VGND VPWR sky130_fd_sc_hd__tapvpwrvgnd_1
XANTENNA__5214__S0 _1820_ VGND VGND VPWR VPWR sky130_fd_sc_hd__diode_2
X_5435_ _2169_ _2170_ _2171_ _2172_ _2031_ _1756_ VGND VGND VPWR VPWR _2173_ sky130_fd_sc_hd__mux4_2
XFILLER_0_2_573 VGND VGND VPWR VPWR sky130_fd_sc_hd__fill_2
X_8154_ registers\[9\]\[8\] _3451_ _4009_ VGND VGND VPWR VPWR _4018_ sky130_fd_sc_hd__mux2_1
XFILLER_0_77_50 VGND VGND VPWR VPWR sky130_fd_sc_hd__decap_3
X_5366_ _2104_ _2107_ _2019_ VGND VGND VPWR VPWR _2108_ sky130_fd_sc_hd__mux2_1
X_4317_ _1112_ VGND VGND VPWR VPWR _1113_ sky130_fd_sc_hd__clkbuf_4
X_7105_ registers\[16\]\[7\] _3449_ _3435_ VGND VGND VPWR VPWR _3450_ sky130_fd_sc_hd__mux2_1
X_8085_ _3981_ VGND VGND VPWR VPWR _0448_ sky130_fd_sc_hd__clkbuf_1
XANTENNA__6258__A _2961_ VGND VGND VPWR VPWR sky130_fd_sc_hd__diode_2
X_5297_ _1754_ _2042_ VGND VGND VPWR VPWR _2043_ sky130_fd_sc_hd__nand2_1
XANTENNA__6095__B2 _2429_ VGND VGND VPWR VPWR sky130_fd_sc_hd__diode_2
X_7036_ _3089_ registers\[15\]\[10\] _3409_ VGND VGND VPWR VPWR _3410_ sky130_fd_sc_hd__mux2_1
X_4248_ _1042_ _1044_ _1047_ _1025_ net8 VGND VGND VPWR VPWR _1048_ sky130_fd_sc_hd__a221oi_2
XANTENNA__6692__S _3225_ VGND VGND VPWR VPWR sky130_fd_sc_hd__diode_2
XANTENNA__7788__S _3815_ VGND VGND VPWR VPWR sky130_fd_sc_hd__diode_2
XFILLER_0_93_82 VGND VGND VPWR VPWR sky130_fd_sc_hd__fill_1
XFILLER_0_69_307 VGND VGND VPWR VPWR sky130_fd_sc_hd__decap_3
XFILLER_0_96_104 VGND VGND VPWR VPWR sky130_fd_sc_hd__fill_2
XTAP_TAPCELL_ROW_2_288 VGND VPWR sky130_fd_sc_hd__tapvpwrvgnd_1
X_8987_ clknet_leaf_102_clk _0084_ VGND VGND VPWR VPWR registers\[18\]\[27\] sky130_fd_sc_hd__dfxtp_1
XTAP_TAPCELL_ROW_87_1388 VGND VPWR sky130_fd_sc_hd__tapvpwrvgnd_1
XANTENNA__7089__A net38 VGND VGND VPWR VPWR sky130_fd_sc_hd__diode_2
X_7938_ _2966_ registers\[28\]\[2\] _3901_ VGND VGND VPWR VPWR _3904_ sky130_fd_sc_hd__mux2_1
XANTENNA__7347__A1 _3462_ VGND VGND VPWR VPWR sky130_fd_sc_hd__diode_2
XANTENNA__8412__S _4153_ VGND VGND VPWR VPWR sky130_fd_sc_hd__diode_2
X_7869_ _3867_ VGND VGND VPWR VPWR _0346_ sky130_fd_sc_hd__clkbuf_1
XFILLER_0_92_365 VGND VGND VPWR VPWR sky130_fd_sc_hd__fill_1
XFILLER_0_92_354 VGND VGND VPWR VPWR sky130_fd_sc_hd__decap_4
XFILLER_0_9_194 VGND VGND VPWR VPWR sky130_fd_sc_hd__fill_2
XANTENNA__4256__S1 _1054_ VGND VGND VPWR VPWR sky130_fd_sc_hd__diode_2
XPHY_EDGE_ROW_14_Right_14 VGND VGND VPWR VPWR sky130_fd_sc_hd__decap_3
XTAP_TAPCELL_ROW_21_530 VGND VPWR sky130_fd_sc_hd__tapvpwrvgnd_1
XANTENNA__5453__S0 _2126_ VGND VGND VPWR VPWR sky130_fd_sc_hd__diode_2
XFILLER_0_107_169 VGND VGND VPWR VPWR sky130_fd_sc_hd__decap_3
XFILLER_0_92_387 VGND VGND VPWR VPWR sky130_fd_sc_hd__fill_2
X_9539_ clknet_leaf_22_clk _0636_ VGND VGND VPWR VPWR registers\[4\]\[3\] sky130_fd_sc_hd__dfxtp_1
XFILLER_0_116_681 VPWR VGND VPWR VGND sky130_ef_sc_hd__decap_12
XANTENNA__5337__A _1768_ VGND VGND VPWR VPWR sky130_fd_sc_hd__diode_2
XFILLER_0_33_443 VGND VGND VPWR VPWR sky130_fd_sc_hd__fill_2
XFILLER_0_115_180 VGND VGND VPWR VPWR sky130_fd_sc_hd__fill_2
XANTENNA__5205__S0 _1742_ VGND VGND VPWR VPWR sky130_fd_sc_hd__diode_2
XANTENNA__6867__S _3310_ VGND VGND VPWR VPWR sky130_fd_sc_hd__diode_2
XFILLER_0_21_649 VGND VGND VPWR VPWR sky130_fd_sc_hd__fill_2
XPHY_EDGE_ROW_23_Right_23 VGND VGND VPWR VPWR sky130_fd_sc_hd__decap_3
XANTENNA__6086__B2 _2034_ VGND VGND VPWR VPWR sky130_fd_sc_hd__diode_2
XANTENNA__6086__A1 _2011_ VGND VGND VPWR VPWR sky130_fd_sc_hd__diode_2
XANTENNA__5800__A net110 VGND VGND VPWR VPWR sky130_fd_sc_hd__diode_2
XTAP_TAPCELL_ROW_29_630 VGND VPWR sky130_fd_sc_hd__tapvpwrvgnd_1
XFILLER_0_88_649 VGND VGND VPWR VPWR sky130_fd_sc_hd__fill_2
XTAP_TAPCELL_ROW_29_641 VGND VPWR sky130_fd_sc_hd__tapvpwrvgnd_1
XFILLER_0_87_159 VGND VGND VPWR VPWR sky130_fd_sc_hd__decap_3
XANTENNA__4416__A _1208_ VGND VGND VPWR VPWR sky130_fd_sc_hd__diode_2
XTAP_TAPCELL_ROW_57_994 VGND VPWR sky130_fd_sc_hd__tapvpwrvgnd_1
XFILLER_0_96_682 VGND VGND VPWR VPWR sky130_fd_sc_hd__fill_2
XANTENNA__4495__S1 _1204_ VGND VGND VPWR VPWR sky130_fd_sc_hd__diode_2
XPHY_EDGE_ROW_32_Right_32 VGND VGND VPWR VPWR sky130_fd_sc_hd__decap_3
XFILLER_0_83_332 VGND VGND VPWR VPWR sky130_fd_sc_hd__fill_2
XANTENNA__7338__A1 _3453_ VGND VGND VPWR VPWR sky130_fd_sc_hd__diode_2
XTAP_TAPCELL_ROW_60_1038 VGND VPWR sky130_fd_sc_hd__tapvpwrvgnd_1
XFILLER_0_44_708 VGND VGND VPWR VPWR sky130_fd_sc_hd__decap_8
XANTENNA__8322__S _4103_ VGND VGND VPWR VPWR sky130_fd_sc_hd__diode_2
XFILLER_0_71_538 VGND VGND VPWR VPWR sky130_fd_sc_hd__fill_2
XANTENNA__4572__A1 _1159_ VGND VGND VPWR VPWR sky130_fd_sc_hd__diode_2
XANTENNA__5247__A _1995_ VGND VGND VPWR VPWR sky130_fd_sc_hd__diode_2
XFILLER_0_3_326 VGND VGND VPWR VPWR sky130_fd_sc_hd__decap_4
XFILLER_0_51_273 VGND VGND VPWR VPWR sky130_fd_sc_hd__fill_1
XFILLER_0_11_104 VGND VGND VPWR VPWR sky130_fd_sc_hd__fill_2
XFILLER_0_12_616 VGND VGND VPWR VPWR sky130_fd_sc_hd__fill_2
XFILLER_0_12_638 VGND VGND VPWR VPWR sky130_fd_sc_hd__decap_4
XFILLER_0_24_498 VGND VGND VPWR VPWR sky130_fd_sc_hd__fill_2
X_5220_ registers\[8\]\[18\] registers\[9\]\[18\] registers\[10\]\[18\] registers\[11\]\[18\]
+ _1968_ _1969_ VGND VGND VPWR VPWR _1970_ sky130_fd_sc_hd__mux4_1
XPHY_EDGE_ROW_41_Right_41 VGND VGND VPWR VPWR sky130_fd_sc_hd__decap_3
XFILLER_0_20_671 VGND VGND VPWR VPWR sky130_fd_sc_hd__fill_2
X_5151_ registers\[12\]\[14\] registers\[13\]\[14\] registers\[14\]\[14\] registers\[15\]\[14\]
+ _1719_ _1720_ VGND VGND VPWR VPWR _1905_ sky130_fd_sc_hd__mux4_1
XFILLER_0_20_682 VGND VGND VPWR VPWR sky130_fd_sc_hd__fill_2
X_5082_ registers\[24\]\[10\] registers\[25\]\[10\] registers\[26\]\[10\] registers\[27\]\[10\]
+ _1757_ _1814_ VGND VGND VPWR VPWR _1840_ sky130_fd_sc_hd__mux4_1
XTAP_TAPCELL_ROW_71_1178 VGND VPWR sky130_fd_sc_hd__tapvpwrvgnd_1
X_8910_ clknet_leaf_53_clk _0007_ VGND VGND VPWR VPWR registers\[16\]\[14\] sky130_fd_sc_hd__dfxtp_1
XFILLER_0_47_75 VGND VGND VPWR VPWR sky130_fd_sc_hd__fill_2
XPHY_EDGE_ROW_16_Left_136 VGND VGND VPWR VPWR sky130_fd_sc_hd__decap_3
XANTENNA__7401__S _3612_ VGND VGND VPWR VPWR sky130_fd_sc_hd__diode_2
XFILLER_0_2_11 VPWR VGND VPWR VGND sky130_ef_sc_hd__decap_12
XFILLER_0_79_638 VGND VGND VPWR VPWR sky130_fd_sc_hd__fill_2
X_8841_ clknet_leaf_19_clk _0962_ VGND VGND VPWR VPWR registers\[14\]\[9\] sky130_fd_sc_hd__dfxtp_1
X_8772_ clknet_leaf_33_clk _0893_ VGND VGND VPWR VPWR registers\[12\]\[4\] sky130_fd_sc_hd__dfxtp_1
XFILLER_0_78_137 VGND VGND VPWR VPWR sky130_fd_sc_hd__decap_3
XANTENNA__4326__A _1034_ VGND VGND VPWR VPWR sky130_fd_sc_hd__diode_2
XPHY_EDGE_ROW_50_Right_50 VGND VGND VPWR VPWR sky130_fd_sc_hd__decap_3
XFILLER_0_93_118 VGND VGND VPWR VPWR sky130_fd_sc_hd__fill_2
XANTENNA__4486__S1 _1168_ VGND VGND VPWR VPWR sky130_fd_sc_hd__diode_2
X_5984_ _2699_ _2700_ _2703_ VGND VGND VPWR VPWR _2704_ sky130_fd_sc_hd__and3_1
X_7723_ _3789_ VGND VGND VPWR VPWR _0278_ sky130_fd_sc_hd__clkbuf_1
X_4935_ _1698_ _1699_ _1682_ VGND VGND VPWR VPWR _1700_ sky130_fd_sc_hd__mux2_1
XFILLER_0_74_365 VGND VGND VPWR VPWR sky130_fd_sc_hd__fill_2
X_7654_ _3752_ VGND VGND VPWR VPWR _0246_ sky130_fd_sc_hd__clkbuf_1
XFILLER_0_7_632 VGND VGND VPWR VPWR sky130_fd_sc_hd__fill_2
XPHY_EDGE_ROW_25_Left_145 VGND VGND VPWR VPWR sky130_fd_sc_hd__decap_3
X_4866_ net4 VGND VGND VPWR VPWR _1634_ sky130_fd_sc_hd__buf_4
XFILLER_0_62_527 VGND VGND VPWR VPWR sky130_fd_sc_hd__fill_2
X_6605_ _3178_ VGND VGND VPWR VPWR _0795_ sky130_fd_sc_hd__clkbuf_1
XANTENNA__5435__S0 _2031_ VGND VGND VPWR VPWR sky130_fd_sc_hd__diode_2
X_7585_ _3129_ registers\[22\]\[29\] _3706_ VGND VGND VPWR VPWR _3716_ sky130_fd_sc_hd__mux2_1
X_4797_ _1438_ _1560_ _1564_ _1568_ VGND VGND VPWR VPWR _1569_ sky130_fd_sc_hd__o2bb2a_2
XFILLER_0_34_229 VGND VGND VPWR VPWR sky130_fd_sc_hd__decap_4
X_9324_ clknet_leaf_44_clk _0421_ VGND VGND VPWR VPWR registers\[2\]\[12\] sky130_fd_sc_hd__dfxtp_1
X_6536_ registers\[7\]\[3\] _2968_ _3137_ VGND VGND VPWR VPWR _3141_ sky130_fd_sc_hd__mux2_1
XFILLER_0_70_582 VGND VGND VPWR VPWR sky130_fd_sc_hd__fill_2
XFILLER_0_6_197 VGND VGND VPWR VPWR sky130_fd_sc_hd__fill_2
XANTENNA__4996__A _1757_ VGND VGND VPWR VPWR sky130_fd_sc_hd__diode_2
XFILLER_0_113_673 VPWR VGND VPWR VGND sky130_ef_sc_hd__decap_12
XFILLER_0_88_60 VGND VGND VPWR VPWR sky130_fd_sc_hd__fill_2
X_6467_ _3094_ registers\[29\]\[12\] _3090_ VGND VGND VPWR VPWR _3095_ sky130_fd_sc_hd__mux2_1
XANTENNA__6687__S _3214_ VGND VGND VPWR VPWR sky130_fd_sc_hd__diode_2
X_9255_ clknet_leaf_23_clk _0352_ VGND VGND VPWR VPWR registers\[27\]\[7\] sky130_fd_sc_hd__dfxtp_1
Xoutput140 net140 VGND VGND VPWR VPWR rd2[5] sky130_fd_sc_hd__buf_1
X_6398_ registers\[3\]\[19\] _3001_ _3041_ VGND VGND VPWR VPWR _3051_ sky130_fd_sc_hd__mux2_1
X_5418_ registers\[24\]\[29\] registers\[25\]\[29\] registers\[26\]\[29\] registers\[27\]\[29\]
+ _2097_ _2109_ VGND VGND VPWR VPWR _2157_ sky130_fd_sc_hd__mux4_1
X_9186_ clknet_leaf_0_clk _0283_ VGND VGND VPWR VPWR registers\[25\]\[2\] sky130_fd_sc_hd__dfxtp_1
XFILLER_0_30_457 VGND VGND VPWR VPWR sky130_fd_sc_hd__fill_2
X_8206_ registers\[6\]\[0\] _3433_ _4045_ VGND VGND VPWR VPWR _4046_ sky130_fd_sc_hd__mux2_1
X_8137_ _4008_ VGND VGND VPWR VPWR _4009_ sky130_fd_sc_hd__clkbuf_8
XTAP_TAPCELL_ROW_7_347 VGND VPWR sky130_fd_sc_hd__tapvpwrvgnd_1
X_5349_ registers\[12\]\[25\] registers\[13\]\[25\] registers\[14\]\[25\] registers\[15\]\[25\]
+ _2027_ _2028_ VGND VGND VPWR VPWR _2092_ sky130_fd_sc_hd__mux4_1
XFILLER_0_11_671 VGND VGND VPWR VPWR sky130_fd_sc_hd__fill_1
XFILLER_0_11_682 VGND VGND VPWR VPWR sky130_fd_sc_hd__fill_2
XPHY_EDGE_ROW_34_Left_154 VGND VGND VPWR VPWR sky130_fd_sc_hd__decap_3
XANTENNA__5815__B2 _2270_ VGND VGND VPWR VPWR sky130_fd_sc_hd__diode_2
XTAP_TAPCELL_ROW_89_1417 VGND VPWR sky130_fd_sc_hd__tapvpwrvgnd_1
X_8068_ _3066_ _3359_ VGND VGND VPWR VPWR _3972_ sky130_fd_sc_hd__nand2_4
XANTENNA__4935__S _1682_ VGND VGND VPWR VPWR sky130_fd_sc_hd__diode_2
XANTENNA__7017__A0 _3071_ VGND VGND VPWR VPWR sky130_fd_sc_hd__diode_2
X_7019_ _3073_ registers\[15\]\[2\] _3398_ VGND VGND VPWR VPWR _3401_ sky130_fd_sc_hd__mux2_1
XTAP_TAPCELL_ROW_26_600 VGND VPWR sky130_fd_sc_hd__tapvpwrvgnd_1
XANTENNA__4477__S1 _1203_ VGND VGND VPWR VPWR sky130_fd_sc_hd__diode_2
XTAP_TAPCELL_ROW_54_964 VGND VPWR sky130_fd_sc_hd__tapvpwrvgnd_1
XFILLER_0_38_502 VGND VGND VPWR VPWR sky130_fd_sc_hd__fill_2
XFILLER_0_78_693 VGND VGND VPWR VPWR sky130_fd_sc_hd__decap_6
XPHY_EDGE_ROW_43_Left_163 VGND VGND VPWR VPWR sky130_fd_sc_hd__decap_3
Xclkbuf_leaf_50_clk clknet_4_15_0_clk VGND VGND VPWR VPWR clknet_leaf_50_clk sky130_fd_sc_hd__clkbuf_8
XFILLER_0_65_343 VGND VGND VPWR VPWR sky130_fd_sc_hd__fill_1
XFILLER_0_53_505 VGND VGND VPWR VPWR sky130_fd_sc_hd__fill_2
XANTENNA__8142__S _4009_ VGND VGND VPWR VPWR sky130_fd_sc_hd__diode_2
XANTENNA__4229__S1 _1027_ VGND VGND VPWR VPWR sky130_fd_sc_hd__diode_2
XANTENNA__5426__S0 _2126_ VGND VGND VPWR VPWR sky130_fd_sc_hd__diode_2
XFILLER_0_25_229 VGND VGND VPWR VPWR sky130_fd_sc_hd__fill_2
XFILLER_0_92_195 VGND VGND VPWR VPWR sky130_fd_sc_hd__fill_1
XFILLER_0_18_281 VGND VGND VPWR VPWR sky130_fd_sc_hd__decap_3
XFILLER_0_0_318 VGND VGND VPWR VPWR sky130_fd_sc_hd__fill_2
XTAP_TAPCELL_ROW_111_1702 VGND VPWR sky130_fd_sc_hd__tapvpwrvgnd_1
XFILLER_0_103_172 VGND VGND VPWR VPWR sky130_fd_sc_hd__fill_2
XPHY_EDGE_ROW_52_Left_172 VGND VGND VPWR VPWR sky130_fd_sc_hd__decap_3
XANTENNA__7221__S _3514_ VGND VGND VPWR VPWR sky130_fd_sc_hd__diode_2
XANTENNA__7008__A0 _3131_ VGND VGND VPWR VPWR sky130_fd_sc_hd__diode_2
XFILLER_0_17_34 VGND VGND VPWR VPWR sky130_fd_sc_hd__fill_2
XTAP_TAPCELL_ROW_109_1675 VGND VPWR sky130_fd_sc_hd__tapvpwrvgnd_1
XFILLER_0_69_671 VGND VGND VPWR VPWR sky130_fd_sc_hd__fill_1
XPHY_EDGE_ROW_61_Left_181 VGND VGND VPWR VPWR sky130_fd_sc_hd__decap_3
XFILLER_0_33_33 VGND VGND VPWR VPWR sky130_fd_sc_hd__fill_2
XFILLER_0_84_641 VGND VGND VPWR VPWR sky130_fd_sc_hd__decap_3
XFILLER_0_68_181 VGND VGND VPWR VPWR sky130_fd_sc_hd__decap_8
XFILLER_0_33_77 VGND VGND VPWR VPWR sky130_fd_sc_hd__decap_4
Xclkbuf_leaf_41_clk clknet_4_7_0_clk VGND VGND VPWR VPWR clknet_leaf_41_clk sky130_fd_sc_hd__clkbuf_8
XFILLER_0_56_365 VGND VGND VPWR VPWR sky130_fd_sc_hd__fill_2
XANTENNA__8052__S _3959_ VGND VGND VPWR VPWR sky130_fd_sc_hd__diode_2
X_4720_ registers\[8\]\[24\] registers\[9\]\[24\] registers\[10\]\[24\] registers\[11\]\[24\]
+ _1382_ _1383_ VGND VGND VPWR VPWR _1496_ sky130_fd_sc_hd__mux4_1
XFILLER_0_29_557 VGND VGND VPWR VPWR sky130_fd_sc_hd__decap_3
XFILLER_0_33_88 VGND VGND VPWR VPWR sky130_fd_sc_hd__fill_2
XFILLER_0_83_162 VGND VGND VPWR VPWR sky130_fd_sc_hd__decap_4
XFILLER_0_44_549 VGND VGND VPWR VPWR sky130_fd_sc_hd__fill_2
XANTENNA__5417__S0 _2097_ VGND VGND VPWR VPWR sky130_fd_sc_hd__diode_2
XFILLER_0_16_229 VGND VGND VPWR VPWR sky130_fd_sc_hd__decap_4
X_4651_ _1429_ _1430_ _1386_ VGND VGND VPWR VPWR _1431_ sky130_fd_sc_hd__mux2_1
XTAP_TAPCELL_ROW_32_669 VGND VPWR sky130_fd_sc_hd__tapvpwrvgnd_1
Xinput20 wd3[13] VGND VGND VPWR VPWR net20 sky130_fd_sc_hd__buf_2
XANTENNA__7891__S _3876_ VGND VGND VPWR VPWR sky130_fd_sc_hd__diode_2
Xinput31 wd3[23] VGND VGND VPWR VPWR net31 sky130_fd_sc_hd__clkbuf_4
XFILLER_0_114_437 VGND VGND VPWR VPWR sky130_fd_sc_hd__fill_2
Xinput42 wd3[4] VGND VGND VPWR VPWR net42 sky130_fd_sc_hd__buf_1
X_4582_ _1148_ _1364_ VGND VGND VPWR VPWR _1365_ sky130_fd_sc_hd__or2_1
XFILLER_0_52_571 VGND VGND VPWR VPWR sky130_fd_sc_hd__fill_2
X_7370_ registers\[1\]\[24\] _3485_ _3597_ VGND VGND VPWR VPWR _3602_ sky130_fd_sc_hd__mux2_1
XANTENNA__4640__S1 _1419_ VGND VGND VPWR VPWR sky130_fd_sc_hd__diode_2
XFILLER_0_3_167 VGND VGND VPWR VPWR sky130_fd_sc_hd__fill_1
XFILLER_0_3_145 VGND VGND VPWR VPWR sky130_fd_sc_hd__fill_2
X_6321_ registers\[19\]\[20\] _3003_ _3004_ VGND VGND VPWR VPWR _3005_ sky130_fd_sc_hd__mux2_1
X_6252_ _2952_ _2766_ _2894_ _2438_ _2956_ VGND VGND VPWR VPWR _2957_ sky130_fd_sc_hd__o221a_1
XANTENNA__5705__A net124 VGND VGND VPWR VPWR sky130_fd_sc_hd__diode_2
XTAP_TAPCELL_ROW_73_1207 VGND VPWR sky130_fd_sc_hd__tapvpwrvgnd_1
XPHY_EDGE_ROW_70_Left_190 VGND VGND VPWR VPWR sky130_fd_sc_hd__decap_3
X_9040_ clknet_leaf_61_clk _0137_ VGND VGND VPWR VPWR registers\[20\]\[16\] sky130_fd_sc_hd__dfxtp_1
XFILLER_0_12_468 VGND VGND VPWR VPWR sky130_fd_sc_hd__fill_2
XFILLER_0_110_676 VGND VGND VPWR VPWR sky130_fd_sc_hd__fill_1
XFILLER_0_110_654 VGND VGND VPWR VPWR sky130_fd_sc_hd__decap_3
X_6183_ _2441_ _2587_ _2891_ _2276_ VGND VGND VPWR VPWR _2892_ sky130_fd_sc_hd__o211a_1
X_5203_ _1754_ _1953_ VGND VGND VPWR VPWR _1954_ sky130_fd_sc_hd__nand2_1
X_5134_ _1887_ _1888_ _1695_ VGND VGND VPWR VPWR _1889_ sky130_fd_sc_hd__mux2_1
XFILLER_0_58_85 VGND VGND VPWR VPWR sky130_fd_sc_hd__fill_2
XTAP_TAPCELL_ROW_4_306 VGND VPWR sky130_fd_sc_hd__tapvpwrvgnd_1
XTAP_TAPCELL_ROW_4_317 VGND VPWR sky130_fd_sc_hd__tapvpwrvgnd_1
XANTENNA__8227__S _4056_ VGND VGND VPWR VPWR sky130_fd_sc_hd__diode_2
X_5065_ registers\[16\]\[9\] registers\[17\]\[9\] registers\[18\]\[9\] registers\[19\]\[9\]
+ _1820_ _1821_ VGND VGND VPWR VPWR _1824_ sky130_fd_sc_hd__mux4_1
XFILLER_0_79_413 VGND VGND VPWR VPWR sky130_fd_sc_hd__fill_1
XANTENNA__6255__B net11 VGND VGND VPWR VPWR sky130_fd_sc_hd__diode_2
X_8824_ clknet_leaf_87_clk _0945_ VGND VGND VPWR VPWR registers\[13\]\[24\] sky130_fd_sc_hd__dfxtp_1
XTAP_TAPCELL_ROW_84_1347 VGND VPWR sky130_fd_sc_hd__tapvpwrvgnd_1
XFILLER_0_79_479 VGND VGND VPWR VPWR sky130_fd_sc_hd__fill_2
X_5967_ _2264_ _2362_ VGND VGND VPWR VPWR _2687_ sky130_fd_sc_hd__nor2_1
XFILLER_0_94_438 VGND VGND VPWR VPWR sky130_fd_sc_hd__fill_1
X_8755_ clknet_leaf_15_clk _0876_ VGND VGND VPWR VPWR registers\[11\]\[19\] sky130_fd_sc_hd__dfxtp_1
XTAP_TAPCELL_ROW_51_923 VGND VPWR sky130_fd_sc_hd__tapvpwrvgnd_1
XFILLER_0_47_332 VGND VGND VPWR VPWR sky130_fd_sc_hd__fill_2
Xclkbuf_leaf_32_clk clknet_4_5_0_clk VGND VGND VPWR VPWR clknet_leaf_32_clk sky130_fd_sc_hd__clkbuf_8
X_8686_ clknet_leaf_52_clk _0807_ VGND VGND VPWR VPWR registers\[0\]\[14\] sky130_fd_sc_hd__dfxtp_1
XFILLER_0_90_83 VGND VGND VPWR VPWR sky130_fd_sc_hd__fill_1
X_4918_ _1680_ _1681_ _1682_ VGND VGND VPWR VPWR _1683_ sky130_fd_sc_hd__mux2_1
XFILLER_0_47_343 VGND VGND VPWR VPWR sky130_fd_sc_hd__decap_3
X_7706_ registers\[24\]\[21\] _3479_ _3779_ VGND VGND VPWR VPWR _3781_ sky130_fd_sc_hd__mux2_1
X_5898_ _2203_ _2208_ _2483_ _2514_ _2484_ VGND VGND VPWR VPWR _2622_ sky130_fd_sc_hd__o41a_1
XFILLER_0_62_302 VGND VGND VPWR VPWR sky130_fd_sc_hd__decap_3
XANTENNA__5408__S0 _2072_ VGND VGND VPWR VPWR sky130_fd_sc_hd__diode_2
X_7637_ _3113_ registers\[23\]\[21\] _3742_ VGND VGND VPWR VPWR _3744_ sky130_fd_sc_hd__mux2_1
XFILLER_0_117_286 VGND VGND VPWR VPWR sky130_fd_sc_hd__fill_2
XFILLER_0_74_195 VGND VGND VPWR VPWR sky130_fd_sc_hd__fill_1
XFILLER_0_62_357 VGND VGND VPWR VPWR sky130_fd_sc_hd__fill_1
XANTENNA__7722__A1 _3495_ VGND VGND VPWR VPWR sky130_fd_sc_hd__diode_2
X_4849_ net1 VGND VGND VPWR VPWR _1617_ sky130_fd_sc_hd__buf_4
XFILLER_0_90_688 VPWR VGND VPWR VGND sky130_ef_sc_hd__decap_12
XFILLER_0_15_251 VGND VGND VPWR VPWR sky130_fd_sc_hd__fill_2
X_7568_ _3707_ VGND VGND VPWR VPWR _0205_ sky130_fd_sc_hd__clkbuf_1
X_6519_ _3129_ registers\[29\]\[29\] _3111_ VGND VGND VPWR VPWR _3130_ sky130_fd_sc_hd__mux2_1
X_9307_ clknet_leaf_90_clk _0404_ VGND VGND VPWR VPWR registers\[28\]\[27\] sky130_fd_sc_hd__dfxtp_1
X_7499_ _3110_ registers\[21\]\[20\] _3670_ VGND VGND VPWR VPWR _3671_ sky130_fd_sc_hd__mux2_1
XFILLER_0_101_621 VGND VGND VPWR VPWR sky130_fd_sc_hd__fill_1
XANTENNA__7306__S _3561_ VGND VGND VPWR VPWR sky130_fd_sc_hd__diode_2
X_9238_ clknet_leaf_94_clk _0335_ VGND VGND VPWR VPWR registers\[26\]\[22\] sky130_fd_sc_hd__dfxtp_1
XTAP_TAPCELL_ROW_95_1498 VGND VPWR sky130_fd_sc_hd__tapvpwrvgnd_1
XANTENNA__4395__S0 _1125_ VGND VGND VPWR VPWR sky130_fd_sc_hd__diode_2
X_9169_ clknet_leaf_55_clk _0266_ VGND VGND VPWR VPWR registers\[24\]\[17\] sky130_fd_sc_hd__dfxtp_1
Xclkbuf_leaf_99_clk clknet_4_3_0_clk VGND VGND VPWR VPWR clknet_leaf_99_clk sky130_fd_sc_hd__clkbuf_8
XFILLER_0_100_197 VGND VGND VPWR VPWR sky130_fd_sc_hd__fill_2
XFILLER_0_97_210 VGND VGND VPWR VPWR sky130_fd_sc_hd__fill_2
XANTENNA__7976__S _3923_ VGND VGND VPWR VPWR sky130_fd_sc_hd__diode_2
XFILLER_0_85_449 VGND VGND VPWR VPWR sky130_fd_sc_hd__decap_3
XFILLER_0_85_438 VGND VGND VPWR VPWR sky130_fd_sc_hd__fill_2
XFILLER_0_78_490 VGND VGND VPWR VPWR sky130_fd_sc_hd__fill_2
Xclkbuf_leaf_23_clk clknet_4_4_0_clk VGND VGND VPWR VPWR clknet_leaf_23_clk sky130_fd_sc_hd__clkbuf_8
XANTENNA__4775__B2 _1389_ VGND VGND VPWR VPWR sky130_fd_sc_hd__diode_2
XFILLER_0_26_516 VGND VGND VPWR VPWR sky130_fd_sc_hd__fill_2
XANTENNA__4870__S1 _1618_ VGND VGND VPWR VPWR sky130_fd_sc_hd__diode_2
XFILLER_0_108_275 VGND VGND VPWR VPWR sky130_fd_sc_hd__fill_2
XFILLER_0_108_253 VGND VGND VPWR VPWR sky130_fd_sc_hd__fill_2
XFILLER_0_81_644 VGND VGND VPWR VPWR sky130_fd_sc_hd__decap_4
XFILLER_0_80_132 VGND VGND VPWR VPWR sky130_fd_sc_hd__decap_8
XFILLER_0_110_26 VGND VGND VPWR VPWR sky130_fd_sc_hd__fill_2
XFILLER_0_80_176 VGND VGND VPWR VPWR sky130_fd_sc_hd__fill_2
XFILLER_0_0_159 VGND VGND VPWR VPWR sky130_fd_sc_hd__decap_3
XFILLER_0_0_137 VGND VGND VPWR VPWR sky130_fd_sc_hd__decap_3
XANTENNA__4386__S0 _1136_ VGND VGND VPWR VPWR sky130_fd_sc_hd__diode_2
XFILLER_0_119_57 VPWR VGND VPWR VGND sky130_ef_sc_hd__decap_12
XFILLER_0_28_77 VGND VGND VPWR VPWR sky130_fd_sc_hd__decap_4
XANTENNA__6356__A net13 VGND VGND VPWR VPWR sky130_fd_sc_hd__diode_2
XANTENNA__4463__B1 _1142_ VGND VGND VPWR VPWR sky130_fd_sc_hd__diode_2
XTAP_TAPCELL_ROW_37_739 VGND VPWR sky130_fd_sc_hd__tapvpwrvgnd_1
XANTENNA__5660__C1 _2394_ VGND VGND VPWR VPWR sky130_fd_sc_hd__diode_2
XFILLER_0_76_416 VGND VGND VPWR VPWR sky130_fd_sc_hd__fill_1
XANTENNA_clkbuf_leaf_62_clk_A clknet_4_14_0_clk VGND VGND VPWR VPWR sky130_fd_sc_hd__diode_2
X_6870_ _3320_ VGND VGND VPWR VPWR _0918_ sky130_fd_sc_hd__clkbuf_1
X_5821_ _1819_ _2548_ VGND VGND VPWR VPWR _2549_ sky130_fd_sc_hd__nor2_1
XFILLER_0_57_630 VGND VGND VPWR VPWR sky130_fd_sc_hd__fill_2
XFILLER_0_119_529 VGND VGND VPWR VPWR sky130_fd_sc_hd__decap_3
XFILLER_0_91_408 VGND VGND VPWR VPWR sky130_fd_sc_hd__fill_2
X_5752_ _2482_ VGND VGND VPWR VPWR _2483_ sky130_fd_sc_hd__buf_2
XFILLER_0_60_20 VGND VGND VPWR VPWR sky130_fd_sc_hd__decap_3
XANTENNA__6091__A net95 VGND VGND VPWR VPWR sky130_fd_sc_hd__diode_2
X_8540_ registers\[4\]\[30\] net39 _4188_ VGND VGND VPWR VPWR _4222_ sky130_fd_sc_hd__mux2_1
XANTENNA__4604__A _1362_ VGND VGND VPWR VPWR sky130_fd_sc_hd__diode_2
XTAP_TAPCELL_ROW_17_474 VGND VPWR sky130_fd_sc_hd__tapvpwrvgnd_1
XFILLER_0_17_505 VGND VGND VPWR VPWR sky130_fd_sc_hd__fill_2
XTAP_TAPCELL_ROW_17_485 VGND VPWR sky130_fd_sc_hd__tapvpwrvgnd_1
Xclkbuf_leaf_14_clk clknet_4_6_0_clk VGND VGND VPWR VPWR clknet_leaf_14_clk sky130_fd_sc_hd__clkbuf_8
XFILLER_0_44_313 VGND VGND VPWR VPWR sky130_fd_sc_hd__decap_4
XFILLER_0_44_302 VGND VGND VPWR VPWR sky130_fd_sc_hd__decap_4
X_4703_ registers\[4\]\[23\] registers\[5\]\[23\] registers\[6\]\[23\] registers\[7\]\[23\]
+ _1415_ _1416_ VGND VGND VPWR VPWR _1480_ sky130_fd_sc_hd__mux4_1
X_5683_ _2267_ _2324_ VGND VGND VPWR VPWR _2417_ sky130_fd_sc_hd__nand2_1
XFILLER_0_71_110 VGND VGND VPWR VPWR sky130_fd_sc_hd__fill_2
X_8471_ _4185_ VGND VGND VPWR VPWR _0630_ sky130_fd_sc_hd__clkbuf_1
XANTENNA_clkbuf_leaf_77_clk_A clknet_4_10_0_clk VGND VGND VPWR VPWR sky130_fd_sc_hd__diode_2
XANTENNA__7704__A1 _3476_ VGND VGND VPWR VPWR sky130_fd_sc_hd__diode_2
XANTENNA__5715__B1 _1070_ VGND VGND VPWR VPWR sky130_fd_sc_hd__diode_2
XFILLER_0_72_688 VGND VGND VPWR VPWR sky130_fd_sc_hd__fill_1
XFILLER_0_71_154 VGND VGND VPWR VPWR sky130_fd_sc_hd__decap_4
X_7422_ registers\[20\]\[16\] _3468_ _3623_ VGND VGND VPWR VPWR _3630_ sky130_fd_sc_hd__mux2_1
X_4634_ _1414_ VGND VGND VPWR VPWR net123 sky130_fd_sc_hd__inv_2
XANTENNA__5191__A1 _1741_ VGND VGND VPWR VPWR sky130_fd_sc_hd__diode_2
X_4565_ registers\[12\]\[16\] registers\[13\]\[16\] registers\[14\]\[16\] registers\[15\]\[16\]
+ _1347_ _1348_ VGND VGND VPWR VPWR _1349_ sky130_fd_sc_hd__mux4_1
X_7353_ registers\[1\]\[16\] _3468_ _3586_ VGND VGND VPWR VPWR _3593_ sky130_fd_sc_hd__mux2_1
XFILLER_0_8_65 VGND VGND VPWR VPWR sky130_fd_sc_hd__decap_3
X_6304_ net22 VGND VGND VPWR VPWR _2993_ sky130_fd_sc_hd__buf_2
XFILLER_0_12_243 VGND VGND VPWR VPWR sky130_fd_sc_hd__decap_3
XFILLER_0_110_451 VGND VGND VPWR VPWR sky130_fd_sc_hd__fill_1
X_4496_ _1282_ _1283_ _1131_ VGND VGND VPWR VPWR _1284_ sky130_fd_sc_hd__mux2_1
X_7284_ _3556_ VGND VGND VPWR VPWR _0072_ sky130_fd_sc_hd__clkbuf_1
XPHY_EDGE_ROW_4_Right_4 VGND VGND VPWR VPWR sky130_fd_sc_hd__decap_3
X_9023_ clknet_leaf_101_clk _0120_ VGND VGND VPWR VPWR registers\[1\]\[31\] sky130_fd_sc_hd__dfxtp_1
X_6235_ _2182_ _2939_ VGND VGND VPWR VPWR _2941_ sky130_fd_sc_hd__nor2_1
XFILLER_0_85_61 VGND VGND VPWR VPWR sky130_fd_sc_hd__fill_2
XANTENNA_clkbuf_leaf_15_clk_A clknet_4_6_0_clk VGND VGND VPWR VPWR sky130_fd_sc_hd__diode_2
X_6166_ _2101_ _2858_ _2875_ VGND VGND VPWR VPWR _2876_ sky130_fd_sc_hd__a21oi_1
X_6097_ _2786_ _2809_ _2307_ VGND VGND VPWR VPWR _2810_ sky130_fd_sc_hd__mux2_1
XANTENNA__4485__S _1117_ VGND VGND VPWR VPWR sky130_fd_sc_hd__diode_2
X_5117_ _1869_ _1872_ _1714_ VGND VGND VPWR VPWR _1873_ sky130_fd_sc_hd__mux2_1
X_5048_ _1752_ _1807_ VGND VGND VPWR VPWR _1808_ sky130_fd_sc_hd__or2_1
XANTENNA__8196__A1 _3493_ VGND VGND VPWR VPWR sky130_fd_sc_hd__diode_2
XFILLER_0_94_235 VGND VGND VPWR VPWR sky130_fd_sc_hd__decap_4
X_8807_ clknet_leaf_25_clk _0928_ VGND VGND VPWR VPWR registers\[13\]\[7\] sky130_fd_sc_hd__dfxtp_1
XFILLER_0_67_449 VGND VGND VPWR VPWR sky130_fd_sc_hd__fill_2
XFILLER_0_48_630 VGND VGND VPWR VPWR sky130_fd_sc_hd__fill_1
XANTENNA__4301__S0 _1026_ VGND VGND VPWR VPWR sky130_fd_sc_hd__diode_2
X_8738_ clknet_leaf_5_clk _0859_ VGND VGND VPWR VPWR registers\[11\]\[2\] sky130_fd_sc_hd__dfxtp_1
X_6999_ _3389_ VGND VGND VPWR VPWR _0978_ sky130_fd_sc_hd__clkbuf_1
Xclkbuf_4_8_0_clk clknet_0_clk VGND VGND VPWR VPWR clknet_4_8_0_clk sky130_fd_sc_hd__clkbuf_8
XFILLER_0_48_685 VPWR VGND VPWR VGND sky130_ef_sc_hd__decap_12
XFILLER_0_47_151 VGND VGND VPWR VPWR sky130_fd_sc_hd__decap_4
XANTENNA__4852__S1 _1618_ VGND VGND VPWR VPWR sky130_fd_sc_hd__diode_2
XFILLER_0_35_313 VGND VGND VPWR VPWR sky130_fd_sc_hd__fill_1
XFILLER_0_90_441 VGND VGND VPWR VPWR sky130_fd_sc_hd__decap_3
XANTENNA__4233__B _1032_ VGND VGND VPWR VPWR sky130_fd_sc_hd__diode_2
X_8669_ clknet_leaf_108_clk _0790_ VGND VGND VPWR VPWR registers\[7\]\[29\] sky130_fd_sc_hd__dfxtp_1
XANTENNA__8420__S _4153_ VGND VGND VPWR VPWR sky130_fd_sc_hd__diode_2
XTAP_TAPCELL_ROW_97_1516 VGND VPWR sky130_fd_sc_hd__tapvpwrvgnd_1
XFILLER_0_7_281 VGND VGND VPWR VPWR sky130_fd_sc_hd__fill_2
XFILLER_0_16_582 VGND VGND VPWR VPWR sky130_fd_sc_hd__decap_4
XFILLER_0_16_593 VGND VGND VPWR VPWR sky130_fd_sc_hd__decap_3
XANTENNA__7036__S _3409_ VGND VGND VPWR VPWR sky130_fd_sc_hd__diode_2
XANTENNA__7459__A0 _3071_ VGND VGND VPWR VPWR sky130_fd_sc_hd__diode_2
XFILLER_0_101_440 VGND VGND VPWR VPWR sky130_fd_sc_hd__fill_2
XANTENNA__4368__S0 _1160_ VGND VGND VPWR VPWR sky130_fd_sc_hd__diode_2
XFILLER_0_101_473 VGND VGND VPWR VPWR sky130_fd_sc_hd__fill_2
XANTENNA__5485__A2 _2216_ VGND VGND VPWR VPWR sky130_fd_sc_hd__diode_2
XANTENNA_input31_A wd3[23] VGND VGND VPWR VPWR sky130_fd_sc_hd__diode_2
XTAP_TAPCELL_ROW_106_1634 VGND VPWR sky130_fd_sc_hd__tapvpwrvgnd_1
XANTENNA__4540__S0 _1323_ VGND VGND VPWR VPWR sky130_fd_sc_hd__diode_2
XFILLER_0_39_630 VGND VGND VPWR VPWR sky130_fd_sc_hd__fill_1
XANTENNA__5096__S1 _1765_ VGND VGND VPWR VPWR sky130_fd_sc_hd__diode_2
XFILLER_0_39_641 VGND VGND VPWR VPWR sky130_fd_sc_hd__fill_2
XFILLER_0_109_540 VGND VGND VPWR VPWR sky130_fd_sc_hd__fill_1
XTAP_TAPCELL_ROW_14_444 VGND VPWR sky130_fd_sc_hd__tapvpwrvgnd_1
XFILLER_0_53_110 VGND VGND VPWR VPWR sky130_fd_sc_hd__fill_2
XANTENNA__4843__S1 _1428_ VGND VGND VPWR VPWR sky130_fd_sc_hd__diode_2
XFILLER_0_54_699 VGND VGND VPWR VPWR sky130_fd_sc_hd__fill_1
XFILLER_0_5_229 VGND VGND VPWR VPWR sky130_fd_sc_hd__fill_2
XANTENNA__8330__S _4103_ VGND VGND VPWR VPWR sky130_fd_sc_hd__diode_2
XTAP_TAPCELL_ROW_117_1774 VGND VPWR sky130_fd_sc_hd__tapvpwrvgnd_1
X_4350_ _1145_ VGND VGND VPWR VPWR net139 sky130_fd_sc_hd__inv_2
XFILLER_0_1_435 VGND VGND VPWR VPWR sky130_fd_sc_hd__fill_2
XTAP_TAPCELL_ROW_117_1785 VGND VPWR sky130_fd_sc_hd__tapvpwrvgnd_1
XFILLER_0_111_259 VGND VGND VPWR VPWR sky130_fd_sc_hd__decap_3
XFILLER_0_39_32 VGND VGND VPWR VPWR sky130_fd_sc_hd__fill_1
XANTENNA__6785__S _3272_ VGND VGND VPWR VPWR sky130_fd_sc_hd__diode_2
X_4281_ _1077_ _1078_ _1030_ VGND VGND VPWR VPWR _1079_ sky130_fd_sc_hd__mux2_1
X_6020_ _2362_ _2415_ VGND VGND VPWR VPWR _2738_ sky130_fd_sc_hd__nor2_1
XANTENNA__5020__S1 _1691_ VGND VGND VPWR VPWR sky130_fd_sc_hd__diode_2
XANTENNA__6673__A1 _2964_ VGND VGND VPWR VPWR sky130_fd_sc_hd__diode_2
Xclkbuf_leaf_3_clk clknet_4_1_0_clk VGND VGND VPWR VPWR clknet_leaf_3_clk sky130_fd_sc_hd__clkbuf_8
XFILLER_0_55_53 VGND VGND VPWR VPWR sky130_fd_sc_hd__decap_3
X_7971_ _2999_ registers\[28\]\[18\] _3912_ VGND VGND VPWR VPWR _3921_ sky130_fd_sc_hd__mux2_1
XANTENNA__8505__S _4200_ VGND VGND VPWR VPWR sky130_fd_sc_hd__diode_2
XTAP_TAPCELL_ROW_68_1139 VGND VPWR sky130_fd_sc_hd__tapvpwrvgnd_1
X_6922_ _3348_ VGND VGND VPWR VPWR _0942_ sky130_fd_sc_hd__clkbuf_1
XFILLER_0_89_585 VPWR VGND VPWR VGND sky130_ef_sc_hd__decap_12
XTAP_TAPCELL_ROW_81_1306 VGND VPWR sky130_fd_sc_hd__tapvpwrvgnd_1
XFILLER_0_49_449 VGND VGND VPWR VPWR sky130_fd_sc_hd__fill_2
X_6853_ registers\[12\]\[21\] _3006_ _3310_ VGND VGND VPWR VPWR _3312_ sky130_fd_sc_hd__mux2_1
XTAP_TAPCELL_ROW_81_1317 VGND VPWR sky130_fd_sc_hd__tapvpwrvgnd_1
X_5804_ _2526_ _2532_ _2328_ VGND VGND VPWR VPWR _2533_ sky130_fd_sc_hd__o21ai_1
XFILLER_0_71_52 VGND VGND VPWR VPWR sky130_fd_sc_hd__fill_2
XFILLER_0_9_535 VGND VGND VPWR VPWR sky130_fd_sc_hd__fill_2
XFILLER_0_119_337 VGND VGND VPWR VPWR sky130_fd_sc_hd__decap_8
XFILLER_0_92_728 VGND VGND VPWR VPWR sky130_fd_sc_hd__fill_2
XFILLER_0_9_557 VGND VGND VPWR VPWR sky130_fd_sc_hd__decap_3
X_6784_ _3274_ VGND VGND VPWR VPWR _0878_ sky130_fd_sc_hd__clkbuf_1
X_5735_ _1145_ _2271_ VGND VGND VPWR VPWR _2467_ sky130_fd_sc_hd__nand2_2
XFILLER_0_44_132 VGND VGND VPWR VPWR sky130_fd_sc_hd__fill_2
XFILLER_0_44_121 VGND VGND VPWR VPWR sky130_fd_sc_hd__fill_2
XFILLER_0_17_335 VGND VGND VPWR VPWR sky130_fd_sc_hd__fill_1
X_8523_ _4213_ VGND VGND VPWR VPWR _0654_ sky130_fd_sc_hd__clkbuf_1
XANTENNA__4834__S1 _1556_ VGND VGND VPWR VPWR sky130_fd_sc_hd__diode_2
XFILLER_0_29_195 VGND VGND VPWR VPWR sky130_fd_sc_hd__fill_2
X_5666_ _2292_ _2301_ _2353_ VGND VGND VPWR VPWR _2400_ sky130_fd_sc_hd__mux2_1
XFILLER_0_17_368 VGND VGND VPWR VPWR sky130_fd_sc_hd__fill_2
X_8454_ registers\[8\]\[21\] net29 _4175_ VGND VGND VPWR VPWR _4177_ sky130_fd_sc_hd__mux2_1
XANTENNA__8350__A1 _3443_ VGND VGND VPWR VPWR sky130_fd_sc_hd__diode_2
X_4617_ registers\[16\]\[19\] registers\[17\]\[19\] registers\[18\]\[19\] registers\[19\]\[19\]
+ _1338_ _1339_ VGND VGND VPWR VPWR _1398_ sky130_fd_sc_hd__mux4_1
XFILLER_0_60_625 VGND VGND VPWR VPWR sky130_fd_sc_hd__decap_3
X_7405_ registers\[20\]\[8\] _3451_ _3612_ VGND VGND VPWR VPWR _3621_ sky130_fd_sc_hd__mux2_1
XFILLER_0_4_240 VGND VGND VPWR VPWR sky130_fd_sc_hd__fill_1
X_5597_ _2330_ _2331_ VGND VGND VPWR VPWR _2332_ sky130_fd_sc_hd__nand2_1
XFILLER_0_13_552 VGND VGND VPWR VPWR sky130_fd_sc_hd__fill_2
X_8385_ _4140_ VGND VGND VPWR VPWR _0589_ sky130_fd_sc_hd__clkbuf_1
XFILLER_0_102_248 VGND VGND VPWR VPWR sky130_fd_sc_hd__fill_1
X_4548_ registers\[8\]\[15\] registers\[9\]\[15\] registers\[10\]\[15\] registers\[11\]\[15\]
+ _1198_ _1199_ VGND VGND VPWR VPWR _1333_ sky130_fd_sc_hd__mux4_1
X_7336_ registers\[1\]\[8\] _3451_ _3575_ VGND VGND VPWR VPWR _3584_ sky130_fd_sc_hd__mux2_1
XFILLER_0_40_360 VGND VGND VPWR VPWR sky130_fd_sc_hd__fill_2
XFILLER_0_13_596 VGND VGND VPWR VPWR sky130_fd_sc_hd__fill_1
X_4479_ _1266_ _1267_ _1116_ VGND VGND VPWR VPWR _1268_ sky130_fd_sc_hd__mux2_1
XFILLER_0_96_60 VGND VGND VPWR VPWR sky130_fd_sc_hd__fill_2
XTAP_TAPCELL_ROW_92_1457 VGND VPWR sky130_fd_sc_hd__tapvpwrvgnd_1
X_7267_ _3547_ VGND VGND VPWR VPWR _0064_ sky130_fd_sc_hd__clkbuf_1
XPHY_EDGE_ROW_8_Left_128 VGND VGND VPWR VPWR sky130_fd_sc_hd__decap_3
XFILLER_0_3_9 VGND VGND VPWR VPWR sky130_fd_sc_hd__fill_2
X_9006_ clknet_leaf_40_clk _0103_ VGND VGND VPWR VPWR registers\[1\]\[14\] sky130_fd_sc_hd__dfxtp_1
X_6218_ _2888_ _2924_ _2308_ VGND VGND VPWR VPWR _2925_ sky130_fd_sc_hd__mux2_1
X_7198_ registers\[17\]\[7\] _3449_ _3503_ VGND VGND VPWR VPWR _3511_ sky130_fd_sc_hd__mux2_1
X_6149_ _2856_ _2859_ VGND VGND VPWR VPWR _2860_ sky130_fd_sc_hd__xnor2_1
XANTENNA__4770__S0 _1433_ VGND VGND VPWR VPWR sky130_fd_sc_hd__diode_2
XANTENNA__6427__C net48 VGND VGND VPWR VPWR sky130_fd_sc_hd__diode_2
XPHY_EDGE_ROW_79_Right_79 VGND VGND VPWR VPWR sky130_fd_sc_hd__decap_3
XANTENNA__4427__B1 _1024_ VGND VGND VPWR VPWR sky130_fd_sc_hd__diode_2
XANTENNA__4522__S0 _1136_ VGND VGND VPWR VPWR sky130_fd_sc_hd__diode_2
XANTENNA__8169__A1 _3466_ VGND VGND VPWR VPWR sky130_fd_sc_hd__diode_2
XANTENNA__5078__S1 _1814_ VGND VGND VPWR VPWR sky130_fd_sc_hd__diode_2
XFILLER_0_95_544 VGND VGND VPWR VPWR sky130_fd_sc_hd__fill_2
XFILLER_0_48_471 VGND VGND VPWR VPWR sky130_fd_sc_hd__decap_3
XTAP_TAPCELL_ROW_101_1575 VGND VPWR sky130_fd_sc_hd__tapvpwrvgnd_1
XFILLER_0_63_441 VGND VGND VPWR VPWR sky130_fd_sc_hd__fill_1
XTAP_TAPCELL_ROW_11_403 VGND VPWR sky130_fd_sc_hd__tapvpwrvgnd_1
XFILLER_0_36_655 VGND VGND VPWR VPWR sky130_fd_sc_hd__fill_2
XFILLER_0_118_381 VGND VGND VPWR VPWR sky130_fd_sc_hd__decap_3
XANTENNA__8150__S _4009_ VGND VGND VPWR VPWR sky130_fd_sc_hd__diode_2
XFILLER_0_51_603 VGND VGND VPWR VPWR sky130_fd_sc_hd__fill_2
XFILLER_0_23_305 VGND VGND VPWR VPWR sky130_fd_sc_hd__fill_2
XPHY_EDGE_ROW_88_Right_88 VGND VGND VPWR VPWR sky130_fd_sc_hd__decap_3
XFILLER_0_63_485 VGND VGND VPWR VPWR sky130_fd_sc_hd__decap_3
XFILLER_0_23_316 VGND VGND VPWR VPWR sky130_fd_sc_hd__fill_1
XFILLER_0_50_157 VGND VGND VPWR VPWR sky130_fd_sc_hd__fill_2
XFILLER_0_23_349 VGND VGND VPWR VPWR sky130_fd_sc_hd__fill_2
XANTENNA__5250__S1 _1997_ VGND VGND VPWR VPWR sky130_fd_sc_hd__diode_2
XFILLER_0_76_19 VGND VGND VPWR VPWR sky130_fd_sc_hd__fill_1
XFILLER_0_31_393 VGND VGND VPWR VPWR sky130_fd_sc_hd__fill_2
XANTENNA__7852__A0 _3123_ VGND VGND VPWR VPWR sky130_fd_sc_hd__diode_2
XPHY_EDGE_ROW_97_Right_97 VGND VGND VPWR VPWR sky130_fd_sc_hd__decap_3
XANTENNA__4761__S0 _1404_ VGND VGND VPWR VPWR sky130_fd_sc_hd__diode_2
XFILLER_0_92_29 VGND VGND VPWR VPWR sky130_fd_sc_hd__fill_2
XTAP_TAPCELL_ROW_19_503 VGND VPWR sky130_fd_sc_hd__tapvpwrvgnd_1
XFILLER_0_98_360 VGND VGND VPWR VPWR sky130_fd_sc_hd__fill_2
XFILLER_0_86_500 VGND VGND VPWR VPWR sky130_fd_sc_hd__fill_2
XFILLER_0_59_703 VGND VGND VPWR VPWR sky130_fd_sc_hd__fill_2
XFILLER_0_86_533 VGND VGND VPWR VPWR sky130_fd_sc_hd__decap_4
XTAP_TAPCELL_ROW_47_867 VGND VPWR sky130_fd_sc_hd__tapvpwrvgnd_1
XFILLER_0_86_599 VGND VGND VPWR VPWR sky130_fd_sc_hd__fill_2
XFILLER_0_27_600 VGND VGND VPWR VPWR sky130_fd_sc_hd__decap_3
XFILLER_0_116_318 VGND VGND VPWR VPWR sky130_fd_sc_hd__fill_2
XANTENNA__4816__S1 _1391_ VGND VGND VPWR VPWR sky130_fd_sc_hd__diode_2
XANTENNA__5394__B2 _2019_ VGND VGND VPWR VPWR sky130_fd_sc_hd__diode_2
XTAP_TAPCELL_ROW_119_1825 VGND VPWR sky130_fd_sc_hd__tapvpwrvgnd_1
XTAP_TAPCELL_ROW_119_1814 VGND VPWR sky130_fd_sc_hd__tapvpwrvgnd_1
XTAP_TAPCELL_ROW_119_1803 VGND VPWR sky130_fd_sc_hd__tapvpwrvgnd_1
X_5520_ _2252_ _2255_ VGND VGND VPWR VPWR _2256_ sky130_fd_sc_hd__nand2_1
XFILLER_0_54_463 VGND VGND VPWR VPWR sky130_fd_sc_hd__fill_2
XFILLER_0_54_441 VGND VGND VPWR VPWR sky130_fd_sc_hd__decap_6
XANTENNA__8060__S _3959_ VGND VGND VPWR VPWR sky130_fd_sc_hd__diode_2
XFILLER_0_42_625 VGND VGND VPWR VPWR sky130_fd_sc_hd__decap_3
XFILLER_0_41_113 VGND VGND VPWR VPWR sky130_fd_sc_hd__decap_3
XFILLER_0_41_146 VGND VGND VPWR VPWR sky130_fd_sc_hd__fill_2
X_5451_ registers\[4\]\[31\] registers\[5\]\[31\] registers\[6\]\[31\] registers\[7\]\[31\]
+ _2126_ _2127_ VGND VGND VPWR VPWR _2188_ sky130_fd_sc_hd__mux4_1
X_4402_ _1153_ _1194_ VGND VGND VPWR VPWR _1195_ sky130_fd_sc_hd__nand2_1
X_8170_ _4026_ VGND VGND VPWR VPWR _0488_ sky130_fd_sc_hd__clkbuf_1
XANTENNA__5697__A2 _1070_ VGND VGND VPWR VPWR sky130_fd_sc_hd__diode_2
XFILLER_0_50_680 VGND VGND VPWR VPWR sky130_fd_sc_hd__fill_2
X_5382_ registers\[16\]\[27\] registers\[17\]\[27\] registers\[18\]\[27\] registers\[19\]\[27\]
+ _2119_ _2120_ VGND VGND VPWR VPWR _2123_ sky130_fd_sc_hd__mux4_1
X_4333_ registers\[8\]\[4\] registers\[9\]\[4\] registers\[10\]\[4\] registers\[11\]\[4\]
+ _1126_ _1128_ VGND VGND VPWR VPWR _1129_ sky130_fd_sc_hd__mux4_1
X_7121_ registers\[16\]\[12\] _3460_ _3456_ VGND VGND VPWR VPWR _3461_ sky130_fd_sc_hd__mux2_1
XFILLER_0_5_11 VGND VGND VPWR VPWR sky130_fd_sc_hd__fill_1
X_7052_ _3106_ registers\[15\]\[18\] _3409_ VGND VGND VPWR VPWR _3418_ sky130_fd_sc_hd__mux2_1
X_4264_ _1030_ _1062_ VGND VGND VPWR VPWR _1063_ sky130_fd_sc_hd__or2_1
X_6003_ _1145_ _2272_ VGND VGND VPWR VPWR _2722_ sky130_fd_sc_hd__nor2_1
XFILLER_0_5_66 VGND VGND VPWR VPWR sky130_fd_sc_hd__decap_4
XANTENNA__4329__A _1110_ VGND VGND VPWR VPWR sky130_fd_sc_hd__diode_2
XANTENNA__4752__S0 _1390_ VGND VGND VPWR VPWR sky130_fd_sc_hd__diode_2
XANTENNA__4504__S0 _1167_ VGND VGND VPWR VPWR sky130_fd_sc_hd__diode_2
XANTENNA__8235__S _4056_ VGND VGND VPWR VPWR sky130_fd_sc_hd__diode_2
X_7954_ _3900_ VGND VGND VPWR VPWR _3912_ sky130_fd_sc_hd__clkbuf_8
XANTENNA__4763__S _1346_ VGND VGND VPWR VPWR sky130_fd_sc_hd__diode_2
X_6905_ _3339_ VGND VGND VPWR VPWR _0934_ sky130_fd_sc_hd__clkbuf_1
XFILLER_0_89_393 VGND VGND VPWR VPWR sky130_fd_sc_hd__fill_1
XFILLER_0_89_382 VGND VGND VPWR VPWR sky130_fd_sc_hd__decap_8
X_7885_ _3875_ VGND VGND VPWR VPWR _0354_ sky130_fd_sc_hd__clkbuf_1
X_6836_ registers\[12\]\[13\] _2989_ _3299_ VGND VGND VPWR VPWR _3303_ sky130_fd_sc_hd__mux2_1
XFILLER_0_92_514 VGND VGND VPWR VPWR sky130_fd_sc_hd__fill_1
XFILLER_0_77_577 VGND VGND VPWR VPWR sky130_fd_sc_hd__fill_2
XFILLER_0_9_321 VGND VGND VPWR VPWR sky130_fd_sc_hd__decap_3
XFILLER_0_119_167 VGND VGND VPWR VPWR sky130_fd_sc_hd__fill_1
X_6767_ _3265_ VGND VGND VPWR VPWR _0870_ sky130_fd_sc_hd__clkbuf_1
X_9555_ clknet_leaf_14_clk _0652_ VGND VGND VPWR VPWR registers\[4\]\[19\] sky130_fd_sc_hd__dfxtp_1
XFILLER_0_64_249 VGND VGND VPWR VPWR sky130_fd_sc_hd__decap_3
X_8506_ _4204_ VGND VGND VPWR VPWR _0646_ sky130_fd_sc_hd__clkbuf_1
X_5718_ _2335_ _2367_ _1072_ VGND VGND VPWR VPWR _2451_ sky130_fd_sc_hd__mux2_1
X_6698_ registers\[10\]\[13\] _2989_ _3225_ VGND VGND VPWR VPWR _3229_ sky130_fd_sc_hd__mux2_1
X_9486_ clknet_leaf_52_clk _0583_ VGND VGND VPWR VPWR registers\[5\]\[14\] sky130_fd_sc_hd__dfxtp_1
XFILLER_0_60_411 VGND VGND VPWR VPWR sky130_fd_sc_hd__fill_2
XFILLER_0_45_485 VGND VGND VPWR VPWR sky130_fd_sc_hd__fill_2
XFILLER_0_115_384 VGND VGND VPWR VPWR sky130_fd_sc_hd__decap_8
X_8437_ registers\[8\]\[13\] net20 _4164_ VGND VGND VPWR VPWR _4168_ sky130_fd_sc_hd__mux2_1
X_5649_ _2382_ _2383_ _2266_ VGND VGND VPWR VPWR _2384_ sky130_fd_sc_hd__mux2_2
XFILLER_0_60_466 VGND VGND VPWR VPWR sky130_fd_sc_hd__fill_2
X_8368_ _4131_ VGND VGND VPWR VPWR _0581_ sky130_fd_sc_hd__clkbuf_1
XANTENNA__5232__S1 _1720_ VGND VGND VPWR VPWR sky130_fd_sc_hd__diode_2
XFILLER_0_60_477 VGND VGND VPWR VPWR sky130_fd_sc_hd__decap_3
X_7319_ _3574_ VGND VGND VPWR VPWR _3575_ sky130_fd_sc_hd__clkbuf_8
XFILLER_0_41_691 VGND VGND VPWR VPWR sky130_fd_sc_hd__decap_4
XFILLER_0_13_393 VGND VGND VPWR VPWR sky130_fd_sc_hd__decap_4
X_8299_ _2987_ registers\[31\]\[12\] _4092_ VGND VGND VPWR VPWR _4095_ sky130_fd_sc_hd__mux2_1
XANTENNA__7314__S _3538_ VGND VGND VPWR VPWR sky130_fd_sc_hd__diode_2
XANTENNA__4239__A a2[0] VGND VGND VPWR VPWR sky130_fd_sc_hd__diode_2
XFILLER_0_99_113 VGND VGND VPWR VPWR sky130_fd_sc_hd__fill_2
XANTENNA__5299__S1 _1799_ VGND VGND VPWR VPWR sky130_fd_sc_hd__diode_2
XANTENNA__4673__S _1346_ VGND VGND VPWR VPWR sky130_fd_sc_hd__diode_2
XFILLER_0_68_533 VGND VGND VPWR VPWR sky130_fd_sc_hd__decap_4
XTAP_TAPCELL_ROW_103_1604 VGND VPWR sky130_fd_sc_hd__tapvpwrvgnd_1
XFILLER_0_68_544 VGND VGND VPWR VPWR sky130_fd_sc_hd__fill_2
XTAP_TAPCELL_ROW_44_837 VGND VPWR sky130_fd_sc_hd__tapvpwrvgnd_1
XTAP_TAPCELL_ROW_44_826 VGND VPWR sky130_fd_sc_hd__tapvpwrvgnd_1
XANTENNA__7984__S _3923_ VGND VGND VPWR VPWR sky130_fd_sc_hd__diode_2
XFILLER_0_95_374 VGND VGND VPWR VPWR sky130_fd_sc_hd__fill_2
XTAP_TAPCELL_ROW_24_572 VGND VPWR sky130_fd_sc_hd__tapvpwrvgnd_1
XANTENNA__5376__A1 _1977_ VGND VGND VPWR VPWR sky130_fd_sc_hd__diode_2
XFILLER_0_83_569 VGND VGND VPWR VPWR sky130_fd_sc_hd__fill_1
XANTENNA__4702__A _1379_ VGND VGND VPWR VPWR sky130_fd_sc_hd__diode_2
XFILLER_0_51_433 VGND VGND VPWR VPWR sky130_fd_sc_hd__fill_2
XFILLER_0_106_395 VGND VGND VPWR VPWR sky130_fd_sc_hd__fill_2
XFILLER_0_11_319 VGND VGND VPWR VPWR sky130_fd_sc_hd__fill_2
XTAP_TAPCELL_ROW_114_1744 VGND VPWR sky130_fd_sc_hd__tapvpwrvgnd_1
XANTENNA__4982__S0 _1742_ VGND VGND VPWR VPWR sky130_fd_sc_hd__diode_2
XANTENNA_output62_A net62 VGND VGND VPWR VPWR sky130_fd_sc_hd__diode_2
XANTENNA__4734__S0 _1415_ VGND VGND VPWR VPWR sky130_fd_sc_hd__diode_2
Xinput7 a2[3] VGND VGND VPWR VPWR net7 sky130_fd_sc_hd__clkbuf_2
XTAP_TAPCELL_ROW_65_1109 VGND VPWR sky130_fd_sc_hd__tapvpwrvgnd_1
X_4951_ registers\[8\]\[4\] registers\[9\]\[4\] registers\[10\]\[4\] registers\[11\]\[4\]
+ _1690_ _1692_ VGND VGND VPWR VPWR _1715_ sky130_fd_sc_hd__mux4_1
X_7670_ registers\[24\]\[4\] _3443_ _3757_ VGND VGND VPWR VPWR _3762_ sky130_fd_sc_hd__mux2_1
XFILLER_0_86_385 VGND VGND VPWR VPWR sky130_fd_sc_hd__decap_6
XFILLER_0_86_352 VGND VGND VPWR VPWR sky130_fd_sc_hd__decap_8
X_4882_ _1647_ _1648_ _1621_ VGND VGND VPWR VPWR _1649_ sky130_fd_sc_hd__mux2_1
XFILLER_0_19_419 VGND VGND VPWR VPWR sky130_fd_sc_hd__decap_3
X_6621_ registers\[0\]\[10\] _2982_ _3186_ VGND VGND VPWR VPWR _3187_ sky130_fd_sc_hd__mux2_1
XFILLER_0_74_558 VGND VGND VPWR VPWR sky130_fd_sc_hd__fill_2
X_9340_ clknet_leaf_109_clk _0437_ VGND VGND VPWR VPWR registers\[2\]\[28\] sky130_fd_sc_hd__dfxtp_1
X_6552_ _3149_ VGND VGND VPWR VPWR _0771_ sky130_fd_sc_hd__clkbuf_1
XPHY_EDGE_ROW_89_Left_209 VGND VGND VPWR VPWR sky130_fd_sc_hd__decap_3
XFILLER_0_15_625 VGND VGND VPWR VPWR sky130_fd_sc_hd__fill_2
X_6483_ _3105_ VGND VGND VPWR VPWR _0746_ sky130_fd_sc_hd__clkbuf_1
X_5503_ _2226_ _2238_ _1090_ VGND VGND VPWR VPWR _2239_ sky130_fd_sc_hd__mux2_1
X_9271_ clknet_leaf_76_clk _0368_ VGND VGND VPWR VPWR registers\[27\]\[23\] sky130_fd_sc_hd__dfxtp_1
XTAP_TAPCELL_ROW_76_1249 VGND VPWR sky130_fd_sc_hd__tapvpwrvgnd_1
X_8222_ registers\[6\]\[8\] _3451_ _4045_ VGND VGND VPWR VPWR _4054_ sky130_fd_sc_hd__mux2_1
XANTENNA__5214__S1 _1821_ VGND VGND VPWR VPWR sky130_fd_sc_hd__diode_2
XFILLER_0_42_477 VGND VGND VPWR VPWR sky130_fd_sc_hd__fill_1
XANTENNA__6867__A1 _3020_ VGND VGND VPWR VPWR sky130_fd_sc_hd__diode_2
X_5434_ registers\[24\]\[30\] registers\[25\]\[30\] registers\[26\]\[30\] registers\[27\]\[30\]
+ _1996_ _1997_ VGND VGND VPWR VPWR _2172_ sky130_fd_sc_hd__mux4_1
XFILLER_0_112_365 VGND VGND VPWR VPWR sky130_fd_sc_hd__decap_4
X_8153_ _4017_ VGND VGND VPWR VPWR _0480_ sky130_fd_sc_hd__clkbuf_1
XANTENNA__4973__S0 _1731_ VGND VGND VPWR VPWR sky130_fd_sc_hd__diode_2
X_7104_ net45 VGND VGND VPWR VPWR _3449_ sky130_fd_sc_hd__buf_2
XFILLER_0_77_73 VGND VGND VPWR VPWR sky130_fd_sc_hd__decap_3
XANTENNA__7816__A0 _3087_ VGND VGND VPWR VPWR sky130_fd_sc_hd__diode_2
X_5365_ _2105_ _2106_ _2031_ VGND VGND VPWR VPWR _2107_ sky130_fd_sc_hd__mux2_1
X_8084_ _2976_ registers\[30\]\[7\] _3973_ VGND VGND VPWR VPWR _3981_ sky130_fd_sc_hd__mux2_1
X_4316_ _1061_ VGND VGND VPWR VPWR _1112_ sky130_fd_sc_hd__clkbuf_4
X_5296_ _2040_ _2041_ _1689_ VGND VGND VPWR VPWR _2042_ sky130_fd_sc_hd__mux2_1
XANTENNA__6973__S _3372_ VGND VGND VPWR VPWR sky130_fd_sc_hd__diode_2
X_7035_ _3397_ VGND VGND VPWR VPWR _3409_ sky130_fd_sc_hd__clkbuf_8
X_4247_ _1045_ _1046_ _1030_ VGND VGND VPWR VPWR _1047_ sky130_fd_sc_hd__mux2_1
XPHY_EDGE_ROW_98_Left_218 VGND VGND VPWR VPWR sky130_fd_sc_hd__decap_3
XFILLER_0_97_617 VGND VGND VPWR VPWR sky130_fd_sc_hd__fill_2
XTAP_TAPCELL_ROW_2_289 VGND VPWR sky130_fd_sc_hd__tapvpwrvgnd_1
X_8986_ clknet_leaf_77_clk _0083_ VGND VGND VPWR VPWR registers\[18\]\[26\] sky130_fd_sc_hd__dfxtp_1
XANTENNA__5150__S0 _1752_ VGND VGND VPWR VPWR sky130_fd_sc_hd__diode_2
XTAP_TAPCELL_ROW_87_1389 VGND VPWR sky130_fd_sc_hd__tapvpwrvgnd_1
X_7937_ _3903_ VGND VGND VPWR VPWR _0378_ sky130_fd_sc_hd__clkbuf_1
X_7868_ _3071_ registers\[27\]\[1\] _3865_ VGND VGND VPWR VPWR _3867_ sky130_fd_sc_hd__mux2_1
X_6819_ registers\[12\]\[5\] _2972_ _3288_ VGND VGND VPWR VPWR _3294_ sky130_fd_sc_hd__mux2_1
XANTENNA__5358__A1 _1977_ VGND VGND VPWR VPWR sky130_fd_sc_hd__diode_2
XFILLER_0_107_126 VGND VGND VPWR VPWR sky130_fd_sc_hd__decap_3
XFILLER_0_80_506 VGND VGND VPWR VPWR sky130_fd_sc_hd__fill_2
XFILLER_0_53_709 VPWR VGND VPWR VGND sky130_ef_sc_hd__decap_12
XFILLER_0_9_162 VGND VGND VPWR VPWR sky130_fd_sc_hd__decap_3
X_7799_ _3830_ VGND VGND VPWR VPWR _0313_ sky130_fd_sc_hd__clkbuf_1
XTAP_TAPCELL_ROW_21_531 VGND VPWR sky130_fd_sc_hd__tapvpwrvgnd_1
XANTENNA__5453__S1 _2127_ VGND VGND VPWR VPWR sky130_fd_sc_hd__diode_2
X_9538_ clknet_leaf_4_clk _0635_ VGND VGND VPWR VPWR registers\[4\]\[2\] sky130_fd_sc_hd__dfxtp_1
XFILLER_0_60_230 VGND VGND VPWR VPWR sky130_fd_sc_hd__fill_1
X_9469_ clknet_leaf_103_clk _0566_ VGND VGND VPWR VPWR registers\[31\]\[29\] sky130_fd_sc_hd__dfxtp_1
XFILLER_0_116_693 VGND VGND VPWR VPWR sky130_fd_sc_hd__decap_6
XFILLER_0_115_192 VGND VGND VPWR VPWR sky130_fd_sc_hd__fill_2
XFILLER_0_103_332 VGND VGND VPWR VPWR sky130_fd_sc_hd__fill_1
XANTENNA__5205__S1 _1743_ VGND VGND VPWR VPWR sky130_fd_sc_hd__diode_2
XFILLER_0_21_617 VGND VGND VPWR VPWR sky130_fd_sc_hd__fill_2
XFILLER_0_20_127 VGND VGND VPWR VPWR sky130_fd_sc_hd__fill_1
XANTENNA__7044__S _3409_ VGND VGND VPWR VPWR sky130_fd_sc_hd__diode_2
XANTENNA__4964__S0 _1678_ VGND VGND VPWR VPWR sky130_fd_sc_hd__diode_2
XANTENNA__5353__A _2076_ VGND VGND VPWR VPWR sky130_fd_sc_hd__diode_2
XFILLER_0_13_190 VGND VGND VPWR VPWR sky130_fd_sc_hd__fill_2
XANTENNA__7283__A1 _3466_ VGND VGND VPWR VPWR sky130_fd_sc_hd__diode_2
XANTENNA__6883__S _3324_ VGND VGND VPWR VPWR sky130_fd_sc_hd__diode_2
XANTENNA__4716__S0 _1433_ VGND VGND VPWR VPWR sky130_fd_sc_hd__diode_2
XTAP_TAPCELL_ROW_29_631 VGND VPWR sky130_fd_sc_hd__tapvpwrvgnd_1
XTAP_TAPCELL_ROW_29_642 VGND VPWR sky130_fd_sc_hd__tapvpwrvgnd_1
XANTENNA__5141__S0 _1748_ VGND VGND VPWR VPWR sky130_fd_sc_hd__diode_2
XTAP_TAPCELL_ROW_57_995 VGND VPWR sky130_fd_sc_hd__tapvpwrvgnd_1
XFILLER_0_68_374 VGND VGND VPWR VPWR sky130_fd_sc_hd__fill_2
XFILLER_0_96_694 VGND VGND VPWR VPWR sky130_fd_sc_hd__decap_4
XFILLER_0_56_547 VGND VGND VPWR VPWR sky130_fd_sc_hd__fill_2
XANTENNA__7219__S _3514_ VGND VGND VPWR VPWR sky130_fd_sc_hd__diode_2
XTAP_TAPCELL_ROW_60_1039 VGND VPWR sky130_fd_sc_hd__tapvpwrvgnd_1
XFILLER_0_22_79 VGND VGND VPWR VPWR sky130_fd_sc_hd__fill_1
XFILLER_0_3_305 VGND VGND VPWR VPWR sky130_fd_sc_hd__fill_2
XFILLER_0_106_192 VGND VGND VPWR VPWR sky130_fd_sc_hd__fill_2
XFILLER_0_24_488 VGND VGND VPWR VPWR sky130_fd_sc_hd__fill_2
XFILLER_0_20_661 VGND VGND VPWR VPWR sky130_fd_sc_hd__decap_3
X_5150_ _1900_ _1901_ _1902_ _1903_ _1752_ _1687_ VGND VGND VPWR VPWR _1904_ sky130_fd_sc_hd__mux4_2
XFILLER_0_47_21 VGND VGND VPWR VPWR sky130_fd_sc_hd__decap_4
XANTENNA__7181__C net48 VGND VGND VPWR VPWR sky130_fd_sc_hd__diode_2
XANTENNA__7889__S _3876_ VGND VGND VPWR VPWR sky130_fd_sc_hd__diode_2
X_5081_ registers\[28\]\[10\] registers\[29\]\[10\] registers\[30\]\[10\] registers\[31\]\[10\]
+ _1757_ _1814_ VGND VGND VPWR VPWR _1839_ sky130_fd_sc_hd__mux4_1
XTAP_TAPCELL_ROW_71_1179 VGND VPWR sky130_fd_sc_hd__tapvpwrvgnd_1
XANTENNA__6793__S _3272_ VGND VGND VPWR VPWR sky130_fd_sc_hd__diode_2
XFILLER_0_2_23 VGND VGND VPWR VPWR sky130_fd_sc_hd__decap_4
XANTENNA__5380__S0 _2119_ VGND VGND VPWR VPWR sky130_fd_sc_hd__diode_2
XANTENNA__6806__B net12 VGND VGND VPWR VPWR sky130_fd_sc_hd__diode_2
XANTENNA__5202__S _1746_ VGND VGND VPWR VPWR sky130_fd_sc_hd__diode_2
X_8840_ clknet_leaf_18_clk _0961_ VGND VGND VPWR VPWR registers\[14\]\[8\] sky130_fd_sc_hd__dfxtp_1
XFILLER_0_63_42 VGND VGND VPWR VPWR sky130_fd_sc_hd__fill_1
XANTENNA__4607__A _1159_ VGND VGND VPWR VPWR sky130_fd_sc_hd__diode_2
XANTENNA__5132__S0 _1883_ VGND VGND VPWR VPWR sky130_fd_sc_hd__diode_2
XFILLER_0_78_149 VGND VGND VPWR VPWR sky130_fd_sc_hd__decap_4
X_5983_ net87 _2681_ _2702_ VGND VGND VPWR VPWR _2703_ sky130_fd_sc_hd__a21oi_1
X_8771_ clknet_leaf_7_clk _0892_ VGND VGND VPWR VPWR registers\[12\]\[3\] sky130_fd_sc_hd__dfxtp_1
XFILLER_0_86_160 VGND VGND VPWR VPWR sky130_fd_sc_hd__fill_2
XANTENNA__8513__S _4200_ VGND VGND VPWR VPWR sky130_fd_sc_hd__diode_2
X_4934_ registers\[0\]\[3\] registers\[1\]\[3\] registers\[2\]\[3\] registers\[3\]\[3\]
+ _1678_ _1679_ VGND VGND VPWR VPWR _1699_ sky130_fd_sc_hd__mux4_1
X_7722_ registers\[24\]\[29\] _3495_ _3779_ VGND VGND VPWR VPWR _3789_ sky130_fd_sc_hd__mux2_1
XFILLER_0_74_333 VGND VGND VPWR VPWR sky130_fd_sc_hd__fill_1
XANTENNA__8526__A1 net31 VGND VGND VPWR VPWR sky130_fd_sc_hd__diode_2
XFILLER_0_19_238 VGND VGND VPWR VPWR sky130_fd_sc_hd__fill_2
XFILLER_0_117_402 VGND VGND VPWR VPWR sky130_fd_sc_hd__fill_2
XFILLER_0_74_355 VGND VGND VPWR VPWR sky130_fd_sc_hd__decap_6
X_4865_ _1631_ _1632_ VGND VGND VPWR VPWR _1633_ sky130_fd_sc_hd__or2_1
XFILLER_0_6_110 VGND VGND VPWR VPWR sky130_fd_sc_hd__fill_2
X_7653_ _3129_ registers\[23\]\[29\] _3742_ VGND VGND VPWR VPWR _3752_ sky130_fd_sc_hd__mux2_1
XFILLER_0_74_377 VGND VGND VPWR VPWR sky130_fd_sc_hd__fill_1
X_6604_ registers\[0\]\[2\] _2966_ _3175_ VGND VGND VPWR VPWR _3178_ sky130_fd_sc_hd__mux2_1
XANTENNA__5435__S1 _1756_ VGND VGND VPWR VPWR sky130_fd_sc_hd__diode_2
X_7584_ _3715_ VGND VGND VPWR VPWR _0213_ sky130_fd_sc_hd__clkbuf_1
X_4796_ _1381_ _1567_ _1372_ VGND VGND VPWR VPWR _1568_ sky130_fd_sc_hd__o21ai_1
XFILLER_0_27_271 VGND VGND VPWR VPWR sky130_fd_sc_hd__decap_4
XFILLER_0_104_118 VGND VGND VPWR VPWR sky130_fd_sc_hd__fill_2
XFILLER_0_104_107 VGND VGND VPWR VPWR sky130_fd_sc_hd__decap_4
XFILLER_0_103_92 VGND VGND VPWR VPWR sky130_fd_sc_hd__fill_2
XFILLER_0_103_81 VGND VGND VPWR VPWR sky130_fd_sc_hd__decap_4
X_9323_ clknet_leaf_51_clk _0420_ VGND VGND VPWR VPWR registers\[2\]\[11\] sky130_fd_sc_hd__dfxtp_1
XFILLER_0_7_688 VGND VGND VPWR VPWR sky130_fd_sc_hd__fill_2
XFILLER_0_7_677 VGND VGND VPWR VPWR sky130_fd_sc_hd__decap_4
XFILLER_0_15_444 VGND VGND VPWR VPWR sky130_fd_sc_hd__fill_2
X_6535_ _3140_ VGND VGND VPWR VPWR _0763_ sky130_fd_sc_hd__clkbuf_1
X_9254_ clknet_leaf_26_clk _0351_ VGND VGND VPWR VPWR registers\[27\]\[6\] sky130_fd_sc_hd__dfxtp_1
X_6466_ net19 VGND VGND VPWR VPWR _3094_ sky130_fd_sc_hd__clkbuf_2
XFILLER_0_42_274 VGND VGND VPWR VPWR sky130_fd_sc_hd__fill_2
X_8205_ _4044_ VGND VGND VPWR VPWR _4045_ sky130_fd_sc_hd__clkbuf_8
XFILLER_0_113_685 VPWR VGND VPWR VGND sky130_ef_sc_hd__decap_12
XANTENNA__4946__S0 _1705_ VGND VGND VPWR VPWR sky130_fd_sc_hd__diode_2
XFILLER_0_88_94 VGND VGND VPWR VPWR sky130_fd_sc_hd__fill_2
XANTENNA__4488__S _1117_ VGND VGND VPWR VPWR sky130_fd_sc_hd__diode_2
Xoutput141 net141 VGND VGND VPWR VPWR rd2[6] sky130_fd_sc_hd__buf_1
X_6397_ _3050_ VGND VGND VPWR VPWR _0715_ sky130_fd_sc_hd__clkbuf_1
Xoutput130 net130 VGND VGND VPWR VPWR rd2[25] sky130_fd_sc_hd__buf_1
X_9185_ clknet_leaf_109_clk _0282_ VGND VGND VPWR VPWR registers\[25\]\[1\] sky130_fd_sc_hd__dfxtp_1
XFILLER_0_2_360 VGND VGND VPWR VPWR sky130_fd_sc_hd__fill_2
X_5417_ registers\[28\]\[29\] registers\[29\]\[29\] registers\[30\]\[29\] registers\[31\]\[29\]
+ _2097_ _2109_ VGND VGND VPWR VPWR _2156_ sky130_fd_sc_hd__mux4_1
XFILLER_0_30_469 VGND VGND VPWR VPWR sky130_fd_sc_hd__decap_4
XFILLER_0_100_335 VGND VGND VPWR VPWR sky130_fd_sc_hd__fill_2
X_8136_ _3501_ _3210_ VGND VGND VPWR VPWR _4008_ sky130_fd_sc_hd__nor2_2
XTAP_TAPCELL_ROW_7_348 VGND VPWR sky130_fd_sc_hd__tapvpwrvgnd_1
X_5348_ _2087_ _2090_ _1756_ VGND VGND VPWR VPWR _2091_ sky130_fd_sc_hd__mux2_1
XFILLER_0_11_694 VGND VGND VPWR VPWR sky130_fd_sc_hd__fill_1
XFILLER_0_100_379 VGND VGND VPWR VPWR sky130_fd_sc_hd__fill_2
X_8067_ _3971_ VGND VGND VPWR VPWR _0440_ sky130_fd_sc_hd__clkbuf_1
XTAP_TAPCELL_ROW_89_1418 VGND VPWR sky130_fd_sc_hd__tapvpwrvgnd_1
XANTENNA__5901__A _1882_ VGND VGND VPWR VPWR sky130_fd_sc_hd__diode_2
X_7018_ _3400_ VGND VGND VPWR VPWR _0986_ sky130_fd_sc_hd__clkbuf_1
X_5279_ _1771_ VGND VGND VPWR VPWR _2026_ sky130_fd_sc_hd__buf_4
XANTENNA__5123__S0 _1810_ VGND VGND VPWR VPWR sky130_fd_sc_hd__diode_2
XTAP_TAPCELL_ROW_26_601 VGND VPWR sky130_fd_sc_hd__tapvpwrvgnd_1
XFILLER_0_78_661 VGND VGND VPWR VPWR sky130_fd_sc_hd__decap_3
XTAP_TAPCELL_ROW_54_965 VGND VPWR sky130_fd_sc_hd__tapvpwrvgnd_1
X_8969_ clknet_leaf_11_clk _0066_ VGND VGND VPWR VPWR registers\[18\]\[9\] sky130_fd_sc_hd__dfxtp_1
XFILLER_0_93_642 VGND VGND VPWR VPWR sky130_fd_sc_hd__fill_2
XFILLER_0_65_300 VGND VGND VPWR VPWR sky130_fd_sc_hd__decap_4
XANTENNA__8517__A1 net26 VGND VGND VPWR VPWR sky130_fd_sc_hd__diode_2
XFILLER_0_38_525 VGND VGND VPWR VPWR sky130_fd_sc_hd__decap_3
XFILLER_0_92_141 VGND VGND VPWR VPWR sky130_fd_sc_hd__fill_2
XFILLER_0_65_388 VGND VGND VPWR VPWR sky130_fd_sc_hd__fill_2
XANTENNA__5426__S1 _2127_ VGND VGND VPWR VPWR sky130_fd_sc_hd__diode_2
XFILLER_0_21_436 VGND VGND VPWR VPWR sky130_fd_sc_hd__fill_2
XFILLER_0_21_447 VGND VGND VPWR VPWR sky130_fd_sc_hd__fill_1
XTAP_TAPCELL_ROW_111_1703 VGND VPWR sky130_fd_sc_hd__tapvpwrvgnd_1
XFILLER_0_104_685 VGND VGND VPWR VPWR sky130_fd_sc_hd__fill_2
XANTENNA__4398__S _1122_ VGND VGND VPWR VPWR sky130_fd_sc_hd__diode_2
XANTENNA__7256__A1 _3439_ VGND VGND VPWR VPWR sky130_fd_sc_hd__diode_2
XFILLER_0_17_46 VGND VGND VPWR VPWR sky130_fd_sc_hd__fill_1
XANTENNA__5022__S _1627_ VGND VGND VPWR VPWR sky130_fd_sc_hd__diode_2
XTAP_TAPCELL_ROW_109_1676 VGND VPWR sky130_fd_sc_hd__tapvpwrvgnd_1
XFILLER_0_88_458 VGND VGND VPWR VPWR sky130_fd_sc_hd__fill_2
XANTENNA__5114__S0 _1798_ VGND VGND VPWR VPWR sky130_fd_sc_hd__diode_2
XANTENNA_clkload7_A clknet_4_8_0_clk VGND VGND VPWR VPWR sky130_fd_sc_hd__diode_2
XFILLER_0_75_108 VGND VGND VPWR VPWR sky130_fd_sc_hd__decap_4
XFILLER_0_69_661 VGND VGND VPWR VPWR sky130_fd_sc_hd__fill_2
XFILLER_0_29_503 VGND VGND VPWR VPWR sky130_fd_sc_hd__fill_1
XFILLER_0_8_419 VGND VGND VPWR VPWR sky130_fd_sc_hd__fill_1
XFILLER_0_29_525 VGND VGND VPWR VPWR sky130_fd_sc_hd__fill_2
XFILLER_0_56_344 VGND VGND VPWR VPWR sky130_fd_sc_hd__fill_2
XFILLER_0_71_325 VGND VGND VPWR VPWR sky130_fd_sc_hd__decap_8
XFILLER_0_71_303 VGND VGND VPWR VPWR sky130_fd_sc_hd__fill_1
XFILLER_0_44_528 VGND VGND VPWR VPWR sky130_fd_sc_hd__fill_2
XANTENNA__5417__S1 _2109_ VGND VGND VPWR VPWR sky130_fd_sc_hd__diode_2
X_4650_ registers\[12\]\[20\] registers\[13\]\[20\] registers\[14\]\[20\] registers\[15\]\[20\]
+ _1427_ _1428_ VGND VGND VPWR VPWR _1430_ sky130_fd_sc_hd__mux4_1
XFILLER_0_116_3 VPWR VGND VPWR VGND sky130_ef_sc_hd__decap_12
Xinput21 wd3[14] VGND VGND VPWR VPWR net21 sky130_fd_sc_hd__clkbuf_2
Xinput10 a3[1] VGND VGND VPWR VPWR net10 sky130_fd_sc_hd__clkbuf_2
Xinput43 wd3[5] VGND VGND VPWR VPWR net43 sky130_fd_sc_hd__dlymetal6s2s_1
X_4581_ registers\[12\]\[17\] registers\[13\]\[17\] registers\[14\]\[17\] registers\[15\]\[17\]
+ _1201_ _1204_ VGND VGND VPWR VPWR _1364_ sky130_fd_sc_hd__mux4_1
Xinput32 wd3[24] VGND VGND VPWR VPWR net32 sky130_fd_sc_hd__clkbuf_4
XFILLER_0_52_561 VGND VGND VPWR VPWR sky130_fd_sc_hd__fill_2
XFILLER_0_40_701 VGND VGND VPWR VPWR sky130_fd_sc_hd__decap_4
XFILLER_0_3_113 VPWR VGND VPWR VGND sky130_ef_sc_hd__decap_12
X_6320_ _2961_ VGND VGND VPWR VPWR _3004_ sky130_fd_sc_hd__clkbuf_8
X_6251_ net138 _2811_ _2955_ _2560_ VGND VGND VPWR VPWR _2956_ sky130_fd_sc_hd__a211o_1
XTAP_TAPCELL_ROW_73_1208 VGND VPWR sky130_fd_sc_hd__tapvpwrvgnd_1
XANTENNA__4928__S0 _1690_ VGND VGND VPWR VPWR sky130_fd_sc_hd__diode_2
X_6182_ _2279_ _2759_ _2887_ _2890_ VGND VGND VPWR VPWR _2891_ sky130_fd_sc_hd__a211o_1
X_5202_ _1951_ _1952_ _1746_ VGND VGND VPWR VPWR _1953_ sky130_fd_sc_hd__mux2_1
XFILLER_0_110_699 VGND VGND VPWR VPWR sky130_fd_sc_hd__fill_1
X_5133_ registers\[24\]\[13\] registers\[25\]\[13\] registers\[26\]\[13\] registers\[27\]\[13\]
+ _1690_ _1692_ VGND VGND VPWR VPWR _1888_ sky130_fd_sc_hd__mux4_1
XANTENNA__7412__S _3623_ VGND VGND VPWR VPWR sky130_fd_sc_hd__diode_2
XTAP_TAPCELL_ROW_4_307 VGND VPWR sky130_fd_sc_hd__tapvpwrvgnd_1
XANTENNA__5258__B1 _1701_ VGND VGND VPWR VPWR sky130_fd_sc_hd__diode_2
X_5064_ registers\[28\]\[9\] registers\[29\]\[9\] registers\[30\]\[9\] registers\[31\]\[9\]
+ _1820_ _1821_ VGND VGND VPWR VPWR _1823_ sky130_fd_sc_hd__mux4_1
XANTENNA__4481__A1 _1073_ VGND VGND VPWR VPWR sky130_fd_sc_hd__diode_2
XANTENNA__5105__S0 _1773_ VGND VGND VPWR VPWR sky130_fd_sc_hd__diode_2
XFILLER_0_79_436 VGND VGND VPWR VPWR sky130_fd_sc_hd__fill_2
XFILLER_0_79_447 VGND VGND VPWR VPWR sky130_fd_sc_hd__fill_1
X_8823_ clknet_leaf_71_clk _0944_ VGND VGND VPWR VPWR registers\[13\]\[23\] sky130_fd_sc_hd__dfxtp_1
XTAP_TAPCELL_ROW_84_1348 VGND VPWR sky130_fd_sc_hd__tapvpwrvgnd_1
X_5966_ _2322_ _2677_ _2679_ _2686_ VGND VGND VPWR VPWR net55 sky130_fd_sc_hd__a211o_1
XFILLER_0_90_73 VGND VGND VPWR VPWR sky130_fd_sc_hd__fill_2
XFILLER_0_87_491 VGND VGND VPWR VPWR sky130_fd_sc_hd__decap_6
XFILLER_0_75_620 VGND VGND VPWR VPWR sky130_fd_sc_hd__fill_2
XFILLER_0_59_160 VGND VGND VPWR VPWR sky130_fd_sc_hd__fill_2
X_8754_ clknet_leaf_67_clk _0875_ VGND VGND VPWR VPWR registers\[11\]\[18\] sky130_fd_sc_hd__dfxtp_1
XANTENNA__8243__S _4056_ VGND VGND VPWR VPWR sky130_fd_sc_hd__diode_2
X_8685_ clknet_leaf_51_clk _0806_ VGND VGND VPWR VPWR registers\[0\]\[13\] sky130_fd_sc_hd__dfxtp_1
X_5897_ _2399_ _2615_ _2621_ VGND VGND VPWR VPWR net51 sky130_fd_sc_hd__o21ai_1
XFILLER_0_90_95 VGND VGND VPWR VPWR sky130_fd_sc_hd__fill_2
XFILLER_0_74_141 VGND VGND VPWR VPWR sky130_fd_sc_hd__fill_2
X_4917_ _1627_ VGND VGND VPWR VPWR _1682_ sky130_fd_sc_hd__clkbuf_8
XTAP_TAPCELL_ROW_51_924 VGND VPWR sky130_fd_sc_hd__tapvpwrvgnd_1
X_7705_ _3780_ VGND VGND VPWR VPWR _0269_ sky130_fd_sc_hd__clkbuf_1
X_4848_ net5 VGND VGND VPWR VPWR _1616_ sky130_fd_sc_hd__inv_2
XFILLER_0_74_174 VGND VGND VPWR VPWR sky130_fd_sc_hd__fill_1
XFILLER_0_47_388 VGND VGND VPWR VPWR sky130_fd_sc_hd__fill_2
XANTENNA__5408__S1 _2073_ VGND VGND VPWR VPWR sky130_fd_sc_hd__diode_2
X_7636_ _3743_ VGND VGND VPWR VPWR _0237_ sky130_fd_sc_hd__clkbuf_1
XFILLER_0_117_265 VGND VGND VPWR VPWR sky130_fd_sc_hd__fill_1
XANTENNA__6698__S _3225_ VGND VGND VPWR VPWR sky130_fd_sc_hd__diode_2
X_7567_ _3110_ registers\[22\]\[20\] _3706_ VGND VGND VPWR VPWR _3707_ sky130_fd_sc_hd__mux2_1
X_4779_ _1405_ VGND VGND VPWR VPWR _1551_ sky130_fd_sc_hd__clkbuf_4
X_9306_ clknet_leaf_76_clk _0403_ VGND VGND VPWR VPWR registers\[28\]\[26\] sky130_fd_sc_hd__dfxtp_1
X_6518_ net37 VGND VGND VPWR VPWR _3129_ sky130_fd_sc_hd__clkbuf_2
X_7498_ _3647_ VGND VGND VPWR VPWR _3670_ sky130_fd_sc_hd__clkbuf_8
X_6449_ _3082_ VGND VGND VPWR VPWR _0735_ sky130_fd_sc_hd__clkbuf_1
XTAP_TAPCELL_ROW_95_1488 VGND VPWR sky130_fd_sc_hd__tapvpwrvgnd_1
XANTENNA__4919__S0 _1678_ VGND VGND VPWR VPWR sky130_fd_sc_hd__diode_2
X_9237_ clknet_leaf_81_clk _0334_ VGND VGND VPWR VPWR registers\[26\]\[21\] sky130_fd_sc_hd__dfxtp_1
XTAP_TAPCELL_ROW_95_1499 VGND VPWR sky130_fd_sc_hd__tapvpwrvgnd_1
XANTENNA__5107__S _1746_ VGND VGND VPWR VPWR sky130_fd_sc_hd__diode_2
X_9168_ clknet_leaf_61_clk _0265_ VGND VGND VPWR VPWR registers\[24\]\[16\] sky130_fd_sc_hd__dfxtp_1
XFILLER_0_100_176 VGND VGND VPWR VPWR sky130_fd_sc_hd__fill_2
XANTENNA__4395__S1 _1127_ VGND VGND VPWR VPWR sky130_fd_sc_hd__diode_2
XANTENNA__7238__A1 _3489_ VGND VGND VPWR VPWR sky130_fd_sc_hd__diode_2
X_8119_ _3999_ VGND VGND VPWR VPWR _0464_ sky130_fd_sc_hd__clkbuf_1
X_9099_ clknet_leaf_56_clk _0196_ VGND VGND VPWR VPWR registers\[22\]\[11\] sky130_fd_sc_hd__dfxtp_1
XANTENNA__8418__S _4153_ VGND VGND VPWR VPWR sky130_fd_sc_hd__diode_2
XANTENNA__7322__S _3575_ VGND VGND VPWR VPWR sky130_fd_sc_hd__diode_2
XFILLER_0_98_701 VPWR VGND VPWR VGND sky130_ef_sc_hd__decap_12
XTAP_TAPCELL_ROW_39_770 VGND VPWR sky130_fd_sc_hd__tapvpwrvgnd_1
XANTENNA__7410__A1 _3455_ VGND VGND VPWR VPWR sky130_fd_sc_hd__diode_2
XFILLER_0_38_300 VGND VGND VPWR VPWR sky130_fd_sc_hd__fill_2
XFILLER_0_109_711 VPWR VGND VPWR VGND sky130_ef_sc_hd__decap_12
XFILLER_0_108_243 VGND VGND VPWR VPWR sky130_fd_sc_hd__decap_4
XANTENNA__7992__S _3923_ VGND VGND VPWR VPWR sky130_fd_sc_hd__diode_2
XFILLER_0_26_528 VGND VGND VPWR VPWR sky130_fd_sc_hd__fill_2
XFILLER_0_80_111 VGND VGND VPWR VPWR sky130_fd_sc_hd__fill_2
XANTENNA__5724__A1 _1108_ VGND VGND VPWR VPWR sky130_fd_sc_hd__diode_2
XANTENNA__5806__A _2295_ VGND VGND VPWR VPWR sky130_fd_sc_hd__diode_2
XFILLER_0_79_19 VGND VGND VPWR VPWR sky130_fd_sc_hd__decap_3
XFILLER_0_22_701 VGND VGND VPWR VPWR sky130_fd_sc_hd__fill_2
XANTENNA__7293__A _3538_ VGND VGND VPWR VPWR sky130_fd_sc_hd__diode_2
XFILLER_0_34_561 VGND VGND VPWR VPWR sky130_fd_sc_hd__fill_2
XTAP_TAPCELL_ROW_59_1030 VGND VPWR sky130_fd_sc_hd__tapvpwrvgnd_1
XFILLER_0_1_617 VGND VGND VPWR VPWR sky130_fd_sc_hd__decap_3
XFILLER_0_22_723 VGND VGND VPWR VPWR sky130_fd_sc_hd__fill_1
XANTENNA__6401__S _3052_ VGND VGND VPWR VPWR sky130_fd_sc_hd__diode_2
XFILLER_0_34_583 VGND VGND VPWR VPWR sky130_fd_sc_hd__fill_2
XFILLER_0_61_391 VGND VGND VPWR VPWR sky130_fd_sc_hd__fill_1
XFILLER_0_0_149 VGND VGND VPWR VPWR sky130_fd_sc_hd__fill_1
XANTENNA__4386__S1 _1137_ VGND VGND VPWR VPWR sky130_fd_sc_hd__diode_2
XFILLER_0_28_23 VGND VGND VPWR VPWR sky130_fd_sc_hd__decap_3
XFILLER_0_119_69 VPWR VGND VPWR VGND sky130_ef_sc_hd__decap_12
XANTENNA__7232__S _3525_ VGND VGND VPWR VPWR sky130_fd_sc_hd__diode_2
XANTENNA__8328__S _4103_ VGND VGND VPWR VPWR sky130_fd_sc_hd__diode_2
XANTENNA__6356__B net12 VGND VGND VPWR VPWR sky130_fd_sc_hd__diode_2
XANTENNA__5335__S0 _2072_ VGND VGND VPWR VPWR sky130_fd_sc_hd__diode_2
XFILLER_0_28_89 VGND VGND VPWR VPWR sky130_fd_sc_hd__decap_4
XANTENNA__6988__A0 _3110_ VGND VGND VPWR VPWR sky130_fd_sc_hd__diode_2
XANTENNA__4463__A1 _1025_ VGND VGND VPWR VPWR sky130_fd_sc_hd__diode_2
XANTENNA__7401__A1 _3447_ VGND VGND VPWR VPWR sky130_fd_sc_hd__diode_2
X_5820_ net143 _2547_ VGND VGND VPWR VPWR _2548_ sky130_fd_sc_hd__xor2_1
X_5751_ _1050_ _1071_ _1090_ _1107_ VGND VGND VPWR VPWR _2482_ sky130_fd_sc_hd__or4_1
XFILLER_0_57_653 VPWR VGND VPWR VGND sky130_ef_sc_hd__decap_12
XFILLER_0_56_141 VGND VGND VPWR VPWR sky130_fd_sc_hd__fill_2
XTAP_TAPCELL_ROW_17_475 VGND VPWR sky130_fd_sc_hd__tapvpwrvgnd_1
XTAP_TAPCELL_ROW_17_486 VGND VPWR sky130_fd_sc_hd__tapvpwrvgnd_1
XFILLER_0_72_612 VGND VGND VPWR VPWR sky130_fd_sc_hd__fill_2
X_4702_ _1379_ _1478_ VGND VGND VPWR VPWR _1479_ sky130_fd_sc_hd__nand2_1
XFILLER_0_8_249 VGND VGND VPWR VPWR sky130_fd_sc_hd__decap_3
X_8470_ registers\[8\]\[29\] net37 _4175_ VGND VGND VPWR VPWR _4185_ sky130_fd_sc_hd__mux2_1
XFILLER_0_17_528 VGND VGND VPWR VPWR sky130_fd_sc_hd__fill_2
X_5682_ _2267_ _2310_ _2315_ VGND VGND VPWR VPWR _2416_ sky130_fd_sc_hd__a21bo_1
XFILLER_0_97_7 VGND VGND VPWR VPWR sky130_fd_sc_hd__decap_8
X_7421_ _3629_ VGND VGND VPWR VPWR _0136_ sky130_fd_sc_hd__clkbuf_1
XFILLER_0_60_76 VGND VGND VPWR VPWR sky130_fd_sc_hd__decap_3
XFILLER_0_114_213 VGND VGND VPWR VPWR sky130_fd_sc_hd__fill_1
XANTENNA__6912__A0 _3104_ VGND VGND VPWR VPWR sky130_fd_sc_hd__diode_2
X_4633_ _1372_ _1403_ _1409_ _1413_ VGND VGND VPWR VPWR _1414_ sky130_fd_sc_hd__a2bb2o_2
XANTENNA__7407__S _3612_ VGND VGND VPWR VPWR sky130_fd_sc_hd__diode_2
XFILLER_0_114_257 VGND VGND VPWR VPWR sky130_fd_sc_hd__fill_1
XANTENNA__6311__S _2983_ VGND VGND VPWR VPWR sky130_fd_sc_hd__diode_2
X_7352_ _3592_ VGND VGND VPWR VPWR _0104_ sky130_fd_sc_hd__clkbuf_1
X_4564_ _1324_ VGND VGND VPWR VPWR _1348_ sky130_fd_sc_hd__buf_4
XFILLER_0_4_466 VGND VGND VPWR VPWR sky130_fd_sc_hd__fill_2
XFILLER_0_12_200 VGND VGND VPWR VPWR sky130_fd_sc_hd__decap_3
X_6303_ _2992_ VGND VGND VPWR VPWR _0679_ sky130_fd_sc_hd__clkbuf_1
X_7283_ registers\[18\]\[15\] _3466_ _3550_ VGND VGND VPWR VPWR _3556_ sky130_fd_sc_hd__mux2_1
XFILLER_0_12_222 VGND VGND VPWR VPWR sky130_fd_sc_hd__fill_2
X_4495_ registers\[12\]\[12\] registers\[13\]\[12\] registers\[14\]\[12\] registers\[15\]\[12\]
+ _1201_ _1204_ VGND VGND VPWR VPWR _1283_ sky130_fd_sc_hd__mux4_1
X_6234_ _2182_ _2939_ VGND VGND VPWR VPWR _2940_ sky130_fd_sc_hd__and2_1
X_9022_ clknet_leaf_13_clk _0119_ VGND VGND VPWR VPWR registers\[1\]\[30\] sky130_fd_sc_hd__dfxtp_1
XFILLER_0_12_266 VGND VGND VPWR VPWR sky130_fd_sc_hd__fill_1
XANTENNA__6140__B2 _2321_ VGND VGND VPWR VPWR sky130_fd_sc_hd__diode_2
XFILLER_0_12_299 VGND VGND VPWR VPWR sky130_fd_sc_hd__decap_3
XFILLER_0_85_51 VGND VGND VPWR VPWR sky130_fd_sc_hd__decap_3
XANTENNA__7142__S _3456_ VGND VGND VPWR VPWR sky130_fd_sc_hd__diode_2
X_6165_ _2084_ _2827_ _2858_ _2101_ VGND VGND VPWR VPWR _2875_ sky130_fd_sc_hd__o22a_1
XFILLER_0_40_3 VGND VGND VPWR VPWR sky130_fd_sc_hd__fill_2
XANTENNA__4766__S _1346_ VGND VGND VPWR VPWR sky130_fd_sc_hd__diode_2
XFILLER_0_99_509 VGND VGND VPWR VPWR sky130_fd_sc_hd__fill_2
XFILLER_0_85_73 VGND VGND VPWR VPWR sky130_fd_sc_hd__fill_1
X_5116_ _1870_ _1871_ _1695_ VGND VGND VPWR VPWR _1872_ sky130_fd_sc_hd__mux2_1
X_6096_ _2267_ _2232_ _2373_ VGND VGND VPWR VPWR _2809_ sky130_fd_sc_hd__a21bo_1
XANTENNA__6981__S _3372_ VGND VGND VPWR VPWR sky130_fd_sc_hd__diode_2
X_5047_ registers\[4\]\[8\] registers\[5\]\[8\] registers\[6\]\[8\] registers\[7\]\[8\]
+ _1806_ _1759_ VGND VGND VPWR VPWR _1807_ sky130_fd_sc_hd__mux4_1
XFILLER_0_79_233 VGND VGND VPWR VPWR sky130_fd_sc_hd__fill_2
XFILLER_0_39_108 VGND VGND VPWR VPWR sky130_fd_sc_hd__fill_2
X_8806_ clknet_leaf_35_clk _0927_ VGND VGND VPWR VPWR registers\[13\]\[6\] sky130_fd_sc_hd__dfxtp_1
XANTENNA__6282__A net46 VGND VGND VPWR VPWR sky130_fd_sc_hd__diode_2
X_6998_ _3121_ registers\[14\]\[25\] _3383_ VGND VGND VPWR VPWR _3389_ sky130_fd_sc_hd__mux2_1
XFILLER_0_94_247 VGND VGND VPWR VPWR sky130_fd_sc_hd__decap_4
X_5949_ _2197_ _2198_ _2359_ _2413_ VGND VGND VPWR VPWR _2671_ sky130_fd_sc_hd__or4_1
XANTENNA__4301__S1 _1027_ VGND VGND VPWR VPWR sky130_fd_sc_hd__diode_2
X_8737_ clknet_leaf_6_clk _0858_ VGND VGND VPWR VPWR registers\[11\]\[1\] sky130_fd_sc_hd__dfxtp_1
XFILLER_0_48_664 VGND VGND VPWR VPWR sky130_fd_sc_hd__fill_2
XFILLER_0_48_697 VGND VGND VPWR VPWR sky130_fd_sc_hd__decap_3
XFILLER_0_47_174 VGND VGND VPWR VPWR sky130_fd_sc_hd__fill_2
X_8668_ clknet_leaf_108_clk _0789_ VGND VGND VPWR VPWR registers\[7\]\[28\] sky130_fd_sc_hd__dfxtp_1
XTAP_TAPCELL_ROW_97_1517 VGND VPWR sky130_fd_sc_hd__tapvpwrvgnd_1
X_7619_ _3734_ VGND VGND VPWR VPWR _0229_ sky130_fd_sc_hd__clkbuf_1
X_8599_ clknet_leaf_92_clk _0720_ VGND VGND VPWR VPWR registers\[3\]\[23\] sky130_fd_sc_hd__dfxtp_1
XFILLER_0_16_561 VGND VGND VPWR VPWR sky130_fd_sc_hd__decap_4
XFILLER_0_23_509 VGND VGND VPWR VPWR sky130_fd_sc_hd__fill_2
XFILLER_0_43_391 VGND VGND VPWR VPWR sky130_fd_sc_hd__fill_1
XFILLER_0_31_586 VGND VGND VPWR VPWR sky130_fd_sc_hd__fill_2
XANTENNA__4368__S1 _1161_ VGND VGND VPWR VPWR sky130_fd_sc_hd__diode_2
XANTENNA__8148__S _4009_ VGND VGND VPWR VPWR sky130_fd_sc_hd__diode_2
XANTENNA__7052__S _3409_ VGND VGND VPWR VPWR sky130_fd_sc_hd__diode_2
XANTENNA__6891__S _3324_ VGND VGND VPWR VPWR sky130_fd_sc_hd__diode_2
XANTENNA_input24_A wd3[17] VGND VGND VPWR VPWR sky130_fd_sc_hd__diode_2
XTAP_TAPCELL_ROW_106_1635 VGND VPWR sky130_fd_sc_hd__tapvpwrvgnd_1
XANTENNA__4540__S1 _1324_ VGND VGND VPWR VPWR sky130_fd_sc_hd__diode_2
XFILLER_0_58_406 VGND VGND VPWR VPWR sky130_fd_sc_hd__fill_2
XFILLER_0_98_586 VGND VGND VPWR VPWR sky130_fd_sc_hd__fill_2
XFILLER_0_85_225 VGND VGND VPWR VPWR sky130_fd_sc_hd__fill_2
XANTENNA__5300__S _1767_ VGND VGND VPWR VPWR sky130_fd_sc_hd__diode_2
XFILLER_0_85_247 VGND VGND VPWR VPWR sky130_fd_sc_hd__fill_2
XFILLER_0_73_409 VGND VGND VPWR VPWR sky130_fd_sc_hd__fill_2
XFILLER_0_39_653 VGND VGND VPWR VPWR sky130_fd_sc_hd__fill_2
XFILLER_0_39_664 VGND VGND VPWR VPWR sky130_fd_sc_hd__fill_2
XTAP_TAPCELL_ROW_14_445 VGND VPWR sky130_fd_sc_hd__tapvpwrvgnd_1
XFILLER_0_54_645 VGND VGND VPWR VPWR sky130_fd_sc_hd__fill_1
XFILLER_0_109_596 VGND VGND VPWR VPWR sky130_fd_sc_hd__decap_3
XANTENNA__5158__C1 _1702_ VGND VGND VPWR VPWR sky130_fd_sc_hd__diode_2
XANTENNA__5536__A _2270_ VGND VGND VPWR VPWR sky130_fd_sc_hd__diode_2
XANTENNA__6131__S _2353_ VGND VGND VPWR VPWR sky130_fd_sc_hd__diode_2
XFILLER_0_81_486 VGND VGND VPWR VPWR sky130_fd_sc_hd__fill_2
XFILLER_0_22_520 VGND VGND VPWR VPWR sky130_fd_sc_hd__fill_2
XFILLER_0_34_380 VGND VGND VPWR VPWR sky130_fd_sc_hd__fill_2
XTAP_TAPCELL_ROW_117_1775 VGND VPWR sky130_fd_sc_hd__tapvpwrvgnd_1
XFILLER_0_112_728 VGND VGND VPWR VPWR sky130_fd_sc_hd__decap_4
XTAP_TAPCELL_ROW_117_1786 VGND VPWR sky130_fd_sc_hd__tapvpwrvgnd_1
X_4280_ registers\[24\]\[2\] registers\[25\]\[2\] registers\[26\]\[2\] registers\[27\]\[2\]
+ _1060_ _1061_ VGND VGND VPWR VPWR _1078_ sky130_fd_sc_hd__mux4_1
XANTENNA__4586__S _1148_ VGND VGND VPWR VPWR sky130_fd_sc_hd__diode_2
XFILLER_0_39_88 VGND VGND VPWR VPWR sky130_fd_sc_hd__fill_2
XANTENNA__8058__S _3959_ VGND VGND VPWR VPWR sky130_fd_sc_hd__diode_2
XANTENNA__5308__S0 _1883_ VGND VGND VPWR VPWR sky130_fd_sc_hd__diode_2
XANTENNA__7897__S _3876_ VGND VGND VPWR VPWR sky130_fd_sc_hd__diode_2
X_7970_ _3920_ VGND VGND VPWR VPWR _0394_ sky130_fd_sc_hd__clkbuf_1
XFILLER_0_89_542 VGND VGND VPWR VPWR sky130_fd_sc_hd__decap_3
X_6921_ _3113_ registers\[13\]\[21\] _3346_ VGND VGND VPWR VPWR _3348_ sky130_fd_sc_hd__mux2_1
XFILLER_0_89_597 VPWR VGND VPWR VGND sky130_ef_sc_hd__decap_12
XTAP_TAPCELL_ROW_81_1307 VGND VPWR sky130_fd_sc_hd__tapvpwrvgnd_1
XFILLER_0_77_726 VGND VGND VPWR VPWR sky130_fd_sc_hd__fill_2
XFILLER_0_71_31 VGND VGND VPWR VPWR sky130_fd_sc_hd__fill_1
X_6852_ _3311_ VGND VGND VPWR VPWR _0909_ sky130_fd_sc_hd__clkbuf_1
XFILLER_0_119_305 VGND VGND VPWR VPWR sky130_fd_sc_hd__decap_3
XTAP_TAPCELL_ROW_81_1318 VGND VPWR sky130_fd_sc_hd__tapvpwrvgnd_1
X_5803_ _2529_ _2531_ VGND VGND VPWR VPWR _2532_ sky130_fd_sc_hd__nand2_1
XFILLER_0_71_64 VGND VGND VPWR VPWR sky130_fd_sc_hd__fill_2
XFILLER_0_9_514 VGND VGND VPWR VPWR sky130_fd_sc_hd__fill_2
XFILLER_0_119_349 VPWR VGND VPWR VGND sky130_ef_sc_hd__decap_12
XANTENNA__4295__S0 _1060_ VGND VGND VPWR VPWR sky130_fd_sc_hd__diode_2
X_6783_ registers\[11\]\[21\] _3006_ _3272_ VGND VGND VPWR VPWR _3274_ sky130_fd_sc_hd__mux2_1
X_8522_ registers\[4\]\[21\] net29 _4211_ VGND VGND VPWR VPWR _4213_ sky130_fd_sc_hd__mux2_1
X_5734_ _2279_ _2464_ _2465_ _2262_ VGND VGND VPWR VPWR _2466_ sky130_fd_sc_hd__o22a_1
XFILLER_0_17_325 VGND VGND VPWR VPWR sky130_fd_sc_hd__fill_2
XANTENNA__7689__A1 _3462_ VGND VGND VPWR VPWR sky130_fd_sc_hd__diode_2
X_5665_ _2329_ _2364_ _2393_ _2398_ _2399_ VGND VGND VPWR VPWR net60 sky130_fd_sc_hd__o32a_1
XFILLER_0_44_166 VGND VGND VPWR VPWR sky130_fd_sc_hd__decap_3
X_8453_ _4176_ VGND VGND VPWR VPWR _0621_ sky130_fd_sc_hd__clkbuf_1
XFILLER_0_115_555 VGND VGND VPWR VPWR sky130_fd_sc_hd__fill_2
XFILLER_0_88_3 VGND VGND VPWR VPWR sky130_fd_sc_hd__fill_1
X_7404_ _3620_ VGND VGND VPWR VPWR _0128_ sky130_fd_sc_hd__clkbuf_1
XANTENNA__4350__A _1145_ VGND VGND VPWR VPWR sky130_fd_sc_hd__diode_2
XFILLER_0_72_497 VGND VGND VPWR VPWR sky130_fd_sc_hd__fill_2
X_4616_ registers\[20\]\[19\] registers\[21\]\[19\] registers\[22\]\[19\] registers\[23\]\[19\]
+ _1338_ _1339_ VGND VGND VPWR VPWR _1397_ sky130_fd_sc_hd__mux4_1
XANTENNA__6361__A1 _2964_ VGND VGND VPWR VPWR sky130_fd_sc_hd__diode_2
X_8384_ registers\[5\]\[20\] _3476_ _4139_ VGND VGND VPWR VPWR _4140_ sky130_fd_sc_hd__mux2_1
XPHY_EDGE_ROW_111_Right_111 VGND VGND VPWR VPWR sky130_fd_sc_hd__decap_3
X_5596_ _1899_ _2215_ _2219_ VGND VGND VPWR VPWR _2331_ sky130_fd_sc_hd__o21ai_1
X_7335_ _3583_ VGND VGND VPWR VPWR _0096_ sky130_fd_sc_hd__clkbuf_1
XFILLER_0_4_285 VGND VGND VPWR VPWR sky130_fd_sc_hd__decap_4
X_4547_ _1132_ _1331_ _1025_ VGND VGND VPWR VPWR _1332_ sky130_fd_sc_hd__o21a_1
XANTENNA__7661__A _3756_ VGND VGND VPWR VPWR sky130_fd_sc_hd__diode_2
XFILLER_0_40_350 VGND VGND VPWR VPWR sky130_fd_sc_hd__decap_8
XFILLER_0_4_296 VGND VGND VPWR VPWR sky130_fd_sc_hd__fill_2
XFILLER_0_20_90 VGND VGND VPWR VPWR sky130_fd_sc_hd__fill_2
X_4478_ registers\[0\]\[11\] registers\[1\]\[11\] registers\[2\]\[11\] registers\[3\]\[11\]
+ _1197_ _1203_ VGND VGND VPWR VPWR _1267_ sky130_fd_sc_hd__mux4_1
XTAP_TAPCELL_ROW_92_1458 VGND VPWR sky130_fd_sc_hd__tapvpwrvgnd_1
X_7266_ registers\[18\]\[7\] _3449_ _3539_ VGND VGND VPWR VPWR _3547_ sky130_fd_sc_hd__mux2_1
X_7197_ _3510_ VGND VGND VPWR VPWR _0031_ sky130_fd_sc_hd__clkbuf_1
X_9005_ clknet_leaf_52_clk _0102_ VGND VGND VPWR VPWR registers\[1\]\[13\] sky130_fd_sc_hd__dfxtp_1
X_6217_ _2267_ _2254_ _2387_ VGND VGND VPWR VPWR _2924_ sky130_fd_sc_hd__a21oi_1
XANTENNA__4496__S _1131_ VGND VGND VPWR VPWR sky130_fd_sc_hd__diode_2
X_6148_ net98 _2858_ VGND VGND VPWR VPWR _2859_ sky130_fd_sc_hd__xnor2_1
XANTENNA__4770__S1 _1434_ VGND VGND VPWR VPWR sky130_fd_sc_hd__diode_2
X_6079_ _2228_ _2236_ VGND VGND VPWR VPWR _2793_ sky130_fd_sc_hd__nand2_1
XANTENNA__4427__A1 _1131_ VGND VGND VPWR VPWR sky130_fd_sc_hd__diode_2
XANTENNA__4522__S1 _1137_ VGND VGND VPWR VPWR sky130_fd_sc_hd__diode_2
XANTENNA__5120__S _1767_ VGND VGND VPWR VPWR sky130_fd_sc_hd__diode_2
XPHY_EDGE_ROW_109_Left_229 VGND VGND VPWR VPWR sky130_fd_sc_hd__decap_3
XFILLER_0_83_729 VGND VGND VPWR VPWR sky130_fd_sc_hd__fill_1
XANTENNA__8431__S _4164_ VGND VGND VPWR VPWR sky130_fd_sc_hd__diode_2
XFILLER_0_82_228 VGND VGND VPWR VPWR sky130_fd_sc_hd__fill_2
XFILLER_0_75_291 VGND VGND VPWR VPWR sky130_fd_sc_hd__decap_3
XTAP_TAPCELL_ROW_11_404 VGND VPWR sky130_fd_sc_hd__tapvpwrvgnd_1
XFILLER_0_35_111 VGND VGND VPWR VPWR sky130_fd_sc_hd__fill_1
XFILLER_0_35_122 VGND VGND VPWR VPWR sky130_fd_sc_hd__fill_2
XFILLER_0_36_645 VGND VGND VPWR VPWR sky130_fd_sc_hd__fill_1
XTAP_TAPCELL_ROW_101_1576 VGND VPWR sky130_fd_sc_hd__tapvpwrvgnd_1
XFILLER_0_90_250 VGND VGND VPWR VPWR sky130_fd_sc_hd__fill_2
XFILLER_0_35_177 VGND VGND VPWR VPWR sky130_fd_sc_hd__fill_2
XFILLER_0_106_599 VGND VGND VPWR VPWR sky130_fd_sc_hd__fill_2
XFILLER_0_31_361 VGND VGND VPWR VPWR sky130_fd_sc_hd__fill_2
XPHY_EDGE_ROW_118_Left_238 VGND VGND VPWR VPWR sky130_fd_sc_hd__decap_3
XANTENNA_clkbuf_leaf_61_clk_A clknet_4_14_0_clk VGND VGND VPWR VPWR sky130_fd_sc_hd__diode_2
XFILLER_0_31_383 VGND VGND VPWR VPWR sky130_fd_sc_hd__fill_2
XANTENNA__6187__A _2490_ VGND VGND VPWR VPWR sky130_fd_sc_hd__diode_2
XANTENNA__4761__S1 _1405_ VGND VGND VPWR VPWR sky130_fd_sc_hd__diode_2
XANTENNA_clkbuf_leaf_76_clk_A clknet_4_11_0_clk VGND VGND VPWR VPWR sky130_fd_sc_hd__diode_2
XFILLER_0_116_15 VPWR VGND VPWR VGND sky130_ef_sc_hd__decap_12
XFILLER_0_92_19 VGND VGND VPWR VPWR sky130_fd_sc_hd__fill_2
XTAP_TAPCELL_ROW_19_504 VGND VPWR sky130_fd_sc_hd__tapvpwrvgnd_1
XTAP_TAPCELL_ROW_47_868 VGND VPWR sky130_fd_sc_hd__tapvpwrvgnd_1
XFILLER_0_25_57 VGND VGND VPWR VPWR sky130_fd_sc_hd__fill_1
XFILLER_0_58_269 VGND VGND VPWR VPWR sky130_fd_sc_hd__decap_3
XANTENNA__4277__S0 _1039_ VGND VGND VPWR VPWR sky130_fd_sc_hd__diode_2
XFILLER_0_27_612 VGND VGND VPWR VPWR sky130_fd_sc_hd__fill_2
XFILLER_0_6_506 VGND VGND VPWR VPWR sky130_fd_sc_hd__fill_2
XTAP_TAPCELL_ROW_119_1815 VGND VPWR sky130_fd_sc_hd__tapvpwrvgnd_1
XTAP_TAPCELL_ROW_119_1804 VGND VPWR sky130_fd_sc_hd__tapvpwrvgnd_1
XANTENNA_clkbuf_leaf_14_clk_A clknet_4_6_0_clk VGND VGND VPWR VPWR sky130_fd_sc_hd__diode_2
XFILLER_0_27_667 VGND VGND VPWR VPWR sky130_fd_sc_hd__fill_2
XFILLER_0_81_261 VGND VGND VPWR VPWR sky130_fd_sc_hd__fill_1
XFILLER_0_54_475 VGND VGND VPWR VPWR sky130_fd_sc_hd__fill_1
XFILLER_0_26_166 VGND VGND VPWR VPWR sky130_fd_sc_hd__decap_4
X_5450_ _2183_ _2184_ _2185_ _2186_ _2076_ _2026_ VGND VGND VPWR VPWR _2187_ sky130_fd_sc_hd__mux4_2
XFILLER_0_112_503 VGND VGND VPWR VPWR sky130_fd_sc_hd__fill_2
X_4401_ _1192_ _1193_ _1132_ VGND VGND VPWR VPWR _1194_ sky130_fd_sc_hd__mux2_1
XFILLER_0_2_701 VGND VGND VPWR VPWR sky130_fd_sc_hd__fill_2
XANTENNA_clkbuf_leaf_29_clk_A clknet_4_5_0_clk VGND VGND VPWR VPWR sky130_fd_sc_hd__diode_2
XANTENNA__5697__A3 _1089_ VGND VGND VPWR VPWR sky130_fd_sc_hd__diode_2
X_5381_ registers\[28\]\[27\] registers\[29\]\[27\] registers\[30\]\[27\] registers\[31\]\[27\]
+ _2119_ _2120_ VGND VGND VPWR VPWR _2122_ sky130_fd_sc_hd__mux4_1
XFILLER_0_112_569 VGND VGND VPWR VPWR sky130_fd_sc_hd__fill_2
X_4332_ _1127_ VGND VGND VPWR VPWR _1128_ sky130_fd_sc_hd__buf_4
X_7120_ net19 VGND VGND VPWR VPWR _3460_ sky130_fd_sc_hd__buf_2
X_7051_ _3417_ VGND VGND VPWR VPWR _1002_ sky130_fd_sc_hd__clkbuf_1
X_4263_ registers\[12\]\[1\] registers\[13\]\[1\] registers\[14\]\[1\] registers\[15\]\[1\]
+ _1060_ _1061_ VGND VGND VPWR VPWR _1062_ sky130_fd_sc_hd__mux4_1
Xclkbuf_4_7_0_clk clknet_0_clk VGND VGND VPWR VPWR clknet_4_7_0_clk sky130_fd_sc_hd__clkbuf_8
X_6002_ _2317_ VGND VGND VPWR VPWR _2721_ sky130_fd_sc_hd__inv_2
XANTENNA__4752__S1 _1391_ VGND VGND VPWR VPWR sky130_fd_sc_hd__diode_2
XANTENNA__7420__S _3623_ VGND VGND VPWR VPWR sky130_fd_sc_hd__diode_2
XANTENNA__4504__S1 _1168_ VGND VGND VPWR VPWR sky130_fd_sc_hd__diode_2
XFILLER_0_96_309 VGND VGND VPWR VPWR sky130_fd_sc_hd__fill_2
X_7953_ _3911_ VGND VGND VPWR VPWR _0386_ sky130_fd_sc_hd__clkbuf_1
X_6904_ _3096_ registers\[13\]\[13\] _3335_ VGND VGND VPWR VPWR _3339_ sky130_fd_sc_hd__mux2_1
XFILLER_0_82_85 VGND VGND VPWR VPWR sky130_fd_sc_hd__decap_3
XANTENNA__8020__A1 _3453_ VGND VGND VPWR VPWR sky130_fd_sc_hd__diode_2
X_7884_ _3087_ registers\[27\]\[9\] _3865_ VGND VGND VPWR VPWR _3875_ sky130_fd_sc_hd__mux2_1
XANTENNA__4290__C1 net8 VGND VGND VPWR VPWR sky130_fd_sc_hd__diode_2
XFILLER_0_119_113 VPWR VGND VPWR VGND sky130_ef_sc_hd__decap_12
XANTENNA__6031__B1 _2748_ VGND VGND VPWR VPWR sky130_fd_sc_hd__diode_2
X_6835_ _3302_ VGND VGND VPWR VPWR _0901_ sky130_fd_sc_hd__clkbuf_1
XANTENNA__4268__S0 _1060_ VGND VGND VPWR VPWR sky130_fd_sc_hd__diode_2
XFILLER_0_9_333 VGND VGND VPWR VPWR sky130_fd_sc_hd__decap_3
XFILLER_0_119_157 VGND VGND VPWR VPWR sky130_fd_sc_hd__fill_1
XFILLER_0_92_537 VGND VGND VPWR VPWR sky130_fd_sc_hd__fill_1
X_6766_ registers\[11\]\[13\] _2989_ _3261_ VGND VGND VPWR VPWR _3265_ sky130_fd_sc_hd__mux2_1
X_9554_ clknet_leaf_66_clk _0651_ VGND VGND VPWR VPWR registers\[4\]\[18\] sky130_fd_sc_hd__dfxtp_1
XANTENNA__6582__A1 _3014_ VGND VGND VPWR VPWR sky130_fd_sc_hd__diode_2
XFILLER_0_17_100 VGND VGND VPWR VPWR sky130_fd_sc_hd__fill_1
X_8505_ registers\[4\]\[13\] net20 _4200_ VGND VGND VPWR VPWR _4204_ sky130_fd_sc_hd__mux2_1
X_5717_ _2332_ _2342_ _2293_ VGND VGND VPWR VPWR _2450_ sky130_fd_sc_hd__mux2_1
XFILLER_0_17_144 VGND VGND VPWR VPWR sky130_fd_sc_hd__fill_2
X_9485_ clknet_leaf_48_clk _0582_ VGND VGND VPWR VPWR registers\[5\]\[13\] sky130_fd_sc_hd__dfxtp_1
X_6697_ _3228_ VGND VGND VPWR VPWR _0837_ sky130_fd_sc_hd__clkbuf_1
XFILLER_0_33_615 VGND VGND VPWR VPWR sky130_fd_sc_hd__fill_1
XFILLER_0_115_352 VGND VGND VPWR VPWR sky130_fd_sc_hd__decap_3
X_5648_ _2267_ _2257_ VGND VGND VPWR VPWR _2383_ sky130_fd_sc_hd__nand2_1
X_8436_ _4167_ VGND VGND VPWR VPWR _0613_ sky130_fd_sc_hd__clkbuf_1
XFILLER_0_60_434 VGND VGND VPWR VPWR sky130_fd_sc_hd__fill_2
XFILLER_0_5_561 VGND VGND VPWR VPWR sky130_fd_sc_hd__fill_2
XFILLER_0_32_136 VGND VGND VPWR VPWR sky130_fd_sc_hd__fill_2
XFILLER_0_33_659 VGND VGND VPWR VPWR sky130_fd_sc_hd__fill_2
X_5579_ _2253_ _2314_ VGND VGND VPWR VPWR _2315_ sky130_fd_sc_hd__or2_1
X_8367_ registers\[5\]\[12\] _3460_ _4128_ VGND VGND VPWR VPWR _4131_ sky130_fd_sc_hd__mux2_1
XFILLER_0_32_169 VGND VGND VPWR VPWR sky130_fd_sc_hd__fill_1
X_8298_ _4094_ VGND VGND VPWR VPWR _0548_ sky130_fd_sc_hd__clkbuf_1
X_7318_ _3028_ _3501_ VGND VGND VPWR VPWR _3574_ sky130_fd_sc_hd__nor2_2
XFILLER_0_13_383 VGND VGND VPWR VPWR sky130_fd_sc_hd__decap_3
XANTENNA__5623__B _2310_ VGND VGND VPWR VPWR sky130_fd_sc_hd__diode_2
X_7249_ _3537_ VGND VGND VPWR VPWR _0056_ sky130_fd_sc_hd__clkbuf_1
XANTENNA__7330__S _3575_ VGND VGND VPWR VPWR sky130_fd_sc_hd__diode_2
XANTENNA__8426__S _4153_ VGND VGND VPWR VPWR sky130_fd_sc_hd__diode_2
XFILLER_0_99_169 VGND VGND VPWR VPWR sky130_fd_sc_hd__decap_4
XTAP_TAPCELL_ROW_44_827 VGND VPWR sky130_fd_sc_hd__tapvpwrvgnd_1
XANTENNA__4255__A a2[1] VGND VGND VPWR VPWR sky130_fd_sc_hd__diode_2
XFILLER_0_95_353 VGND VGND VPWR VPWR sky130_fd_sc_hd__fill_2
XFILLER_0_68_567 VGND VGND VPWR VPWR sky130_fd_sc_hd__decap_8
XANTENNA__4259__S0 _1053_ VGND VGND VPWR VPWR sky130_fd_sc_hd__diode_2
XANTENNA__8161__S _4020_ VGND VGND VPWR VPWR sky130_fd_sc_hd__diode_2
XFILLER_0_83_537 VGND VGND VPWR VPWR sky130_fd_sc_hd__decap_3
XANTENNA__7566__A _3683_ VGND VGND VPWR VPWR sky130_fd_sc_hd__diode_2
XTAP_TAPCELL_ROW_62_1070 VGND VPWR sky130_fd_sc_hd__tapvpwrvgnd_1
XTAP_TAPCELL_ROW_24_573 VGND VPWR sky130_fd_sc_hd__tapvpwrvgnd_1
XFILLER_0_102_39 VGND VGND VPWR VPWR sky130_fd_sc_hd__fill_2
XFILLER_0_36_475 VGND VGND VPWR VPWR sky130_fd_sc_hd__fill_1
XFILLER_0_106_363 VGND VGND VPWR VPWR sky130_fd_sc_hd__fill_1
XFILLER_0_24_648 VGND VGND VPWR VPWR sky130_fd_sc_hd__fill_2
XFILLER_0_51_467 VGND VGND VPWR VPWR sky130_fd_sc_hd__decap_8
XFILLER_0_23_169 VGND VGND VPWR VPWR sky130_fd_sc_hd__decap_3
XTAP_TAPCELL_ROW_114_1745 VGND VPWR sky130_fd_sc_hd__tapvpwrvgnd_1
XANTENNA__7505__S _3670_ VGND VGND VPWR VPWR sky130_fd_sc_hd__diode_2
XANTENNA__4982__S1 _1743_ VGND VGND VPWR VPWR sky130_fd_sc_hd__diode_2
XANTENNA__5533__B _2216_ VGND VGND VPWR VPWR sky130_fd_sc_hd__diode_2
XANTENNA__6089__B1 _2394_ VGND VGND VPWR VPWR sky130_fd_sc_hd__diode_2
XANTENNA__5025__S _1627_ VGND VGND VPWR VPWR sky130_fd_sc_hd__diode_2
XANTENNA__4734__S1 _1416_ VGND VGND VPWR VPWR sky130_fd_sc_hd__diode_2
XANTENNA__8336__S _4080_ VGND VGND VPWR VPWR sky130_fd_sc_hd__diode_2
Xinput8 a2[4] VGND VGND VPWR VPWR net8 sky130_fd_sc_hd__buf_4
XFILLER_0_36_23 VGND VGND VPWR VPWR sky130_fd_sc_hd__decap_3
XFILLER_0_78_309 VGND VGND VPWR VPWR sky130_fd_sc_hd__decap_3
XANTENNA__8250__A1 _3479_ VGND VGND VPWR VPWR sky130_fd_sc_hd__diode_2
XANTENNA__7240__S _3525_ VGND VGND VPWR VPWR sky130_fd_sc_hd__diode_2
XFILLER_0_99_670 VGND VGND VPWR VPWR sky130_fd_sc_hd__fill_2
XFILLER_0_36_89 VGND VGND VPWR VPWR sky130_fd_sc_hd__fill_1
X_4950_ _1634_ VGND VGND VPWR VPWR _1714_ sky130_fd_sc_hd__clkbuf_8
XFILLER_0_52_11 VGND VGND VPWR VPWR sky130_fd_sc_hd__decap_3
XFILLER_0_59_589 VGND VGND VPWR VPWR sky130_fd_sc_hd__decap_6
XFILLER_0_47_729 VGND VGND VPWR VPWR sky130_fd_sc_hd__fill_1
XANTENNA__8002__A1 _3433_ VGND VGND VPWR VPWR sky130_fd_sc_hd__diode_2
X_4881_ registers\[24\]\[1\] registers\[25\]\[1\] registers\[26\]\[1\] registers\[27\]\[1\]
+ _1642_ _1643_ VGND VGND VPWR VPWR _1648_ sky130_fd_sc_hd__mux4_1
XFILLER_0_117_617 VPWR VGND VPWR VGND sky130_ef_sc_hd__decap_12
X_6620_ _3174_ VGND VGND VPWR VPWR _3186_ sky130_fd_sc_hd__buf_4
X_6551_ registers\[7\]\[10\] _2982_ _3148_ VGND VGND VPWR VPWR _3149_ sky130_fd_sc_hd__mux2_1
XFILLER_0_109_190 VGND VGND VPWR VPWR sky130_fd_sc_hd__fill_2
X_5502_ _2230_ _2237_ _1072_ VGND VGND VPWR VPWR _2238_ sky130_fd_sc_hd__mux2_1
XFILLER_0_15_615 VGND VGND VPWR VPWR sky130_fd_sc_hd__fill_1
XFILLER_0_27_475 VGND VGND VPWR VPWR sky130_fd_sc_hd__fill_1
X_6482_ _3104_ registers\[29\]\[17\] _3090_ VGND VGND VPWR VPWR _3105_ sky130_fd_sc_hd__mux2_1
XFILLER_0_14_114 VGND VGND VPWR VPWR sky130_fd_sc_hd__decap_4
X_9270_ clknet_leaf_94_clk _0367_ VGND VGND VPWR VPWR registers\[27\]\[22\] sky130_fd_sc_hd__dfxtp_1
X_8221_ _4053_ VGND VGND VPWR VPWR _0512_ sky130_fd_sc_hd__clkbuf_1
X_5433_ registers\[28\]\[30\] registers\[29\]\[30\] registers\[30\]\[30\] registers\[31\]\[30\]
+ _2027_ _2028_ VGND VGND VPWR VPWR _2171_ sky130_fd_sc_hd__mux4_1
X_8152_ registers\[9\]\[7\] _3449_ _4009_ VGND VGND VPWR VPWR _4017_ sky130_fd_sc_hd__mux2_1
X_5364_ registers\[24\]\[26\] registers\[25\]\[26\] registers\[26\]\[26\] registers\[27\]\[26\]
+ _1996_ _1997_ VGND VGND VPWR VPWR _2106_ sky130_fd_sc_hd__mux4_1
XANTENNA__4973__S1 _1691_ VGND VGND VPWR VPWR sky130_fd_sc_hd__diode_2
X_7103_ _3448_ VGND VGND VPWR VPWR _1023_ sky130_fd_sc_hd__clkbuf_1
X_4315_ _1110_ VGND VGND VPWR VPWR _1111_ sky130_fd_sc_hd__buf_4
XFILLER_0_22_191 VGND VGND VPWR VPWR sky130_fd_sc_hd__fill_1
X_8083_ _3980_ VGND VGND VPWR VPWR _0447_ sky130_fd_sc_hd__clkbuf_1
X_5295_ registers\[12\]\[22\] registers\[13\]\[22\] registers\[14\]\[22\] registers\[15\]\[22\]
+ _1806_ _1759_ VGND VGND VPWR VPWR _2041_ sky130_fd_sc_hd__mux4_1
XFILLER_0_10_386 VGND VGND VPWR VPWR sky130_fd_sc_hd__decap_4
X_7034_ _3408_ VGND VGND VPWR VPWR _0994_ sky130_fd_sc_hd__clkbuf_1
X_4246_ registers\[0\]\[0\] registers\[1\]\[0\] registers\[2\]\[0\] registers\[3\]\[0\]
+ _1039_ _1040_ VGND VGND VPWR VPWR _1046_ sky130_fd_sc_hd__mux4_1
XANTENNA__4774__S _1362_ VGND VGND VPWR VPWR sky130_fd_sc_hd__diode_2
XANTENNA__8241__A1 _3470_ VGND VGND VPWR VPWR sky130_fd_sc_hd__diode_2
XFILLER_0_117_91 VGND VGND VPWR VPWR sky130_fd_sc_hd__fill_2
XFILLER_0_96_128 VGND VGND VPWR VPWR sky130_fd_sc_hd__fill_1
XTAP_TAPCELL_ROW_2_279 VGND VPWR sky130_fd_sc_hd__tapvpwrvgnd_1
X_8985_ clknet_leaf_80_clk _0082_ VGND VGND VPWR VPWR registers\[18\]\[25\] sky130_fd_sc_hd__dfxtp_1
XANTENNA__5150__S1 _1687_ VGND VGND VPWR VPWR sky130_fd_sc_hd__diode_2
XFILLER_0_89_191 VGND VGND VPWR VPWR sky130_fd_sc_hd__fill_2
X_7936_ _2964_ registers\[28\]\[1\] _3901_ VGND VGND VPWR VPWR _3903_ sky130_fd_sc_hd__mux2_1
X_7867_ _3866_ VGND VGND VPWR VPWR _0345_ sky130_fd_sc_hd__clkbuf_1
XFILLER_0_108_617 VGND VGND VPWR VPWR sky130_fd_sc_hd__fill_2
X_6818_ _3293_ VGND VGND VPWR VPWR _0893_ sky130_fd_sc_hd__clkbuf_1
XFILLER_0_92_334 VGND VGND VPWR VPWR sky130_fd_sc_hd__fill_1
XFILLER_0_65_526 VGND VGND VPWR VPWR sky130_fd_sc_hd__fill_2
XFILLER_0_65_559 VGND VGND VPWR VPWR sky130_fd_sc_hd__fill_1
XFILLER_0_9_174 VGND VGND VPWR VPWR sky130_fd_sc_hd__fill_2
X_7798_ _3065_ registers\[26\]\[0\] _3829_ VGND VGND VPWR VPWR _3830_ sky130_fd_sc_hd__mux2_1
X_6749_ registers\[11\]\[5\] _2972_ _3250_ VGND VGND VPWR VPWR _3256_ sky130_fd_sc_hd__mux2_1
XFILLER_0_80_518 VGND VGND VPWR VPWR sky130_fd_sc_hd__fill_2
X_9537_ clknet_leaf_6_clk _0634_ VGND VGND VPWR VPWR registers\[4\]\[1\] sky130_fd_sc_hd__dfxtp_1
XFILLER_0_18_464 VGND VGND VPWR VPWR sky130_fd_sc_hd__fill_2
XTAP_TAPCELL_ROW_21_532 VGND VPWR sky130_fd_sc_hd__tapvpwrvgnd_1
XFILLER_0_61_732 VGND VGND VPWR VPWR sky130_fd_sc_hd__fill_1
X_9468_ clknet_leaf_103_clk _0565_ VGND VGND VPWR VPWR registers\[31\]\[28\] sky130_fd_sc_hd__dfxtp_1
XFILLER_0_18_497 VGND VGND VPWR VPWR sky130_fd_sc_hd__fill_2
XFILLER_0_115_160 VGND VGND VPWR VPWR sky130_fd_sc_hd__decap_8
X_8419_ _4158_ VGND VGND VPWR VPWR _0605_ sky130_fd_sc_hd__clkbuf_1
XFILLER_0_103_311 VGND VGND VPWR VPWR sky130_fd_sc_hd__fill_1
XANTENNA__4949__S _1687_ VGND VGND VPWR VPWR sky130_fd_sc_hd__diode_2
XFILLER_0_60_253 VGND VGND VPWR VPWR sky130_fd_sc_hd__fill_1
XFILLER_0_5_391 VGND VGND VPWR VPWR sky130_fd_sc_hd__fill_1
XFILLER_0_21_607 VGND VGND VPWR VPWR sky130_fd_sc_hd__decap_8
XFILLER_0_33_467 VGND VGND VPWR VPWR sky130_fd_sc_hd__fill_2
XFILLER_0_60_297 VGND VGND VPWR VPWR sky130_fd_sc_hd__fill_2
X_9399_ clknet_leaf_70_clk _0496_ VGND VGND VPWR VPWR registers\[9\]\[23\] sky130_fd_sc_hd__dfxtp_1
XANTENNA__4964__S1 _1679_ VGND VGND VPWR VPWR sky130_fd_sc_hd__diode_2
XANTENNA__8480__A1 net27 VGND VGND VPWR VPWR sky130_fd_sc_hd__diode_2
XANTENNA__4716__S1 _1434_ VGND VGND VPWR VPWR sky130_fd_sc_hd__diode_2
XANTENNA__8156__S _4009_ VGND VGND VPWR VPWR sky130_fd_sc_hd__diode_2
XFILLER_0_87_106 VGND VGND VPWR VPWR sky130_fd_sc_hd__decap_3
XTAP_TAPCELL_ROW_29_632 VGND VPWR sky130_fd_sc_hd__tapvpwrvgnd_1
XFILLER_0_96_640 VGND VGND VPWR VPWR sky130_fd_sc_hd__fill_2
XANTENNA__5141__S1 _1749_ VGND VGND VPWR VPWR sky130_fd_sc_hd__diode_2
XTAP_TAPCELL_ROW_57_996 VGND VPWR sky130_fd_sc_hd__tapvpwrvgnd_1
XFILLER_0_29_729 VGND VGND VPWR VPWR sky130_fd_sc_hd__fill_1
XFILLER_0_113_38 VGND VGND VPWR VPWR sky130_fd_sc_hd__fill_2
XFILLER_0_56_537 VGND VGND VPWR VPWR sky130_fd_sc_hd__fill_1
XANTENNA__6546__A1 _2978_ VGND VGND VPWR VPWR sky130_fd_sc_hd__diode_2
XFILLER_0_118_7 VGND VGND VPWR VPWR sky130_fd_sc_hd__fill_2
XFILLER_0_98_29 VGND VGND VPWR VPWR sky130_fd_sc_hd__fill_2
XFILLER_0_51_220 VGND VGND VPWR VPWR sky130_fd_sc_hd__fill_2
XFILLER_0_107_694 VPWR VGND VPWR VGND sky130_ef_sc_hd__decap_12
X_5080_ _1836_ _1837_ _1767_ VGND VGND VPWR VPWR _1838_ sky130_fd_sc_hd__mux2_1
XANTENNA__6482__A0 _3104_ VGND VGND VPWR VPWR sky130_fd_sc_hd__diode_2
XANTENNA__8066__S _3936_ VGND VGND VPWR VPWR sky130_fd_sc_hd__diode_2
XANTENNA__5380__S1 _2120_ VGND VGND VPWR VPWR sky130_fd_sc_hd__diode_2
XANTENNA__6806__C net11 VGND VGND VPWR VPWR sky130_fd_sc_hd__diode_2
XFILLER_0_78_117 VPWR VGND VPWR VGND sky130_ef_sc_hd__decap_12
XANTENNA__5132__S1 _1692_ VGND VGND VPWR VPWR sky130_fd_sc_hd__diode_2
X_5982_ _2662_ _2664_ _2682_ _2701_ _2683_ VGND VGND VPWR VPWR _2702_ sky130_fd_sc_hd__a32o_1
X_8770_ clknet_leaf_2_clk _0891_ VGND VGND VPWR VPWR registers\[12\]\[2\] sky130_fd_sc_hd__dfxtp_1
XFILLER_0_87_673 VGND VGND VPWR VPWR sky130_fd_sc_hd__decap_6
XFILLER_0_87_662 VGND VGND VPWR VPWR sky130_fd_sc_hd__decap_8
XFILLER_0_86_150 VGND VGND VPWR VPWR sky130_fd_sc_hd__decap_4
X_4933_ registers\[4\]\[3\] registers\[5\]\[3\] registers\[6\]\[3\] registers\[7\]\[3\]
+ _1678_ _1679_ VGND VGND VPWR VPWR _1698_ sky130_fd_sc_hd__mux4_1
X_7721_ _3788_ VGND VGND VPWR VPWR _0277_ sky130_fd_sc_hd__clkbuf_1
XANTENNA__4796__B1 _1372_ VGND VGND VPWR VPWR sky130_fd_sc_hd__diode_2
XFILLER_0_86_183 VGND VGND VPWR VPWR sky130_fd_sc_hd__fill_1
XANTENNA__6314__S _2983_ VGND VGND VPWR VPWR sky130_fd_sc_hd__diode_2
XFILLER_0_47_548 VGND VGND VPWR VPWR sky130_fd_sc_hd__fill_2
XFILLER_0_19_228 VGND VGND VPWR VPWR sky130_fd_sc_hd__decap_4
XFILLER_0_86_194 VGND VGND VPWR VPWR sky130_fd_sc_hd__fill_2
XANTENNA__4623__A _1323_ VGND VGND VPWR VPWR sky130_fd_sc_hd__diode_2
XFILLER_0_47_559 VGND VGND VPWR VPWR sky130_fd_sc_hd__fill_1
X_4864_ registers\[8\]\[0\] registers\[9\]\[0\] registers\[10\]\[0\] registers\[11\]\[0\]
+ _1617_ _1618_ VGND VGND VPWR VPWR _1632_ sky130_fd_sc_hd__mux4_1
XFILLER_0_7_612 VGND VGND VPWR VPWR sky130_fd_sc_hd__fill_1
XFILLER_0_7_601 VGND VGND VPWR VPWR sky130_fd_sc_hd__decap_6
X_7652_ _3751_ VGND VGND VPWR VPWR _0245_ sky130_fd_sc_hd__clkbuf_1
XFILLER_0_117_458 VGND VGND VPWR VPWR sky130_fd_sc_hd__fill_2
XFILLER_0_117_447 VGND VGND VPWR VPWR sky130_fd_sc_hd__fill_1
XFILLER_0_55_570 VGND VGND VPWR VPWR sky130_fd_sc_hd__decap_4
X_6603_ _3177_ VGND VGND VPWR VPWR _0794_ sky130_fd_sc_hd__clkbuf_1
XFILLER_0_7_656 VGND VGND VPWR VPWR sky130_fd_sc_hd__fill_2
X_4795_ _1565_ _1566_ _1513_ VGND VGND VPWR VPWR _1567_ sky130_fd_sc_hd__mux2_1
X_7583_ _3127_ registers\[22\]\[28\] _3706_ VGND VGND VPWR VPWR _3715_ sky130_fd_sc_hd__mux2_1
X_9322_ clknet_leaf_40_clk _0419_ VGND VGND VPWR VPWR registers\[2\]\[10\] sky130_fd_sc_hd__dfxtp_1
XFILLER_0_6_166 VGND VGND VPWR VPWR sky130_fd_sc_hd__fill_1
XFILLER_0_12_80 VGND VGND VPWR VPWR sky130_fd_sc_hd__fill_2
XANTENNA__4643__S0 _1418_ VGND VGND VPWR VPWR sky130_fd_sc_hd__diode_2
X_6534_ registers\[7\]\[2\] _2966_ _3137_ VGND VGND VPWR VPWR _3140_ sky130_fd_sc_hd__mux2_1
X_6465_ _3093_ VGND VGND VPWR VPWR _0740_ sky130_fd_sc_hd__clkbuf_1
X_9253_ clknet_leaf_26_clk _0350_ VGND VGND VPWR VPWR registers\[27\]\[5\] sky130_fd_sc_hd__dfxtp_1
XFILLER_0_42_253 VGND VGND VPWR VPWR sky130_fd_sc_hd__fill_2
XFILLER_0_6_188 VGND VGND VPWR VPWR sky130_fd_sc_hd__decap_3
XFILLER_0_15_478 VGND VGND VPWR VPWR sky130_fd_sc_hd__fill_2
XFILLER_0_113_653 VGND VGND VPWR VPWR sky130_fd_sc_hd__fill_1
XFILLER_0_112_141 VGND VGND VPWR VPWR sky130_fd_sc_hd__decap_3
X_8204_ _3135_ _3212_ VGND VGND VPWR VPWR _4044_ sky130_fd_sc_hd__nor2_2
X_5416_ _2153_ _2154_ _2081_ VGND VGND VPWR VPWR _2155_ sky130_fd_sc_hd__mux2_1
XFILLER_0_113_697 VPWR VGND VPWR VGND sky130_ef_sc_hd__decap_12
XANTENNA__4946__S1 _1706_ VGND VGND VPWR VPWR sky130_fd_sc_hd__diode_2
Xoutput142 net142 VGND VGND VPWR VPWR rd2[7] sky130_fd_sc_hd__buf_1
Xoutput120 net120 VGND VGND VPWR VPWR rd2[16] sky130_fd_sc_hd__buf_1
X_6396_ registers\[3\]\[18\] _2999_ _3041_ VGND VGND VPWR VPWR _3050_ sky130_fd_sc_hd__mux2_1
Xoutput131 net131 VGND VGND VPWR VPWR rd2[26] sky130_fd_sc_hd__buf_1
X_9184_ clknet_leaf_110_clk _0281_ VGND VGND VPWR VPWR registers\[25\]\[0\] sky130_fd_sc_hd__dfxtp_1
X_5347_ _2088_ _2089_ _1768_ VGND VGND VPWR VPWR _2090_ sky130_fd_sc_hd__mux2_1
XFILLER_0_10_150 VGND VGND VPWR VPWR sky130_fd_sc_hd__fill_1
X_8135_ _4007_ VGND VGND VPWR VPWR _0472_ sky130_fd_sc_hd__clkbuf_1
XANTENNA__8462__A1 net33 VGND VGND VPWR VPWR sky130_fd_sc_hd__diode_2
XTAP_TAPCELL_ROW_7_349 VGND VPWR sky130_fd_sc_hd__tapvpwrvgnd_1
X_5278_ _2019_ _2024_ VGND VGND VPWR VPWR _2025_ sky130_fd_sc_hd__nand2_1
X_8066_ registers\[2\]\[31\] _3499_ _3936_ VGND VGND VPWR VPWR _3971_ sky130_fd_sc_hd__mux2_1
XTAP_TAPCELL_ROW_89_1419 VGND VPWR sky130_fd_sc_hd__tapvpwrvgnd_1
X_7017_ _3071_ registers\[15\]\[1\] _3398_ VGND VGND VPWR VPWR _3400_ sky130_fd_sc_hd__mux2_1
X_4229_ registers\[16\]\[0\] registers\[17\]\[0\] registers\[18\]\[0\] registers\[19\]\[0\]
+ _1026_ _1027_ VGND VGND VPWR VPWR _1029_ sky130_fd_sc_hd__mux4_1
XANTENNA__8214__A1 _3443_ VGND VGND VPWR VPWR sky130_fd_sc_hd__diode_2
XANTENNA__6285__A net47 VGND VGND VPWR VPWR sky130_fd_sc_hd__diode_2
XFILLER_0_97_426 VGND VGND VPWR VPWR sky130_fd_sc_hd__fill_2
XFILLER_0_97_437 VGND VGND VPWR VPWR sky130_fd_sc_hd__fill_2
XANTENNA__5123__S1 _1811_ VGND VGND VPWR VPWR sky130_fd_sc_hd__diode_2
X_8968_ clknet_leaf_8_clk _0065_ VGND VGND VPWR VPWR registers\[18\]\[8\] sky130_fd_sc_hd__dfxtp_1
XTAP_TAPCELL_ROW_26_602 VGND VPWR sky130_fd_sc_hd__tapvpwrvgnd_1
XTAP_TAPCELL_ROW_54_955 VGND VPWR sky130_fd_sc_hd__tapvpwrvgnd_1
X_7919_ _3893_ VGND VGND VPWR VPWR _0370_ sky130_fd_sc_hd__clkbuf_1
XFILLER_0_93_621 VGND VGND VPWR VPWR sky130_fd_sc_hd__decap_3
X_8899_ clknet_leaf_21_clk _1020_ VGND VGND VPWR VPWR registers\[16\]\[3\] sky130_fd_sc_hd__dfxtp_1
XTAP_TAPCELL_ROW_54_966 VGND VPWR sky130_fd_sc_hd__tapvpwrvgnd_1
XFILLER_0_38_548 VGND VGND VPWR VPWR sky130_fd_sc_hd__fill_2
XFILLER_0_38_537 VGND VGND VPWR VPWR sky130_fd_sc_hd__decap_4
XFILLER_0_92_164 VGND VGND VPWR VPWR sky130_fd_sc_hd__decap_3
XFILLER_0_53_529 VGND VGND VPWR VPWR sky130_fd_sc_hd__decap_4
XFILLER_0_108_469 VGND VGND VPWR VPWR sky130_fd_sc_hd__decap_6
XFILLER_0_92_197 VGND VGND VPWR VPWR sky130_fd_sc_hd__fill_1
XFILLER_0_61_573 VGND VGND VPWR VPWR sky130_fd_sc_hd__fill_1
XFILLER_0_61_551 VGND VGND VPWR VPWR sky130_fd_sc_hd__decap_3
XFILLER_0_104_653 VGND VGND VPWR VPWR sky130_fd_sc_hd__decap_3
XFILLER_0_21_415 VGND VGND VPWR VPWR sky130_fd_sc_hd__fill_2
XTAP_TAPCELL_ROW_111_1704 VGND VPWR sky130_fd_sc_hd__tapvpwrvgnd_1
XFILLER_0_104_697 VGND VGND VPWR VPWR sky130_fd_sc_hd__decap_3
XANTENNA__6700__A1 _2991_ VGND VGND VPWR VPWR sky130_fd_sc_hd__diode_2
XANTENNA__6464__A0 _3092_ VGND VGND VPWR VPWR sky130_fd_sc_hd__diode_2
XFILLER_0_17_14 VGND VGND VPWR VPWR sky130_fd_sc_hd__fill_2
XFILLER_0_88_415 VGND VGND VPWR VPWR sky130_fd_sc_hd__fill_2
XTAP_TAPCELL_ROW_109_1677 VGND VPWR sky130_fd_sc_hd__tapvpwrvgnd_1
XANTENNA__5114__S1 _1799_ VGND VGND VPWR VPWR sky130_fd_sc_hd__diode_2
XFILLER_0_69_673 VGND VGND VPWR VPWR sky130_fd_sc_hd__fill_2
XFILLER_0_68_172 VGND VGND VPWR VPWR sky130_fd_sc_hd__fill_2
XFILLER_0_68_161 VGND VGND VPWR VPWR sky130_fd_sc_hd__decap_4
XFILLER_0_56_323 VGND VGND VPWR VPWR sky130_fd_sc_hd__fill_1
XFILLER_0_33_57 VGND VGND VPWR VPWR sky130_fd_sc_hd__fill_1
XFILLER_0_84_654 VGND VGND VPWR VPWR sky130_fd_sc_hd__fill_2
XANTENNA__4443__A _1116_ VGND VGND VPWR VPWR sky130_fd_sc_hd__diode_2
XANTENNA__7192__A1 _3443_ VGND VGND VPWR VPWR sky130_fd_sc_hd__diode_2
XFILLER_0_83_175 VGND VGND VPWR VPWR sky130_fd_sc_hd__fill_1
Xinput22 wd3[15] VGND VGND VPWR VPWR net22 sky130_fd_sc_hd__buf_2
X_4580_ registers\[8\]\[17\] registers\[9\]\[17\] registers\[10\]\[17\] registers\[11\]\[17\]
+ _1323_ _1324_ VGND VGND VPWR VPWR _1363_ sky130_fd_sc_hd__mux4_1
XFILLER_0_71_337 VGND VGND VPWR VPWR sky130_fd_sc_hd__decap_4
XANTENNA__4625__S0 _1404_ VGND VGND VPWR VPWR sky130_fd_sc_hd__diode_2
Xinput11 a3[2] VGND VGND VPWR VPWR net11 sky130_fd_sc_hd__clkbuf_2
XFILLER_0_109_3 VGND VGND VPWR VPWR sky130_fd_sc_hd__fill_2
Xinput44 wd3[6] VGND VGND VPWR VPWR net44 sky130_fd_sc_hd__clkbuf_2
Xinput33 wd3[25] VGND VGND VPWR VPWR net33 sky130_fd_sc_hd__clkbuf_4
XFILLER_0_4_637 VGND VGND VPWR VPWR sky130_fd_sc_hd__decap_4
XFILLER_0_3_125 VGND VGND VPWR VPWR sky130_fd_sc_hd__decap_4
XANTENNA__5274__A _1765_ VGND VGND VPWR VPWR sky130_fd_sc_hd__diode_2
X_6250_ _2297_ _2889_ _2954_ VGND VGND VPWR VPWR _2955_ sky130_fd_sc_hd__a21o_1
XTAP_TAPCELL_ROW_73_1209 VGND VPWR sky130_fd_sc_hd__tapvpwrvgnd_1
XANTENNA__4928__S1 _1692_ VGND VGND VPWR VPWR sky130_fd_sc_hd__diode_2
XFILLER_0_110_634 VGND VGND VPWR VPWR sky130_fd_sc_hd__decap_4
X_6181_ _2270_ _2889_ _2467_ VGND VGND VPWR VPWR _2890_ sky130_fd_sc_hd__a21o_1
X_5201_ registers\[8\]\[17\] registers\[9\]\[17\] registers\[10\]\[17\] registers\[11\]\[17\]
+ _1773_ _1821_ VGND VGND VPWR VPWR _1952_ sky130_fd_sc_hd__mux4_1
X_5132_ registers\[28\]\[13\] registers\[29\]\[13\] registers\[30\]\[13\] registers\[31\]\[13\]
+ _1883_ _1692_ VGND VGND VPWR VPWR _1887_ sky130_fd_sc_hd__mux4_1
XTAP_TAPCELL_ROW_4_308 VGND VPWR sky130_fd_sc_hd__tapvpwrvgnd_1
XANTENNA__5258__A1 _1856_ VGND VGND VPWR VPWR sky130_fd_sc_hd__diode_2
XANTENNA__5213__S _1746_ VGND VGND VPWR VPWR sky130_fd_sc_hd__diode_2
X_5063_ registers\[24\]\[9\] registers\[25\]\[9\] registers\[26\]\[9\] registers\[27\]\[9\]
+ _1820_ _1821_ VGND VGND VPWR VPWR _1822_ sky130_fd_sc_hd__mux4_1
XFILLER_0_74_64 VGND VGND VPWR VPWR sky130_fd_sc_hd__fill_1
XANTENNA__6207__B1 _2399_ VGND VGND VPWR VPWR sky130_fd_sc_hd__diode_2
X_8822_ clknet_leaf_95_clk _0943_ VGND VGND VPWR VPWR registers\[13\]\[22\] sky130_fd_sc_hd__dfxtp_1
XANTENNA__8524__S _4211_ VGND VGND VPWR VPWR sky130_fd_sc_hd__diode_2
XFILLER_0_94_418 VGND VGND VPWR VPWR sky130_fd_sc_hd__fill_2
XANTENNA__5105__S1 _1775_ VGND VGND VPWR VPWR sky130_fd_sc_hd__diode_2
XTAP_TAPCELL_ROW_84_1349 VGND VPWR sky130_fd_sc_hd__tapvpwrvgnd_1
XFILLER_0_66_109 VGND VGND VPWR VPWR sky130_fd_sc_hd__fill_1
X_8753_ clknet_leaf_63_clk _0874_ VGND VGND VPWR VPWR registers\[11\]\[17\] sky130_fd_sc_hd__dfxtp_1
X_5965_ _2682_ _2684_ _2685_ VGND VGND VPWR VPWR _2686_ sky130_fd_sc_hd__o21a_1
XANTENNA__4864__S0 _1617_ VGND VGND VPWR VPWR sky130_fd_sc_hd__diode_2
XFILLER_0_118_701 VPWR VGND VPWR VGND sky130_ef_sc_hd__decap_12
XFILLER_0_114_70 VGND VGND VPWR VPWR sky130_fd_sc_hd__fill_1
X_5896_ _2452_ _2587_ _2619_ _2560_ _2620_ VGND VGND VPWR VPWR _2621_ sky130_fd_sc_hd__o221a_1
XFILLER_0_90_85 VGND VGND VPWR VPWR sky130_fd_sc_hd__fill_2
XANTENNA__4353__A _1116_ VGND VGND VPWR VPWR sky130_fd_sc_hd__diode_2
X_8684_ clknet_leaf_45_clk _0805_ VGND VGND VPWR VPWR registers\[0\]\[12\] sky130_fd_sc_hd__dfxtp_1
X_4916_ registers\[16\]\[3\] registers\[17\]\[3\] registers\[18\]\[3\] registers\[19\]\[3\]
+ _1678_ _1679_ VGND VGND VPWR VPWR _1681_ sky130_fd_sc_hd__mux4_1
XTAP_TAPCELL_ROW_51_925 VGND VPWR sky130_fd_sc_hd__tapvpwrvgnd_1
X_7704_ registers\[24\]\[20\] _3476_ _3779_ VGND VGND VPWR VPWR _3780_ sky130_fd_sc_hd__mux2_1
XFILLER_0_90_602 VGND VGND VPWR VPWR sky130_fd_sc_hd__decap_8
XANTENNA__6979__S _3372_ VGND VGND VPWR VPWR sky130_fd_sc_hd__diode_2
X_4847_ _1615_ VGND VGND VPWR VPWR net137 sky130_fd_sc_hd__buf_1
XFILLER_0_16_710 VPWR VGND VPWR VGND sky130_ef_sc_hd__decap_12
X_7635_ _3110_ registers\[23\]\[20\] _3742_ VGND VGND VPWR VPWR _3743_ sky130_fd_sc_hd__mux2_1
XFILLER_0_35_529 VGND VGND VPWR VPWR sky130_fd_sc_hd__fill_2
XFILLER_0_117_244 VGND VGND VPWR VPWR sky130_fd_sc_hd__fill_1
XANTENNA__4616__S0 _1338_ VGND VGND VPWR VPWR sky130_fd_sc_hd__diode_2
XFILLER_0_62_337 VGND VGND VPWR VPWR sky130_fd_sc_hd__fill_2
XFILLER_0_62_326 VGND VGND VPWR VPWR sky130_fd_sc_hd__decap_4
XFILLER_0_7_453 VGND VGND VPWR VPWR sky130_fd_sc_hd__decap_3
XTAP_TAPCELL_ROW_31_660 VGND VPWR sky130_fd_sc_hd__tapvpwrvgnd_1
XFILLER_0_99_61 VGND VGND VPWR VPWR sky130_fd_sc_hd__fill_2
X_9305_ clknet_leaf_81_clk _0402_ VGND VGND VPWR VPWR registers\[28\]\[25\] sky130_fd_sc_hd__dfxtp_1
X_4778_ _1390_ VGND VGND VPWR VPWR _1550_ sky130_fd_sc_hd__buf_4
X_7566_ _3683_ VGND VGND VPWR VPWR _3706_ sky130_fd_sc_hd__clkbuf_8
XANTENNA__5184__A _1809_ VGND VGND VPWR VPWR sky130_fd_sc_hd__diode_2
X_7497_ _3669_ VGND VGND VPWR VPWR _0172_ sky130_fd_sc_hd__clkbuf_1
X_6517_ _3128_ VGND VGND VPWR VPWR _0757_ sky130_fd_sc_hd__clkbuf_1
X_6448_ _3081_ registers\[29\]\[6\] _3069_ VGND VGND VPWR VPWR _3082_ sky130_fd_sc_hd__mux2_1
XANTENNA__4919__S1 _1679_ VGND VGND VPWR VPWR sky130_fd_sc_hd__diode_2
X_9236_ clknet_leaf_74_clk _0333_ VGND VGND VPWR VPWR registers\[26\]\[20\] sky130_fd_sc_hd__dfxtp_1
XFILLER_0_101_656 VGND VGND VPWR VPWR sky130_fd_sc_hd__fill_2
XTAP_TAPCELL_ROW_95_1489 VGND VPWR sky130_fd_sc_hd__tapvpwrvgnd_1
X_9167_ clknet_leaf_65_clk _0264_ VGND VGND VPWR VPWR registers\[24\]\[15\] sky130_fd_sc_hd__dfxtp_1
X_6379_ _3029_ VGND VGND VPWR VPWR _3041_ sky130_fd_sc_hd__buf_4
XFILLER_0_30_267 VGND VGND VPWR VPWR sky130_fd_sc_hd__fill_2
XANTENNA__7603__S _3720_ VGND VGND VPWR VPWR sky130_fd_sc_hd__diode_2
XANTENNA__8435__A1 net19 VGND VGND VPWR VPWR sky130_fd_sc_hd__diode_2
X_8118_ _3010_ registers\[30\]\[23\] _3995_ VGND VGND VPWR VPWR _3999_ sky130_fd_sc_hd__mux2_1
X_9098_ clknet_leaf_37_clk _0195_ VGND VGND VPWR VPWR registers\[22\]\[10\] sky130_fd_sc_hd__dfxtp_1
XANTENNA__4528__A _1159_ VGND VGND VPWR VPWR sky130_fd_sc_hd__diode_2
X_8049_ _3962_ VGND VGND VPWR VPWR _0431_ sky130_fd_sc_hd__clkbuf_1
XFILLER_0_98_713 VGND VGND VPWR VPWR sky130_fd_sc_hd__decap_6
XFILLER_0_97_201 VGND VGND VPWR VPWR sky130_fd_sc_hd__decap_3
XFILLER_0_97_234 VGND VGND VPWR VPWR sky130_fd_sc_hd__fill_2
XTAP_TAPCELL_ROW_39_771 VGND VPWR sky130_fd_sc_hd__tapvpwrvgnd_1
XTAP_TAPCELL_ROW_39_760 VGND VPWR sky130_fd_sc_hd__tapvpwrvgnd_1
XANTENNA__7839__A _3828_ VGND VGND VPWR VPWR sky130_fd_sc_hd__diode_2
XANTENNA__6749__A1 _2972_ VGND VGND VPWR VPWR sky130_fd_sc_hd__diode_2
XFILLER_0_97_245 VGND VGND VPWR VPWR sky130_fd_sc_hd__fill_2
XANTENNA__4855__S0 _1617_ VGND VGND VPWR VPWR sky130_fd_sc_hd__diode_2
XANTENNA__5359__A _2101_ VGND VGND VPWR VPWR sky130_fd_sc_hd__diode_2
XFILLER_0_109_723 VGND VGND VPWR VPWR sky130_fd_sc_hd__decap_3
XANTENNA__6889__S _3324_ VGND VGND VPWR VPWR sky130_fd_sc_hd__diode_2
XFILLER_0_53_337 VGND VGND VPWR VPWR sky130_fd_sc_hd__fill_1
XFILLER_0_110_17 VGND VGND VPWR VPWR sky130_fd_sc_hd__decap_3
XFILLER_0_110_39 VGND VGND VPWR VPWR sky130_fd_sc_hd__fill_1
XANTENNA__4932__B1 _1634_ VGND VGND VPWR VPWR sky130_fd_sc_hd__diode_2
XTAP_TAPCELL_ROW_59_1031 VGND VPWR sky130_fd_sc_hd__tapvpwrvgnd_1
XTAP_TAPCELL_ROW_59_1020 VGND VPWR sky130_fd_sc_hd__tapvpwrvgnd_1
XANTENNA__5094__A _1851_ VGND VGND VPWR VPWR sky130_fd_sc_hd__diode_2
XFILLER_0_104_472 VGND VGND VPWR VPWR sky130_fd_sc_hd__fill_2
XANTENNA__6134__C1 _2276_ VGND VGND VPWR VPWR sky130_fd_sc_hd__diode_2
XFILLER_0_21_223 VGND VGND VPWR VPWR sky130_fd_sc_hd__fill_1
Xclkbuf_leaf_100_clk clknet_4_2_0_clk VGND VGND VPWR VPWR clknet_leaf_100_clk sky130_fd_sc_hd__clkbuf_8
XFILLER_0_104_494 VGND VGND VPWR VPWR sky130_fd_sc_hd__fill_1
XANTENNA__5488__A1 _1979_ VGND VGND VPWR VPWR sky130_fd_sc_hd__diode_2
XANTENNA__5032__S0 _1705_ VGND VGND VPWR VPWR sky130_fd_sc_hd__diode_2
XFILLER_0_119_15 VGND VGND VPWR VPWR sky130_fd_sc_hd__fill_2
XANTENNA__8426__A1 net46 VGND VGND VPWR VPWR sky130_fd_sc_hd__diode_2
XANTENNA__5822__A _1819_ VGND VGND VPWR VPWR sky130_fd_sc_hd__diode_2
XANTENNA__6918__A _3323_ VGND VGND VPWR VPWR sky130_fd_sc_hd__diode_2
XANTENNA__7513__S _3670_ VGND VGND VPWR VPWR sky130_fd_sc_hd__diode_2
XFILLER_0_28_46 VGND VGND VPWR VPWR sky130_fd_sc_hd__decap_3
XANTENNA__5033__S _1682_ VGND VGND VPWR VPWR sky130_fd_sc_hd__diode_2
XANTENNA__5335__S1 _2073_ VGND VGND VPWR VPWR sky130_fd_sc_hd__diode_2
XANTENNA__6356__C net11 VGND VGND VPWR VPWR sky130_fd_sc_hd__diode_2
XANTENNA__8344__S _4117_ VGND VGND VPWR VPWR sky130_fd_sc_hd__diode_2
XANTENNA__5660__A1 _1438_ VGND VGND VPWR VPWR sky130_fd_sc_hd__diode_2
XFILLER_0_57_610 VGND VGND VPWR VPWR sky130_fd_sc_hd__fill_2
XFILLER_0_44_89 VGND VGND VPWR VPWR sky130_fd_sc_hd__fill_2
X_5750_ _2463_ _2474_ _2422_ _2481_ VGND VGND VPWR VPWR net75 sky130_fd_sc_hd__o2bb2a_1
XFILLER_0_9_729 VGND VGND VPWR VPWR sky130_fd_sc_hd__decap_4
XTAP_TAPCELL_ROW_17_476 VGND VPWR sky130_fd_sc_hd__tapvpwrvgnd_1
XFILLER_0_29_323 VGND VGND VPWR VPWR sky130_fd_sc_hd__fill_2
X_5681_ _2411_ _2414_ _2279_ VGND VGND VPWR VPWR _2415_ sky130_fd_sc_hd__mux2_1
XFILLER_0_60_33 VGND VGND VPWR VPWR sky130_fd_sc_hd__fill_1
XFILLER_0_57_665 VGND VGND VPWR VPWR sky130_fd_sc_hd__decap_6
X_4701_ _1476_ _1477_ _1362_ VGND VGND VPWR VPWR _1478_ sky130_fd_sc_hd__mux2_1
XANTENNA__6799__S _3272_ VGND VGND VPWR VPWR sky130_fd_sc_hd__diode_2
XFILLER_0_29_378 VGND VGND VPWR VPWR sky130_fd_sc_hd__fill_2
XFILLER_0_29_389 VGND VGND VPWR VPWR sky130_fd_sc_hd__decap_3
X_7420_ registers\[20\]\[15\] _3466_ _3623_ VGND VGND VPWR VPWR _3629_ sky130_fd_sc_hd__mux2_1
XFILLER_0_56_197 VGND VGND VPWR VPWR sky130_fd_sc_hd__fill_2
XFILLER_0_56_175 VGND VGND VPWR VPWR sky130_fd_sc_hd__fill_2
X_4632_ _1389_ _1412_ _1143_ VGND VGND VPWR VPWR _1413_ sky130_fd_sc_hd__a21oi_1
XFILLER_0_114_247 VGND VGND VPWR VPWR sky130_fd_sc_hd__decap_3
X_7351_ registers\[1\]\[15\] _3466_ _3586_ VGND VGND VPWR VPWR _3592_ sky130_fd_sc_hd__mux2_1
X_4563_ _1126_ VGND VGND VPWR VPWR _1347_ sky130_fd_sc_hd__clkbuf_8
XFILLER_0_40_521 VGND VGND VPWR VPWR sky130_fd_sc_hd__fill_2
X_6302_ registers\[19\]\[14\] _2991_ _2983_ VGND VGND VPWR VPWR _2992_ sky130_fd_sc_hd__mux2_1
X_7282_ _3555_ VGND VGND VPWR VPWR _0071_ sky130_fd_sc_hd__clkbuf_1
X_4494_ registers\[8\]\[12\] registers\[9\]\[12\] registers\[10\]\[12\] registers\[11\]\[12\]
+ _1201_ _1204_ VGND VGND VPWR VPWR _1282_ sky130_fd_sc_hd__mux4_1
XFILLER_0_8_89 VGND VGND VPWR VPWR sky130_fd_sc_hd__fill_2
XANTENNA__5023__S0 _1628_ VGND VGND VPWR VPWR sky130_fd_sc_hd__diode_2
X_6233_ net136 _2938_ VGND VGND VPWR VPWR _2939_ sky130_fd_sc_hd__xor2_1
XFILLER_0_40_587 VGND VGND VPWR VPWR sky130_fd_sc_hd__fill_1
X_9021_ clknet_leaf_108_clk _0118_ VGND VGND VPWR VPWR registers\[1\]\[29\] sky130_fd_sc_hd__dfxtp_1
XFILLER_0_12_278 VGND VGND VPWR VPWR sky130_fd_sc_hd__fill_2
XFILLER_0_110_475 VGND VGND VPWR VPWR sky130_fd_sc_hd__fill_1
XFILLER_0_100_94 VGND VGND VPWR VPWR sky130_fd_sc_hd__fill_2
XFILLER_0_0_673 VGND VGND VPWR VPWR sky130_fd_sc_hd__decap_3
X_6164_ net99 _2873_ VGND VGND VPWR VPWR _2874_ sky130_fd_sc_hd__xnor2_1
X_6095_ _2792_ _2797_ _2798_ _2808_ _2429_ VGND VGND VPWR VPWR net63 sky130_fd_sc_hd__a32oi_4
X_5115_ registers\[24\]\[12\] registers\[25\]\[12\] registers\[26\]\[12\] registers\[27\]\[12\]
+ _1798_ _1799_ VGND VGND VPWR VPWR _1871_ sky130_fd_sc_hd__mux4_1
XFILLER_0_109_81 VGND VGND VPWR VPWR sky130_fd_sc_hd__fill_2
X_5046_ _1705_ VGND VGND VPWR VPWR _1806_ sky130_fd_sc_hd__clkbuf_8
XFILLER_0_85_96 VGND VGND VPWR VPWR sky130_fd_sc_hd__decap_4
XFILLER_0_33_3 VGND VGND VPWR VPWR sky130_fd_sc_hd__fill_1
XFILLER_0_79_201 VGND VGND VPWR VPWR sky130_fd_sc_hd__decap_4
XANTENNA__8254__S _4067_ VGND VGND VPWR VPWR sky130_fd_sc_hd__diode_2
XANTENNA__4782__S _1513_ VGND VGND VPWR VPWR sky130_fd_sc_hd__diode_2
XFILLER_0_95_705 VGND VGND VPWR VPWR sky130_fd_sc_hd__fill_2
XFILLER_0_79_256 VGND VGND VPWR VPWR sky130_fd_sc_hd__decap_8
XANTENNA__7928__A0 _3131_ VGND VGND VPWR VPWR sky130_fd_sc_hd__diode_2
XTAP_TAPCELL_ROW_36_730 VGND VPWR sky130_fd_sc_hd__tapvpwrvgnd_1
X_8805_ clknet_leaf_31_clk _0926_ VGND VGND VPWR VPWR registers\[13\]\[5\] sky130_fd_sc_hd__dfxtp_1
XFILLER_0_79_278 VGND VGND VPWR VPWR sky130_fd_sc_hd__fill_2
X_6997_ _3388_ VGND VGND VPWR VPWR _0977_ sky130_fd_sc_hd__clkbuf_1
X_5948_ _2509_ _2669_ _2490_ VGND VGND VPWR VPWR _2670_ sky130_fd_sc_hd__mux2_1
X_8736_ clknet_leaf_5_clk _0857_ VGND VGND VPWR VPWR registers\[11\]\[0\] sky130_fd_sc_hd__dfxtp_1
XANTENNA__4837__S0 _1513_ VGND VGND VPWR VPWR sky130_fd_sc_hd__diode_2
XFILLER_0_63_613 VGND VGND VPWR VPWR sky130_fd_sc_hd__decap_3
XFILLER_0_63_602 VGND VGND VPWR VPWR sky130_fd_sc_hd__fill_2
X_5879_ _2603_ _2604_ VGND VGND VPWR VPWR _2605_ sky130_fd_sc_hd__nand2_1
XFILLER_0_90_421 VGND VGND VPWR VPWR sky130_fd_sc_hd__fill_2
XFILLER_0_63_646 VGND VGND VPWR VPWR sky130_fd_sc_hd__fill_2
X_8667_ clknet_leaf_106_clk _0788_ VGND VGND VPWR VPWR registers\[7\]\[27\] sky130_fd_sc_hd__dfxtp_1
XTAP_TAPCELL_ROW_97_1518 VGND VPWR sky130_fd_sc_hd__tapvpwrvgnd_1
X_7618_ _3094_ registers\[23\]\[12\] _3731_ VGND VGND VPWR VPWR _3734_ sky130_fd_sc_hd__mux2_1
X_8598_ clknet_leaf_93_clk _0719_ VGND VGND VPWR VPWR registers\[3\]\[22\] sky130_fd_sc_hd__dfxtp_1
X_7549_ _3697_ VGND VGND VPWR VPWR _0196_ sky130_fd_sc_hd__clkbuf_1
XANTENNA__8105__A0 _2997_ VGND VGND VPWR VPWR sky130_fd_sc_hd__diode_2
XFILLER_0_105_236 VGND VGND VPWR VPWR sky130_fd_sc_hd__decap_4
XFILLER_0_90_498 VGND VGND VPWR VPWR sky130_fd_sc_hd__decap_3
XFILLER_0_50_318 VGND VGND VPWR VPWR sky130_fd_sc_hd__decap_3
XANTENNA__5014__S0 _1773_ VGND VGND VPWR VPWR sky130_fd_sc_hd__diode_2
X_9219_ clknet_leaf_23_clk _0316_ VGND VGND VPWR VPWR registers\[26\]\[3\] sky130_fd_sc_hd__dfxtp_1
XANTENNA__5642__A _1070_ VGND VGND VPWR VPWR sky130_fd_sc_hd__diode_2
XFILLER_0_98_521 VGND VGND VPWR VPWR sky130_fd_sc_hd__fill_2
XANTENNA_input17_A wd3[10] VGND VGND VPWR VPWR sky130_fd_sc_hd__diode_2
XTAP_TAPCELL_ROW_106_1636 VGND VPWR sky130_fd_sc_hd__tapvpwrvgnd_1
XFILLER_0_86_716 VGND VGND VPWR VPWR sky130_fd_sc_hd__fill_2
XFILLER_0_86_727 VGND VGND VPWR VPWR sky130_fd_sc_hd__decap_3
XFILLER_0_85_215 VGND VGND VPWR VPWR sky130_fd_sc_hd__decap_6
XFILLER_0_39_621 VGND VGND VPWR VPWR sky130_fd_sc_hd__decap_3
XANTENNA__4828__S0 _1382_ VGND VGND VPWR VPWR sky130_fd_sc_hd__diode_2
XFILLER_0_66_473 VGND VGND VPWR VPWR sky130_fd_sc_hd__decap_3
XTAP_TAPCELL_ROW_14_435 VGND VPWR sky130_fd_sc_hd__tapvpwrvgnd_1
XTAP_TAPCELL_ROW_14_446 VGND VPWR sky130_fd_sc_hd__tapvpwrvgnd_1
XFILLER_0_93_281 VGND VGND VPWR VPWR sky130_fd_sc_hd__fill_2
XFILLER_0_93_270 VGND VGND VPWR VPWR sky130_fd_sc_hd__decap_4
XFILLER_0_54_624 VGND VGND VPWR VPWR sky130_fd_sc_hd__fill_2
XFILLER_0_39_698 VGND VGND VPWR VPWR sky130_fd_sc_hd__fill_1
XFILLER_0_53_156 VGND VGND VPWR VPWR sky130_fd_sc_hd__fill_2
XTAP_TAPCELL_ROW_42_799 VGND VPWR sky130_fd_sc_hd__tapvpwrvgnd_1
XFILLER_0_26_348 VGND VGND VPWR VPWR sky130_fd_sc_hd__fill_2
XFILLER_0_30_47 VGND VGND VPWR VPWR sky130_fd_sc_hd__decap_3
XANTENNA__5253__S0 _1996_ VGND VGND VPWR VPWR sky130_fd_sc_hd__diode_2
XFILLER_0_111_206 VGND VGND VPWR VPWR sky130_fd_sc_hd__fill_1
XTAP_TAPCELL_ROW_117_1776 VGND VPWR sky130_fd_sc_hd__tapvpwrvgnd_1
XFILLER_0_22_587 VGND VGND VPWR VPWR sky130_fd_sc_hd__fill_1
XANTENNA_output85_A net85 VGND VGND VPWR VPWR sky130_fd_sc_hd__diode_2
XANTENNA__5308__S1 _1774_ VGND VGND VPWR VPWR sky130_fd_sc_hd__diode_2
XANTENNA__5633__A1 _2011_ VGND VGND VPWR VPWR sky130_fd_sc_hd__diode_2
XFILLER_0_89_565 VGND VGND VPWR VPWR sky130_fd_sc_hd__fill_1
XANTENNA__8074__S _3973_ VGND VGND VPWR VPWR sky130_fd_sc_hd__diode_2
X_6920_ _3347_ VGND VGND VPWR VPWR _0941_ sky130_fd_sc_hd__clkbuf_1
XFILLER_0_89_576 VGND VGND VPWR VPWR sky130_fd_sc_hd__decap_6
XFILLER_0_49_418 VGND VGND VPWR VPWR sky130_fd_sc_hd__fill_2
X_6851_ registers\[12\]\[20\] _3003_ _3310_ VGND VGND VPWR VPWR _3311_ sky130_fd_sc_hd__mux2_1
XTAP_TAPCELL_ROW_81_1308 VGND VPWR sky130_fd_sc_hd__tapvpwrvgnd_1
XFILLER_0_76_259 VGND VGND VPWR VPWR sky130_fd_sc_hd__fill_2
XFILLER_0_76_248 VGND VGND VPWR VPWR sky130_fd_sc_hd__fill_2
X_5802_ _2530_ VGND VGND VPWR VPWR _2531_ sky130_fd_sc_hd__inv_2
XANTENNA__4819__S0 _1390_ VGND VGND VPWR VPWR sky130_fd_sc_hd__diode_2
XANTENNA__4295__S1 _1061_ VGND VGND VPWR VPWR sky130_fd_sc_hd__diode_2
X_6782_ _3273_ VGND VGND VPWR VPWR _0877_ sky130_fd_sc_hd__clkbuf_1
X_8521_ _4212_ VGND VGND VPWR VPWR _0653_ sky130_fd_sc_hd__clkbuf_1
XANTENNA__7418__S _3623_ VGND VGND VPWR VPWR sky130_fd_sc_hd__diode_2
X_5733_ _2344_ _1108_ VGND VGND VPWR VPWR _2465_ sky130_fd_sc_hd__nand2_2
XFILLER_0_72_421 VGND VGND VPWR VPWR sky130_fd_sc_hd__fill_2
XFILLER_0_17_337 VGND VGND VPWR VPWR sky130_fd_sc_hd__decap_3
XFILLER_0_72_465 VGND VGND VPWR VPWR sky130_fd_sc_hd__fill_2
X_5664_ _2276_ VGND VGND VPWR VPWR _2399_ sky130_fd_sc_hd__clkbuf_4
XFILLER_0_17_348 VGND VGND VPWR VPWR sky130_fd_sc_hd__decap_3
X_8452_ registers\[8\]\[20\] net28 _4175_ VGND VGND VPWR VPWR _4176_ sky130_fd_sc_hd__mux2_1
X_7403_ registers\[20\]\[7\] _3449_ _3612_ VGND VGND VPWR VPWR _3620_ sky130_fd_sc_hd__mux2_1
X_5595_ _1913_ _2215_ _1050_ VGND VGND VPWR VPWR _2330_ sky130_fd_sc_hd__o21ai_1
XFILLER_0_60_649 VGND VGND VPWR VPWR sky130_fd_sc_hd__decap_6
XFILLER_0_60_638 VGND VGND VPWR VPWR sky130_fd_sc_hd__fill_2
X_4615_ _1396_ VGND VGND VPWR VPWR net122 sky130_fd_sc_hd__inv_2
X_8383_ _4116_ VGND VGND VPWR VPWR _4139_ sky130_fd_sc_hd__clkbuf_8
XFILLER_0_103_729 VGND VGND VPWR VPWR sky130_fd_sc_hd__fill_1
XFILLER_0_103_718 VGND VGND VPWR VPWR sky130_fd_sc_hd__decap_3
X_7334_ registers\[1\]\[7\] _3449_ _3575_ VGND VGND VPWR VPWR _3583_ sky130_fd_sc_hd__mux2_1
X_4546_ registers\[0\]\[15\] registers\[1\]\[15\] registers\[2\]\[15\] registers\[3\]\[15\]
+ _1160_ _1161_ VGND VGND VPWR VPWR _1331_ sky130_fd_sc_hd__mux4_1
XFILLER_0_4_253 VGND VGND VPWR VPWR sky130_fd_sc_hd__decap_3
X_7265_ _3546_ VGND VGND VPWR VPWR _0063_ sky130_fd_sc_hd__clkbuf_1
XTAP_TAPCELL_ROW_92_1459 VGND VPWR sky130_fd_sc_hd__tapvpwrvgnd_1
X_4477_ registers\[4\]\[11\] registers\[5\]\[11\] registers\[6\]\[11\] registers\[7\]\[11\]
+ _1197_ _1203_ VGND VGND VPWR VPWR _1266_ sky130_fd_sc_hd__mux4_1
XANTENNA__5462__A net15 VGND VGND VPWR VPWR sky130_fd_sc_hd__diode_2
XFILLER_0_40_373 VGND VGND VPWR VPWR sky130_fd_sc_hd__decap_3
XANTENNA__7310__A1 _3493_ VGND VGND VPWR VPWR sky130_fd_sc_hd__diode_2
XFILLER_0_96_73 VGND VGND VPWR VPWR sky130_fd_sc_hd__decap_4
X_7196_ registers\[17\]\[6\] _3447_ _3503_ VGND VGND VPWR VPWR _3510_ sky130_fd_sc_hd__mux2_1
X_6216_ net138 _2788_ VGND VGND VPWR VPWR _2923_ sky130_fd_sc_hd__nand2_1
X_9004_ clknet_leaf_44_clk _0101_ VGND VGND VPWR VPWR registers\[1\]\[12\] sky130_fd_sc_hd__dfxtp_1
XFILLER_0_0_481 VGND VGND VPWR VPWR sky130_fd_sc_hd__fill_2
XANTENNA__6992__S _3383_ VGND VGND VPWR VPWR sky130_fd_sc_hd__diode_2
X_6147_ _1517_ _2857_ VGND VGND VPWR VPWR _2858_ sky130_fd_sc_hd__xnor2_2
XANTENNA_input9_A a3[0] VGND VGND VPWR VPWR sky130_fd_sc_hd__diode_2
XANTENNA__7386__A_N net12 VGND VGND VPWR VPWR sky130_fd_sc_hd__diode_2
XFILLER_0_99_307 VGND VGND VPWR VPWR sky130_fd_sc_hd__fill_2
X_6078_ _2509_ _2789_ _2420_ VGND VGND VPWR VPWR _2792_ sky130_fd_sc_hd__o21a_1
X_5029_ _1788_ _1789_ _1631_ VGND VGND VPWR VPWR _1790_ sky130_fd_sc_hd__mux2_1
XFILLER_0_68_727 VGND VGND VPWR VPWR sky130_fd_sc_hd__decap_3
XFILLER_0_36_613 VGND VGND VPWR VPWR sky130_fd_sc_hd__fill_2
XANTENNA__7328__S _3575_ VGND VGND VPWR VPWR sky130_fd_sc_hd__diode_2
XTAP_TAPCELL_ROW_101_1566 VGND VPWR sky130_fd_sc_hd__tapvpwrvgnd_1
X_8719_ clknet_leaf_44_clk _0840_ VGND VGND VPWR VPWR registers\[10\]\[15\] sky130_fd_sc_hd__dfxtp_1
XFILLER_0_75_281 VGND VGND VPWR VPWR sky130_fd_sc_hd__fill_1
XANTENNA__8326__A0 _3014_ VGND VGND VPWR VPWR sky130_fd_sc_hd__diode_2
XTAP_TAPCELL_ROW_11_405 VGND VPWR sky130_fd_sc_hd__tapvpwrvgnd_1
XFILLER_0_35_101 VGND VGND VPWR VPWR sky130_fd_sc_hd__fill_2
XTAP_TAPCELL_ROW_101_1577 VGND VPWR sky130_fd_sc_hd__tapvpwrvgnd_1
XFILLER_0_63_465 VGND VGND VPWR VPWR sky130_fd_sc_hd__fill_2
XFILLER_0_90_262 VGND VGND VPWR VPWR sky130_fd_sc_hd__fill_2
XANTENNA__5235__S0 _1719_ VGND VGND VPWR VPWR sky130_fd_sc_hd__diode_2
XFILLER_0_51_638 VGND VGND VPWR VPWR sky130_fd_sc_hd__fill_1
XFILLER_0_106_589 VGND VGND VPWR VPWR sky130_fd_sc_hd__decap_3
XANTENNA__8159__S _4020_ VGND VGND VPWR VPWR sky130_fd_sc_hd__diode_2
XANTENNA__7063__S _3420_ VGND VGND VPWR VPWR sky130_fd_sc_hd__diode_2
XFILLER_0_31_373 VGND VGND VPWR VPWR sky130_fd_sc_hd__fill_1
XANTENNA__7998__S _3900_ VGND VGND VPWR VPWR sky130_fd_sc_hd__diode_2
XTAP_TAPCELL_ROW_19_505 VGND VPWR sky130_fd_sc_hd__tapvpwrvgnd_1
XFILLER_0_116_27 VGND VGND VPWR VPWR sky130_fd_sc_hd__fill_1
XANTENNA__6407__S _3052_ VGND VGND VPWR VPWR sky130_fd_sc_hd__diode_2
XTAP_TAPCELL_ROW_67_1130 VGND VPWR sky130_fd_sc_hd__tapvpwrvgnd_1
XFILLER_0_58_204 VGND VGND VPWR VPWR sky130_fd_sc_hd__fill_2
XTAP_TAPCELL_ROW_47_869 VGND VPWR sky130_fd_sc_hd__tapvpwrvgnd_1
XANTENNA__7368__A1 _3483_ VGND VGND VPWR VPWR sky130_fd_sc_hd__diode_2
XFILLER_0_98_395 VGND VGND VPWR VPWR sky130_fd_sc_hd__fill_2
XFILLER_0_58_248 VGND VGND VPWR VPWR sky130_fd_sc_hd__fill_2
XANTENNA__4277__S1 _1040_ VGND VGND VPWR VPWR sky130_fd_sc_hd__diode_2
XFILLER_0_41_57 VGND VGND VPWR VPWR sky130_fd_sc_hd__decap_3
XANTENNA__7238__S _3525_ VGND VGND VPWR VPWR sky130_fd_sc_hd__diode_2
XTAP_TAPCELL_ROW_119_1816 VGND VPWR sky130_fd_sc_hd__tapvpwrvgnd_1
XTAP_TAPCELL_ROW_119_1805 VGND VPWR sky130_fd_sc_hd__tapvpwrvgnd_1
XFILLER_0_109_383 VGND VGND VPWR VPWR sky130_fd_sc_hd__decap_8
XFILLER_0_54_487 VGND VGND VPWR VPWR sky130_fd_sc_hd__fill_1
XANTENNA__6879__A0 _3071_ VGND VGND VPWR VPWR sky130_fd_sc_hd__diode_2
XFILLER_0_14_329 VGND VGND VPWR VPWR sky130_fd_sc_hd__fill_2
X_4400_ registers\[12\]\[7\] registers\[13\]\[7\] registers\[14\]\[7\] registers\[15\]\[7\]
+ _1136_ _1137_ VGND VGND VPWR VPWR _1193_ sky130_fd_sc_hd__mux4_1
XFILLER_0_42_649 VGND VGND VPWR VPWR sky130_fd_sc_hd__fill_2
XTAP_TAPCELL_ROW_78_1270 VGND VPWR sky130_fd_sc_hd__tapvpwrvgnd_1
X_5380_ registers\[24\]\[27\] registers\[25\]\[27\] registers\[26\]\[27\] registers\[27\]\[27\]
+ _2119_ _2120_ VGND VGND VPWR VPWR _2121_ sky130_fd_sc_hd__mux4_1
X_4331_ _1112_ VGND VGND VPWR VPWR _1127_ sky130_fd_sc_hd__buf_4
X_7050_ _3104_ registers\[15\]\[17\] _3409_ VGND VGND VPWR VPWR _3417_ sky130_fd_sc_hd__mux2_1
X_4262_ a2[1] VGND VGND VPWR VPWR _1061_ sky130_fd_sc_hd__clkbuf_4
X_6001_ _2328_ _2718_ _2719_ VGND VGND VPWR VPWR _2720_ sky130_fd_sc_hd__and3_1
XANTENNA__7701__S _3768_ VGND VGND VPWR VPWR sky130_fd_sc_hd__diode_2
XANTENNA__5606__A1 _1866_ VGND VGND VPWR VPWR sky130_fd_sc_hd__diode_2
XANTENNA__6317__S _2983_ VGND VGND VPWR VPWR sky130_fd_sc_hd__diode_2
X_7952_ _2980_ registers\[28\]\[9\] _3901_ VGND VGND VPWR VPWR _3911_ sky130_fd_sc_hd__mux2_1
XFILLER_0_77_502 VGND VGND VPWR VPWR sky130_fd_sc_hd__fill_2
X_6903_ _3338_ VGND VGND VPWR VPWR _0933_ sky130_fd_sc_hd__clkbuf_1
X_7883_ _3874_ VGND VGND VPWR VPWR _0353_ sky130_fd_sc_hd__clkbuf_1
XFILLER_0_119_125 VPWR VGND VPWR VGND sky130_ef_sc_hd__decap_12
XANTENNA__6031__A1 _2429_ VGND VGND VPWR VPWR sky130_fd_sc_hd__diode_2
XFILLER_0_106_82 VGND VGND VPWR VPWR sky130_fd_sc_hd__fill_2
X_6834_ registers\[12\]\[12\] _2987_ _3299_ VGND VGND VPWR VPWR _3302_ sky130_fd_sc_hd__mux2_1
XANTENNA__4268__S1 _1061_ VGND VGND VPWR VPWR sky130_fd_sc_hd__diode_2
XANTENNA__8532__S _4211_ VGND VGND VPWR VPWR sky130_fd_sc_hd__diode_2
XFILLER_0_119_169 VPWR VGND VPWR VGND sky130_ef_sc_hd__decap_12
X_9553_ clknet_leaf_63_clk _0650_ VGND VGND VPWR VPWR registers\[4\]\[17\] sky130_fd_sc_hd__dfxtp_1
X_6765_ _3264_ VGND VGND VPWR VPWR _0869_ sky130_fd_sc_hd__clkbuf_1
X_5716_ net124 _2447_ _2448_ VGND VGND VPWR VPWR _2449_ sky130_fd_sc_hd__o21ai_1
X_8504_ _4203_ VGND VGND VPWR VPWR _0645_ sky130_fd_sc_hd__clkbuf_1
X_9484_ clknet_leaf_45_clk _0581_ VGND VGND VPWR VPWR registers\[5\]\[12\] sky130_fd_sc_hd__dfxtp_1
X_8435_ registers\[8\]\[12\] net19 _4164_ VGND VGND VPWR VPWR _4167_ sky130_fd_sc_hd__mux2_1
X_6696_ registers\[10\]\[12\] _2987_ _3225_ VGND VGND VPWR VPWR _3228_ sky130_fd_sc_hd__mux2_1
XFILLER_0_60_402 VGND VGND VPWR VPWR sky130_fd_sc_hd__decap_6
XFILLER_0_33_627 VGND VGND VPWR VPWR sky130_fd_sc_hd__decap_3
X_5647_ _2381_ VGND VGND VPWR VPWR _2382_ sky130_fd_sc_hd__inv_2
XFILLER_0_72_295 VGND VGND VPWR VPWR sky130_fd_sc_hd__decap_3
XANTENNA__5542__B1 _2277_ VGND VGND VPWR VPWR sky130_fd_sc_hd__diode_2
XFILLER_0_103_559 VGND VGND VPWR VPWR sky130_fd_sc_hd__fill_1
XFILLER_0_103_548 VGND VGND VPWR VPWR sky130_fd_sc_hd__fill_2
XFILLER_0_103_526 VGND VGND VPWR VPWR sky130_fd_sc_hd__fill_2
X_8366_ _4130_ VGND VGND VPWR VPWR _0580_ sky130_fd_sc_hd__clkbuf_1
X_5578_ _1660_ _2214_ VGND VGND VPWR VPWR _2314_ sky130_fd_sc_hd__or2_1
XFILLER_0_41_671 VGND VGND VPWR VPWR sky130_fd_sc_hd__fill_1
XFILLER_0_32_159 VGND VGND VPWR VPWR sky130_fd_sc_hd__decap_4
X_8297_ _2985_ registers\[31\]\[11\] _4092_ VGND VGND VPWR VPWR _4094_ sky130_fd_sc_hd__mux2_1
X_4529_ registers\[8\]\[14\] registers\[9\]\[14\] registers\[10\]\[14\] registers\[11\]\[14\]
+ _1198_ _1199_ VGND VGND VPWR VPWR _1315_ sky130_fd_sc_hd__mux4_1
XANTENNA__6288__A net17 VGND VGND VPWR VPWR sky130_fd_sc_hd__diode_2
X_7317_ _3573_ VGND VGND VPWR VPWR _0088_ sky130_fd_sc_hd__clkbuf_1
XANTENNA__4300__S _1034_ VGND VGND VPWR VPWR sky130_fd_sc_hd__diode_2
XANTENNA__5192__A _1943_ VGND VGND VPWR VPWR sky130_fd_sc_hd__diode_2
XFILLER_0_40_192 VGND VGND VPWR VPWR sky130_fd_sc_hd__fill_2
X_7248_ registers\[17\]\[31\] _3499_ _3502_ VGND VGND VPWR VPWR _3537_ sky130_fd_sc_hd__mux2_1
XANTENNA__5845__A1 _2560_ VGND VGND VPWR VPWR sky130_fd_sc_hd__diode_2
XANTENNA__5920__A _1286_ VGND VGND VPWR VPWR sky130_fd_sc_hd__diode_2
XANTENNA__7611__S _3720_ VGND VGND VPWR VPWR sky130_fd_sc_hd__diode_2
X_7179_ registers\[16\]\[31\] _3499_ _3434_ VGND VGND VPWR VPWR _3500_ sky130_fd_sc_hd__mux2_1
XANTENNA__5058__C1 _1702_ VGND VGND VPWR VPWR sky130_fd_sc_hd__diode_2
XANTENNA__4536__A _1204_ VGND VGND VPWR VPWR sky130_fd_sc_hd__diode_2
XANTENNA__5131__S _1695_ VGND VGND VPWR VPWR sky130_fd_sc_hd__diode_2
XTAP_TAPCELL_ROW_44_828 VGND VPWR sky130_fd_sc_hd__tapvpwrvgnd_1
XFILLER_0_83_505 VGND VGND VPWR VPWR sky130_fd_sc_hd__decap_3
Xclkbuf_leaf_80_clk clknet_4_10_0_clk VGND VGND VPWR VPWR clknet_leaf_80_clk sky130_fd_sc_hd__clkbuf_8
XANTENNA__4259__S1 _1054_ VGND VGND VPWR VPWR sky130_fd_sc_hd__diode_2
XANTENNA__5456__S0 _2126_ VGND VGND VPWR VPWR sky130_fd_sc_hd__diode_2
XFILLER_0_36_421 VGND VGND VPWR VPWR sky130_fd_sc_hd__fill_2
XTAP_TAPCELL_ROW_62_1071 VGND VPWR sky130_fd_sc_hd__tapvpwrvgnd_1
XTAP_TAPCELL_ROW_62_1060 VGND VPWR sky130_fd_sc_hd__tapvpwrvgnd_1
XTAP_TAPCELL_ROW_24_574 VGND VPWR sky130_fd_sc_hd__tapvpwrvgnd_1
XANTENNA__5367__A _1760_ VGND VGND VPWR VPWR sky130_fd_sc_hd__diode_2
XFILLER_0_106_331 VGND VGND VPWR VPWR sky130_fd_sc_hd__fill_2
XFILLER_0_102_29 VGND VGND VPWR VPWR sky130_fd_sc_hd__fill_1
XFILLER_0_23_104 VGND VGND VPWR VPWR sky130_fd_sc_hd__decap_3
XFILLER_0_51_446 VGND VGND VPWR VPWR sky130_fd_sc_hd__fill_2
XTAP_TAPCELL_ROW_114_1746 VGND VPWR sky130_fd_sc_hd__tapvpwrvgnd_1
XTAP_TAPCELL_ROW_114_1735 VGND VPWR sky130_fd_sc_hd__tapvpwrvgnd_1
XANTENNA__5306__S _1695_ VGND VGND VPWR VPWR sky130_fd_sc_hd__diode_2
XANTENNA__7038__A0 _3092_ VGND VGND VPWR VPWR sky130_fd_sc_hd__diode_2
XANTENNA__7521__S _3647_ VGND VGND VPWR VPWR sky130_fd_sc_hd__diode_2
XFILLER_0_36_46 VGND VGND VPWR VPWR sky130_fd_sc_hd__fill_2
Xinput9 a3[0] VGND VGND VPWR VPWR net9 sky130_fd_sc_hd__clkbuf_4
XANTENNA__5041__S _1767_ VGND VGND VPWR VPWR sky130_fd_sc_hd__diode_2
XFILLER_0_99_693 VGND VGND VPWR VPWR sky130_fd_sc_hd__fill_1
XFILLER_0_59_557 VGND VGND VPWR VPWR sky130_fd_sc_hd__decap_3
XFILLER_0_59_535 VGND VGND VPWR VPWR sky130_fd_sc_hd__fill_2
XFILLER_0_59_524 VGND VGND VPWR VPWR sky130_fd_sc_hd__decap_4
XANTENNA__8352__S _4117_ VGND VGND VPWR VPWR sky130_fd_sc_hd__diode_2
XFILLER_0_59_579 VGND VGND VPWR VPWR sky130_fd_sc_hd__decap_8
Xclkbuf_leaf_71_clk clknet_4_11_0_clk VGND VGND VPWR VPWR clknet_leaf_71_clk sky130_fd_sc_hd__clkbuf_8
X_4880_ registers\[28\]\[1\] registers\[29\]\[1\] registers\[30\]\[1\] registers\[31\]\[1\]
+ _1642_ _1643_ VGND VGND VPWR VPWR _1647_ sky130_fd_sc_hd__mux4_1
XFILLER_0_86_398 VGND VGND VPWR VPWR sky130_fd_sc_hd__fill_2
XANTENNA__5447__S0 _2119_ VGND VGND VPWR VPWR sky130_fd_sc_hd__diode_2
XFILLER_0_117_629 VPWR VGND VPWR VGND sky130_ef_sc_hd__decap_12
X_6550_ _3136_ VGND VGND VPWR VPWR _3148_ sky130_fd_sc_hd__clkbuf_8
X_5501_ _2233_ _2236_ VGND VGND VPWR VPWR _2237_ sky130_fd_sc_hd__nand2_1
X_6481_ net24 VGND VGND VPWR VPWR _3104_ sky130_fd_sc_hd__buf_2
XFILLER_0_15_638 VGND VGND VPWR VPWR sky130_fd_sc_hd__fill_2
XFILLER_0_27_498 VGND VGND VPWR VPWR sky130_fd_sc_hd__fill_2
XFILLER_0_112_334 VGND VGND VPWR VPWR sky130_fd_sc_hd__fill_1
X_8220_ registers\[6\]\[7\] _3449_ _4045_ VGND VGND VPWR VPWR _4053_ sky130_fd_sc_hd__mux2_1
XANTENNA__6600__S _3175_ VGND VGND VPWR VPWR sky130_fd_sc_hd__diode_2
X_5432_ registers\[16\]\[30\] registers\[17\]\[30\] registers\[18\]\[30\] registers\[19\]\[30\]
+ _2027_ _2028_ VGND VGND VPWR VPWR _2170_ sky130_fd_sc_hd__mux4_1
X_8151_ _4016_ VGND VGND VPWR VPWR _0479_ sky130_fd_sc_hd__clkbuf_1
X_5363_ registers\[28\]\[26\] registers\[29\]\[26\] registers\[30\]\[26\] registers\[31\]\[26\]
+ _1996_ _1997_ VGND VGND VPWR VPWR _2105_ sky130_fd_sc_hd__mux4_1
X_7102_ registers\[16\]\[6\] _3447_ _3435_ VGND VGND VPWR VPWR _3448_ sky130_fd_sc_hd__mux2_1
X_4314_ _1060_ VGND VGND VPWR VPWR _1110_ sky130_fd_sc_hd__buf_4
XANTENNA__5216__S _1746_ VGND VGND VPWR VPWR sky130_fd_sc_hd__diode_2
XFILLER_0_2_598 VGND VGND VPWR VPWR sky130_fd_sc_hd__fill_2
XFILLER_0_2_587 VGND VGND VPWR VPWR sky130_fd_sc_hd__fill_1
X_8082_ _2974_ registers\[30\]\[6\] _3973_ VGND VGND VPWR VPWR _3980_ sky130_fd_sc_hd__mux2_1
X_5294_ registers\[8\]\[22\] registers\[9\]\[22\] registers\[10\]\[22\] registers\[11\]\[22\]
+ _1806_ _1759_ VGND VGND VPWR VPWR _2040_ sky130_fd_sc_hd__mux4_1
XANTENNA__7029__A0 _3083_ VGND VGND VPWR VPWR sky130_fd_sc_hd__diode_2
X_7033_ _3087_ registers\[15\]\[9\] _3398_ VGND VGND VPWR VPWR _3408_ sky130_fd_sc_hd__mux2_1
XANTENNA__7431__S _3634_ VGND VGND VPWR VPWR sky130_fd_sc_hd__diode_2
X_4245_ registers\[4\]\[0\] registers\[5\]\[0\] registers\[6\]\[0\] registers\[7\]\[0\]
+ _1039_ _1040_ VGND VGND VPWR VPWR _1045_ sky130_fd_sc_hd__mux4_1
XFILLER_0_117_81 VGND VGND VPWR VPWR sky130_fd_sc_hd__fill_1
X_8984_ clknet_leaf_85_clk _0081_ VGND VGND VPWR VPWR registers\[18\]\[24\] sky130_fd_sc_hd__dfxtp_1
X_7935_ _3902_ VGND VGND VPWR VPWR _0377_ sky130_fd_sc_hd__clkbuf_1
XFILLER_0_77_354 VGND VGND VPWR VPWR sky130_fd_sc_hd__fill_1
Xclkbuf_leaf_62_clk clknet_4_14_0_clk VGND VGND VPWR VPWR clknet_leaf_62_clk sky130_fd_sc_hd__clkbuf_8
XFILLER_0_65_505 VGND VGND VPWR VPWR sky130_fd_sc_hd__fill_2
X_7866_ _3065_ registers\[27\]\[0\] _3865_ VGND VGND VPWR VPWR _3866_ sky130_fd_sc_hd__mux2_1
XANTENNA__8262__S _4067_ VGND VGND VPWR VPWR sky130_fd_sc_hd__diode_2
X_6817_ registers\[12\]\[4\] _2970_ _3288_ VGND VGND VPWR VPWR _3293_ sky130_fd_sc_hd__mux2_1
XFILLER_0_65_549 VGND VGND VPWR VPWR sky130_fd_sc_hd__fill_2
XFILLER_0_65_516 VGND VGND VPWR VPWR sky130_fd_sc_hd__fill_2
XANTENNA__5438__S0 _1968_ VGND VGND VPWR VPWR sky130_fd_sc_hd__diode_2
XANTENNA__7386__B net11 VGND VGND VPWR VPWR sky130_fd_sc_hd__diode_2
X_7797_ _3828_ VGND VGND VPWR VPWR _3829_ sky130_fd_sc_hd__clkbuf_8
X_9536_ clknet_leaf_4_clk _0633_ VGND VGND VPWR VPWR registers\[4\]\[0\] sky130_fd_sc_hd__dfxtp_1
X_6748_ _3255_ VGND VGND VPWR VPWR _0861_ sky130_fd_sc_hd__clkbuf_1
XTAP_TAPCELL_ROW_21_533 VGND VPWR sky130_fd_sc_hd__tapvpwrvgnd_1
X_6679_ registers\[10\]\[4\] _2970_ _3214_ VGND VGND VPWR VPWR _3219_ sky130_fd_sc_hd__mux2_1
X_9467_ clknet_leaf_90_clk _0564_ VGND VGND VPWR VPWR registers\[31\]\[27\] sky130_fd_sc_hd__dfxtp_1
XANTENNA_clkbuf_leaf_75_clk_A clknet_4_11_0_clk VGND VGND VPWR VPWR sky130_fd_sc_hd__diode_2
X_8418_ registers\[8\]\[4\] net42 _4153_ VGND VGND VPWR VPWR _4158_ sky130_fd_sc_hd__mux2_1
X_9398_ clknet_leaf_95_clk _0495_ VGND VGND VPWR VPWR registers\[9\]\[22\] sky130_fd_sc_hd__dfxtp_1
XANTENNA__6510__S _3111_ VGND VGND VPWR VPWR sky130_fd_sc_hd__diode_2
XFILLER_0_33_479 VGND VGND VPWR VPWR sky130_fd_sc_hd__fill_1
XFILLER_0_103_367 VGND VGND VPWR VPWR sky130_fd_sc_hd__fill_2
XFILLER_0_103_356 VGND VGND VPWR VPWR sky130_fd_sc_hd__fill_1
X_8349_ _4121_ VGND VGND VPWR VPWR _0572_ sky130_fd_sc_hd__clkbuf_1
XANTENNA__7341__S _3586_ VGND VGND VPWR VPWR sky130_fd_sc_hd__diode_2
XANTENNA__8437__S _4164_ VGND VGND VPWR VPWR sky130_fd_sc_hd__diode_2
XANTENNA_clkbuf_leaf_13_clk_A clknet_4_3_0_clk VGND VGND VPWR VPWR sky130_fd_sc_hd__diode_2
XTAP_TAPCELL_ROW_29_633 VGND VPWR sky130_fd_sc_hd__tapvpwrvgnd_1
XTAP_TAPCELL_ROW_57_997 VGND VPWR sky130_fd_sc_hd__tapvpwrvgnd_1
Xclkbuf_leaf_53_clk clknet_4_13_0_clk VGND VGND VPWR VPWR clknet_leaf_53_clk sky130_fd_sc_hd__clkbuf_8
XFILLER_0_96_663 VGND VGND VPWR VPWR sky130_fd_sc_hd__fill_2
XANTENNA_clkbuf_leaf_28_clk_A clknet_4_5_0_clk VGND VGND VPWR VPWR sky130_fd_sc_hd__diode_2
XANTENNA__6481__A net24 VGND VGND VPWR VPWR sky130_fd_sc_hd__diode_2
XFILLER_0_83_302 VGND VGND VPWR VPWR sky130_fd_sc_hd__fill_2
XFILLER_0_56_516 VGND VGND VPWR VPWR sky130_fd_sc_hd__fill_2
Xclkbuf_4_6_0_clk clknet_0_clk VGND VGND VPWR VPWR clknet_4_6_0_clk sky130_fd_sc_hd__clkbuf_8
XFILLER_0_107_651 VGND VGND VPWR VPWR sky130_fd_sc_hd__decap_4
XFILLER_0_106_150 VGND VGND VPWR VPWR sky130_fd_sc_hd__fill_2
XFILLER_0_106_172 VGND VGND VPWR VPWR sky130_fd_sc_hd__fill_1
XTAP_TAPCELL_ROW_75_1240 VGND VPWR sky130_fd_sc_hd__tapvpwrvgnd_1
XFILLER_0_20_630 VGND VGND VPWR VPWR sky130_fd_sc_hd__fill_2
XANTENNA__5809__A1 _1072_ VGND VGND VPWR VPWR sky130_fd_sc_hd__diode_2
XTAP_TAPCELL_ROW_9_380 VGND VPWR sky130_fd_sc_hd__tapvpwrvgnd_1
XPHY_EDGE_ROW_10_Right_10 VGND VGND VPWR VPWR sky130_fd_sc_hd__decap_3
XANTENNA__4493__B1 _1025_ VGND VGND VPWR VPWR sky130_fd_sc_hd__diode_2
XFILLER_0_78_129 VGND VGND VPWR VPWR sky130_fd_sc_hd__fill_1
X_5981_ net87 _2681_ VGND VGND VPWR VPWR _2701_ sky130_fd_sc_hd__or2_1
XANTENNA__8082__S _3973_ VGND VGND VPWR VPWR sky130_fd_sc_hd__diode_2
XTAP_TAPCELL_ROW_86_1380 VGND VPWR sky130_fd_sc_hd__tapvpwrvgnd_1
Xclkbuf_leaf_44_clk clknet_4_6_0_clk VGND VGND VPWR VPWR clknet_leaf_44_clk sky130_fd_sc_hd__clkbuf_8
X_4932_ _1695_ _1696_ _1634_ VGND VGND VPWR VPWR _1697_ sky130_fd_sc_hd__o21a_1
XFILLER_0_59_365 VGND VGND VPWR VPWR sky130_fd_sc_hd__decap_4
XFILLER_0_47_505 VGND VGND VPWR VPWR sky130_fd_sc_hd__fill_1
X_7720_ registers\[24\]\[28\] _3493_ _3779_ VGND VGND VPWR VPWR _3788_ sky130_fd_sc_hd__mux2_1
XANTENNA__4796__A1 _1381_ VGND VGND VPWR VPWR sky130_fd_sc_hd__diode_2
XFILLER_0_47_527 VGND VGND VPWR VPWR sky130_fd_sc_hd__fill_2
X_7651_ _3127_ registers\[23\]\[28\] _3742_ VGND VGND VPWR VPWR _3751_ sky130_fd_sc_hd__mux2_1
X_6602_ registers\[0\]\[1\] _2964_ _3175_ VGND VGND VPWR VPWR _3177_ sky130_fd_sc_hd__mux2_1
X_4863_ net3 VGND VGND VPWR VPWR _1631_ sky130_fd_sc_hd__buf_4
XFILLER_0_43_711 VGND VGND VPWR VPWR sky130_fd_sc_hd__fill_2
X_4794_ registers\[0\]\[28\] registers\[1\]\[28\] registers\[2\]\[28\] registers\[3\]\[28\]
+ _1550_ _1551_ VGND VGND VPWR VPWR _1566_ sky130_fd_sc_hd__mux4_1
X_7582_ _3714_ VGND VGND VPWR VPWR _0212_ sky130_fd_sc_hd__clkbuf_1
X_9321_ clknet_leaf_16_clk _0418_ VGND VGND VPWR VPWR registers\[2\]\[9\] sky130_fd_sc_hd__dfxtp_1
X_6533_ _3139_ VGND VGND VPWR VPWR _0762_ sky130_fd_sc_hd__clkbuf_1
XANTENNA__4643__S1 _1419_ VGND VGND VPWR VPWR sky130_fd_sc_hd__diode_2
X_6464_ _3092_ registers\[29\]\[11\] _3090_ VGND VGND VPWR VPWR _3093_ sky130_fd_sc_hd__mux2_1
XFILLER_0_113_621 VPWR VGND VPWR VGND sky130_ef_sc_hd__decap_12
XANTENNA__5735__A _1145_ VGND VGND VPWR VPWR sky130_fd_sc_hd__diode_2
X_9252_ clknet_leaf_28_clk _0349_ VGND VGND VPWR VPWR registers\[27\]\[4\] sky130_fd_sc_hd__dfxtp_1
XANTENNA__7426__S _3623_ VGND VGND VPWR VPWR sky130_fd_sc_hd__diode_2
XANTENNA__6330__S _3004_ VGND VGND VPWR VPWR sky130_fd_sc_hd__diode_2
XANTENNA__8111__A _3972_ VGND VGND VPWR VPWR sky130_fd_sc_hd__diode_2
XFILLER_0_88_41 VGND VGND VPWR VPWR sky130_fd_sc_hd__fill_2
XFILLER_0_70_596 VGND VGND VPWR VPWR sky130_fd_sc_hd__fill_2
X_8203_ _4043_ VGND VGND VPWR VPWR _0504_ sky130_fd_sc_hd__clkbuf_1
Xoutput110 net110 VGND VGND VPWR VPWR rd1[7] sky130_fd_sc_hd__buf_1
X_5415_ registers\[16\]\[29\] registers\[17\]\[29\] registers\[18\]\[29\] registers\[19\]\[29\]
+ _2072_ _2073_ VGND VGND VPWR VPWR _2154_ sky130_fd_sc_hd__mux4_1
XFILLER_0_100_304 VGND VGND VPWR VPWR sky130_fd_sc_hd__fill_2
X_6395_ _3049_ VGND VGND VPWR VPWR _0714_ sky130_fd_sc_hd__clkbuf_1
Xoutput143 net143 VGND VGND VPWR VPWR rd2[8] sky130_fd_sc_hd__buf_1
Xoutput121 net121 VGND VGND VPWR VPWR rd2[17] sky130_fd_sc_hd__buf_1
Xoutput132 net132 VGND VGND VPWR VPWR rd2[27] sky130_fd_sc_hd__buf_1
X_9183_ clknet_leaf_106_clk _0280_ VGND VGND VPWR VPWR registers\[24\]\[31\] sky130_fd_sc_hd__dfxtp_1
X_5346_ registers\[24\]\[25\] registers\[25\]\[25\] registers\[26\]\[25\] registers\[27\]\[25\]
+ _2027_ _2028_ VGND VGND VPWR VPWR _2089_ sky130_fd_sc_hd__mux4_1
X_8134_ _3026_ registers\[30\]\[31\] _3972_ VGND VGND VPWR VPWR _4007_ sky130_fd_sc_hd__mux2_1
X_8065_ _3970_ VGND VGND VPWR VPWR _0439_ sky130_fd_sc_hd__clkbuf_1
XFILLER_0_10_195 VGND VGND VPWR VPWR sky130_fd_sc_hd__fill_1
X_5277_ _2022_ _2023_ _1856_ VGND VGND VPWR VPWR _2024_ sky130_fd_sc_hd__mux2_1
XANTENNA__5470__A net120 VGND VGND VPWR VPWR sky130_fd_sc_hd__diode_2
XANTENNA__7161__S _3477_ VGND VGND VPWR VPWR sky130_fd_sc_hd__diode_2
X_4228_ registers\[20\]\[0\] registers\[21\]\[0\] registers\[22\]\[0\] registers\[23\]\[0\]
+ _1026_ _1027_ VGND VGND VPWR VPWR _1028_ sky130_fd_sc_hd__mux4_1
X_7016_ _3399_ VGND VGND VPWR VPWR _0985_ sky130_fd_sc_hd__clkbuf_1
XPHY_EDGE_ROW_106_Right_106 VGND VGND VPWR VPWR sky130_fd_sc_hd__decap_3
X_8967_ clknet_leaf_24_clk _0064_ VGND VGND VPWR VPWR registers\[18\]\[7\] sky130_fd_sc_hd__dfxtp_1
XTAP_TAPCELL_ROW_26_603 VGND VPWR sky130_fd_sc_hd__tapvpwrvgnd_1
XTAP_TAPCELL_ROW_54_956 VGND VPWR sky130_fd_sc_hd__tapvpwrvgnd_1
X_7918_ _3121_ registers\[27\]\[25\] _3887_ VGND VGND VPWR VPWR _3893_ sky130_fd_sc_hd__mux2_1
Xclkbuf_leaf_35_clk clknet_4_7_0_clk VGND VGND VPWR VPWR clknet_leaf_35_clk sky130_fd_sc_hd__clkbuf_8
XFILLER_0_77_173 VGND VGND VPWR VPWR sky130_fd_sc_hd__fill_1
XFILLER_0_77_151 VGND VGND VPWR VPWR sky130_fd_sc_hd__fill_2
XTAP_TAPCELL_ROW_54_967 VGND VPWR sky130_fd_sc_hd__tapvpwrvgnd_1
X_8898_ clknet_leaf_1_clk _1019_ VGND VGND VPWR VPWR registers\[16\]\[2\] sky130_fd_sc_hd__dfxtp_1
XFILLER_0_65_335 VGND VGND VPWR VPWR sky130_fd_sc_hd__fill_1
X_7849_ _3856_ VGND VGND VPWR VPWR _0337_ sky130_fd_sc_hd__clkbuf_1
XFILLER_0_93_677 VPWR VGND VPWR VGND sky130_ef_sc_hd__decap_12
XFILLER_0_80_305 VGND VGND VPWR VPWR sky130_fd_sc_hd__decap_3
X_9519_ clknet_leaf_47_clk _0616_ VGND VGND VPWR VPWR registers\[8\]\[15\] sky130_fd_sc_hd__dfxtp_1
XPHY_EDGE_ROW_12_Left_132 VGND VGND VPWR VPWR sky130_fd_sc_hd__decap_3
XFILLER_0_34_722 VGND VGND VPWR VPWR sky130_fd_sc_hd__fill_2
XFILLER_0_116_481 VGND VGND VPWR VPWR sky130_fd_sc_hd__fill_2
XANTENNA__5645__A _1049_ VGND VGND VPWR VPWR sky130_fd_sc_hd__diode_2
XANTENNA__7336__S _3575_ VGND VGND VPWR VPWR sky130_fd_sc_hd__diode_2
XANTENNA__8150__A1 _3447_ VGND VGND VPWR VPWR sky130_fd_sc_hd__diode_2
XFILLER_0_21_427 VGND VGND VPWR VPWR sky130_fd_sc_hd__fill_2
XFILLER_0_33_276 VGND VGND VPWR VPWR sky130_fd_sc_hd__fill_2
XFILLER_0_21_449 VGND VGND VPWR VPWR sky130_fd_sc_hd__fill_2
XTAP_TAPCELL_ROW_111_1705 VGND VPWR sky130_fd_sc_hd__tapvpwrvgnd_1
XANTENNA__8167__S _4020_ VGND VGND VPWR VPWR sky130_fd_sc_hd__diode_2
XANTENNA_input47_A wd3[9] VGND VGND VPWR VPWR sky130_fd_sc_hd__diode_2
XANTENNA__7071__S _3420_ VGND VGND VPWR VPWR sky130_fd_sc_hd__diode_2
XTAP_TAPCELL_ROW_70_1170 VGND VPWR sky130_fd_sc_hd__tapvpwrvgnd_1
XFILLER_0_17_26 VGND VGND VPWR VPWR sky130_fd_sc_hd__fill_2
XPHY_EDGE_ROW_21_Left_141 VGND VGND VPWR VPWR sky130_fd_sc_hd__decap_3
XANTENNA__4570__S0 _1126_ VGND VGND VPWR VPWR sky130_fd_sc_hd__diode_2
XTAP_TAPCELL_ROW_109_1678 VGND VPWR sky130_fd_sc_hd__tapvpwrvgnd_1
XFILLER_0_69_630 VGND VGND VPWR VPWR sky130_fd_sc_hd__fill_1
XANTENNA__6415__S _3052_ VGND VGND VPWR VPWR sky130_fd_sc_hd__diode_2
Xclkbuf_leaf_26_clk clknet_4_4_0_clk VGND VGND VPWR VPWR clknet_leaf_26_clk sky130_fd_sc_hd__clkbuf_8
XFILLER_0_69_685 VGND VGND VPWR VPWR sky130_fd_sc_hd__fill_2
XFILLER_0_29_505 VGND VGND VPWR VPWR sky130_fd_sc_hd__decap_3
XFILLER_0_84_666 VGND VGND VPWR VPWR sky130_fd_sc_hd__fill_2
XFILLER_0_83_121 VGND VGND VPWR VPWR sky130_fd_sc_hd__fill_2
XFILLER_0_83_110 VGND VGND VPWR VPWR sky130_fd_sc_hd__fill_2
XFILLER_0_68_195 VGND VGND VPWR VPWR sky130_fd_sc_hd__fill_1
XFILLER_0_56_357 VGND VGND VPWR VPWR sky130_fd_sc_hd__fill_2
XANTENNA__7716__A1 _3489_ VGND VGND VPWR VPWR sky130_fd_sc_hd__diode_2
XFILLER_0_29_549 VGND VGND VPWR VPWR sky130_fd_sc_hd__fill_2
XFILLER_0_84_688 VGND VGND VPWR VPWR sky130_fd_sc_hd__decap_8
XPHY_EDGE_ROW_30_Left_150 VGND VGND VPWR VPWR sky130_fd_sc_hd__decap_3
XANTENNA__4625__S1 _1405_ VGND VGND VPWR VPWR sky130_fd_sc_hd__diode_2
XFILLER_0_37_582 VGND VGND VPWR VPWR sky130_fd_sc_hd__fill_2
Xinput12 a3[3] VGND VGND VPWR VPWR net12 sky130_fd_sc_hd__clkbuf_2
Xinput45 wd3[7] VGND VGND VPWR VPWR net45 sky130_fd_sc_hd__dlymetal6s2s_1
Xinput23 wd3[16] VGND VGND VPWR VPWR net23 sky130_fd_sc_hd__buf_2
XANTENNA__5555__A _1835_ VGND VGND VPWR VPWR sky130_fd_sc_hd__diode_2
Xinput34 wd3[26] VGND VGND VPWR VPWR net34 sky130_fd_sc_hd__clkbuf_4
XANTENNA__7246__S _3502_ VGND VGND VPWR VPWR sky130_fd_sc_hd__diode_2
XFILLER_0_107_492 VGND VGND VPWR VPWR sky130_fd_sc_hd__fill_2
XFILLER_0_52_585 VGND VGND VPWR VPWR sky130_fd_sc_hd__decap_3
XFILLER_0_40_725 VGND VGND VPWR VPWR sky130_fd_sc_hd__fill_1
XFILLER_0_3_159 VGND VGND VPWR VPWR sky130_fd_sc_hd__fill_2
XFILLER_0_12_416 VGND VGND VPWR VPWR sky130_fd_sc_hd__fill_2
XFILLER_0_110_624 VGND VGND VPWR VPWR sky130_fd_sc_hd__decap_8
XFILLER_0_110_613 VGND VGND VPWR VPWR sky130_fd_sc_hd__fill_2
X_5200_ registers\[12\]\[17\] registers\[13\]\[17\] registers\[14\]\[17\] registers\[15\]\[17\]
+ _1773_ _1775_ VGND VGND VPWR VPWR _1951_ sky130_fd_sc_hd__mux4_1
X_6180_ _2849_ _2888_ _2307_ VGND VGND VPWR VPWR _2889_ sky130_fd_sc_hd__mux2_1
XFILLER_0_110_668 VGND VGND VPWR VPWR sky130_fd_sc_hd__decap_8
X_5131_ _1884_ _1885_ _1695_ VGND VGND VPWR VPWR _1886_ sky130_fd_sc_hd__mux2_1
X_5062_ _1692_ VGND VGND VPWR VPWR _1821_ sky130_fd_sc_hd__buf_4
XTAP_TAPCELL_ROW_4_309 VGND VPWR sky130_fd_sc_hd__tapvpwrvgnd_1
XFILLER_0_74_10 VGND VGND VPWR VPWR sky130_fd_sc_hd__decap_4
XFILLER_0_35_7 VGND VGND VPWR VPWR sky130_fd_sc_hd__decap_4
XFILLER_0_74_76 VGND VGND VPWR VPWR sky130_fd_sc_hd__fill_2
XANTENNA__4561__S0 _1344_ VGND VGND VPWR VPWR sky130_fd_sc_hd__diode_2
X_8821_ clknet_leaf_82_clk _0942_ VGND VGND VPWR VPWR registers\[13\]\[21\] sky130_fd_sc_hd__dfxtp_1
X_8752_ clknet_leaf_63_clk _0873_ VGND VGND VPWR VPWR registers\[11\]\[16\] sky130_fd_sc_hd__dfxtp_1
XANTENNA__4634__A _1414_ VGND VGND VPWR VPWR sky130_fd_sc_hd__diode_2
XFILLER_0_87_482 VGND VGND VPWR VPWR sky130_fd_sc_hd__decap_3
Xclkbuf_leaf_17_clk clknet_4_6_0_clk VGND VGND VPWR VPWR clknet_leaf_17_clk sky130_fd_sc_hd__clkbuf_8
X_5964_ _2682_ _2684_ _2276_ VGND VGND VPWR VPWR _2685_ sky130_fd_sc_hd__a21oi_1
X_7703_ _3756_ VGND VGND VPWR VPWR _3779_ sky130_fd_sc_hd__clkbuf_8
XFILLER_0_118_713 VPWR VGND VPWR VGND sky130_ef_sc_hd__decap_12
XFILLER_0_117_201 VGND VGND VPWR VPWR sky130_fd_sc_hd__decap_4
X_8683_ clknet_leaf_57_clk _0804_ VGND VGND VPWR VPWR registers\[0\]\[11\] sky130_fd_sc_hd__dfxtp_1
X_5895_ _2441_ _2567_ _2570_ _2444_ VGND VGND VPWR VPWR _2620_ sky130_fd_sc_hd__o22a_1
XFILLER_0_74_132 VGND VGND VPWR VPWR sky130_fd_sc_hd__decap_4
X_4915_ registers\[20\]\[3\] registers\[21\]\[3\] registers\[22\]\[3\] registers\[23\]\[3\]
+ _1678_ _1679_ VGND VGND VPWR VPWR _1680_ sky130_fd_sc_hd__mux4_1
XTAP_TAPCELL_ROW_51_926 VGND VPWR sky130_fd_sc_hd__tapvpwrvgnd_1
XFILLER_0_47_324 VGND VGND VPWR VPWR sky130_fd_sc_hd__fill_2
XANTENNA__4864__S1 _1618_ VGND VGND VPWR VPWR sky130_fd_sc_hd__diode_2
XFILLER_0_117_234 VGND VGND VPWR VPWR sky130_fd_sc_hd__fill_2
XFILLER_0_117_223 VGND VGND VPWR VPWR sky130_fd_sc_hd__fill_1
XFILLER_0_114_93 VGND VGND VPWR VPWR sky130_fd_sc_hd__decap_4
XFILLER_0_75_699 VGND VGND VPWR VPWR sky130_fd_sc_hd__decap_8
XFILLER_0_75_688 VGND VGND VPWR VPWR sky130_fd_sc_hd__decap_6
XFILLER_0_47_357 VGND VGND VPWR VPWR sky130_fd_sc_hd__fill_2
XFILLER_0_7_421 VGND VGND VPWR VPWR sky130_fd_sc_hd__fill_2
X_4846_ _1438_ _1606_ _1610_ _1614_ VGND VGND VPWR VPWR _1615_ sky130_fd_sc_hd__a22o_1
X_7634_ _3719_ VGND VGND VPWR VPWR _3742_ sky130_fd_sc_hd__clkbuf_8
XFILLER_0_105_407 VGND VGND VPWR VPWR sky130_fd_sc_hd__fill_2
XANTENNA__4616__S1 _1339_ VGND VGND VPWR VPWR sky130_fd_sc_hd__diode_2
X_7565_ _3705_ VGND VGND VPWR VPWR _0204_ sky130_fd_sc_hd__clkbuf_1
XFILLER_0_16_722 VGND VGND VPWR VPWR sky130_fd_sc_hd__decap_8
XFILLER_0_28_571 VGND VGND VPWR VPWR sky130_fd_sc_hd__decap_6
XTAP_TAPCELL_ROW_31_661 VGND VPWR sky130_fd_sc_hd__tapvpwrvgnd_1
X_4777_ _1549_ VGND VGND VPWR VPWR net132 sky130_fd_sc_hd__buf_1
X_9304_ clknet_leaf_86_clk _0401_ VGND VGND VPWR VPWR registers\[28\]\[24\] sky130_fd_sc_hd__dfxtp_1
X_6516_ _3127_ registers\[29\]\[28\] _3111_ VGND VGND VPWR VPWR _3128_ sky130_fd_sc_hd__mux2_1
XFILLER_0_15_232 VGND VGND VPWR VPWR sky130_fd_sc_hd__fill_1
XFILLER_0_113_440 VGND VGND VPWR VPWR sky130_fd_sc_hd__fill_2
X_7496_ _3108_ registers\[21\]\[19\] _3659_ VGND VGND VPWR VPWR _3669_ sky130_fd_sc_hd__mux2_1
XFILLER_0_43_596 VGND VGND VPWR VPWR sky130_fd_sc_hd__decap_8
XFILLER_0_31_714 VGND VGND VPWR VPWR sky130_fd_sc_hd__fill_2
X_6447_ net44 VGND VGND VPWR VPWR _3081_ sky130_fd_sc_hd__clkbuf_2
X_9235_ clknet_leaf_96_clk _0332_ VGND VGND VPWR VPWR registers\[26\]\[19\] sky130_fd_sc_hd__dfxtp_1
XFILLER_0_3_660 VGND VGND VPWR VPWR sky130_fd_sc_hd__decap_8
X_9166_ clknet_leaf_38_clk _0263_ VGND VGND VPWR VPWR registers\[24\]\[14\] sky130_fd_sc_hd__dfxtp_1
XFILLER_0_101_646 VGND VGND VPWR VPWR sky130_fd_sc_hd__fill_2
XANTENNA__6694__A1 _2985_ VGND VGND VPWR VPWR sky130_fd_sc_hd__diode_2
X_6378_ _3040_ VGND VGND VPWR VPWR _0706_ sky130_fd_sc_hd__clkbuf_1
XFILLER_0_100_145 VGND VGND VPWR VPWR sky130_fd_sc_hd__decap_3
XFILLER_0_11_493 VGND VGND VPWR VPWR sky130_fd_sc_hd__fill_2
X_5329_ _1969_ VGND VGND VPWR VPWR _2073_ sky130_fd_sc_hd__clkbuf_4
X_8117_ _3998_ VGND VGND VPWR VPWR _0463_ sky130_fd_sc_hd__clkbuf_1
X_9097_ clknet_leaf_8_clk _0194_ VGND VGND VPWR VPWR registers\[22\]\[9\] sky130_fd_sc_hd__dfxtp_1
XANTENNA__4809__A _1381_ VGND VGND VPWR VPWR sky130_fd_sc_hd__diode_2
X_8048_ registers\[2\]\[22\] _3481_ _3959_ VGND VGND VPWR VPWR _3962_ sky130_fd_sc_hd__mux2_1
XTAP_TAPCELL_ROW_39_761 VGND VPWR sky130_fd_sc_hd__tapvpwrvgnd_1
XTAP_TAPCELL_ROW_39_772 VGND VPWR sky130_fd_sc_hd__tapvpwrvgnd_1
XFILLER_0_85_419 VGND VGND VPWR VPWR sky130_fd_sc_hd__fill_1
XFILLER_0_81_614 VGND VGND VPWR VPWR sky130_fd_sc_hd__fill_2
XFILLER_0_26_508 VGND VGND VPWR VPWR sky130_fd_sc_hd__fill_2
XFILLER_0_93_496 VGND VGND VPWR VPWR sky130_fd_sc_hd__fill_2
XFILLER_0_81_658 VGND VGND VPWR VPWR sky130_fd_sc_hd__decap_3
XFILLER_0_53_316 VGND VGND VPWR VPWR sky130_fd_sc_hd__fill_2
XFILLER_0_81_669 VGND VGND VPWR VPWR sky130_fd_sc_hd__decap_3
XFILLER_0_80_157 VGND VGND VPWR VPWR sky130_fd_sc_hd__decap_4
XFILLER_0_110_29 VGND VGND VPWR VPWR sky130_fd_sc_hd__fill_2
XFILLER_0_61_371 VGND VGND VPWR VPWR sky130_fd_sc_hd__fill_2
XTAP_TAPCELL_ROW_59_1032 VGND VPWR sky130_fd_sc_hd__tapvpwrvgnd_1
XANTENNA__4932__A1 _1695_ VGND VGND VPWR VPWR sky130_fd_sc_hd__diode_2
XTAP_TAPCELL_ROW_59_1021 VGND VPWR sky130_fd_sc_hd__tapvpwrvgnd_1
XFILLER_0_61_393 VGND VGND VPWR VPWR sky130_fd_sc_hd__fill_2
XANTENNA__6685__A1 _2976_ VGND VGND VPWR VPWR sky130_fd_sc_hd__diode_2
XANTENNA__5488__A2 _2216_ VGND VGND VPWR VPWR sky130_fd_sc_hd__diode_2
XANTENNA__5032__S1 _1706_ VGND VGND VPWR VPWR sky130_fd_sc_hd__diode_2
XANTENNA__7882__A0 _3085_ VGND VGND VPWR VPWR sky130_fd_sc_hd__diode_2
XFILLER_0_119_27 VGND VGND VPWR VPWR sky130_fd_sc_hd__fill_1
XANTENNA__4719__A _1379_ VGND VGND VPWR VPWR sky130_fd_sc_hd__diode_2
XANTENNA__4448__B1 net8 VGND VGND VPWR VPWR sky130_fd_sc_hd__diode_2
XFILLER_0_28_69 VGND VGND VPWR VPWR sky130_fd_sc_hd__fill_2
XANTENNA__4543__S0 _1132_ VGND VGND VPWR VPWR sky130_fd_sc_hd__diode_2
XFILLER_0_57_600 VGND VGND VPWR VPWR sky130_fd_sc_hd__fill_1
XFILLER_0_9_708 VGND VGND VPWR VPWR sky130_fd_sc_hd__fill_2
XFILLER_0_57_644 VGND VGND VPWR VPWR sky130_fd_sc_hd__fill_2
XFILLER_0_56_121 VGND VGND VPWR VPWR sky130_fd_sc_hd__fill_2
XFILLER_0_8_207 VGND VGND VPWR VPWR sky130_fd_sc_hd__fill_1
XTAP_TAPCELL_ROW_17_477 VGND VPWR sky130_fd_sc_hd__tapvpwrvgnd_1
X_5680_ _2412_ _2413_ net135 VGND VGND VPWR VPWR _2414_ sky130_fd_sc_hd__mux2_1
XFILLER_0_72_603 VGND VGND VPWR VPWR sky130_fd_sc_hd__fill_2
XANTENNA__8360__S _4117_ VGND VGND VPWR VPWR sky130_fd_sc_hd__diode_2
X_4700_ registers\[12\]\[23\] registers\[13\]\[23\] registers\[14\]\[23\] registers\[15\]\[23\]
+ _1347_ _1348_ VGND VGND VPWR VPWR _1477_ sky130_fd_sc_hd__mux4_1
XANTENNA__5176__A1 _1741_ VGND VGND VPWR VPWR sky130_fd_sc_hd__diode_2
XFILLER_0_71_113 VGND VGND VPWR VPWR sky130_fd_sc_hd__decap_3
X_4631_ _1410_ _1411_ _1346_ VGND VGND VPWR VPWR _1412_ sky130_fd_sc_hd__mux2_1
XFILLER_0_115_727 VGND VGND VPWR VPWR sky130_fd_sc_hd__fill_1
XFILLER_0_44_349 VGND VGND VPWR VPWR sky130_fd_sc_hd__fill_2
XFILLER_0_4_413 VGND VGND VPWR VPWR sky130_fd_sc_hd__fill_2
XFILLER_0_4_402 VGND VGND VPWR VPWR sky130_fd_sc_hd__fill_2
XFILLER_0_25_552 VGND VGND VPWR VPWR sky130_fd_sc_hd__fill_2
X_7350_ _3591_ VGND VGND VPWR VPWR _0103_ sky130_fd_sc_hd__clkbuf_1
XFILLER_0_13_703 VPWR VGND VPWR VGND sky130_ef_sc_hd__decap_12
XFILLER_0_25_574 VGND VGND VPWR VPWR sky130_fd_sc_hd__fill_2
X_4562_ _1140_ VGND VGND VPWR VPWR _1346_ sky130_fd_sc_hd__buf_4
X_7281_ registers\[18\]\[14\] _3464_ _3550_ VGND VGND VPWR VPWR _3555_ sky130_fd_sc_hd__mux2_1
X_6301_ net21 VGND VGND VPWR VPWR _2991_ sky130_fd_sc_hd__buf_2
X_4493_ _1132_ _1280_ _1025_ VGND VGND VPWR VPWR _1281_ sky130_fd_sc_hd__o21a_1
XFILLER_0_110_421 VGND VGND VPWR VPWR sky130_fd_sc_hd__fill_2
XANTENNA__5023__S1 _1629_ VGND VGND VPWR VPWR sky130_fd_sc_hd__diode_2
Xclkbuf_leaf_6_clk clknet_4_1_0_clk VGND VGND VPWR VPWR clknet_leaf_6_clk sky130_fd_sc_hd__clkbuf_8
X_6232_ _2202_ _2209_ _2210_ _2815_ _2515_ VGND VGND VPWR VPWR _2938_ sky130_fd_sc_hd__o41a_1
X_9020_ clknet_leaf_109_clk _0117_ VGND VGND VPWR VPWR registers\[1\]\[28\] sky130_fd_sc_hd__dfxtp_1
XANTENNA__7704__S _3779_ VGND VGND VPWR VPWR sky130_fd_sc_hd__diode_2
XFILLER_0_0_641 VGND VGND VPWR VPWR sky130_fd_sc_hd__fill_1
XFILLER_0_110_498 VGND VGND VPWR VPWR sky130_fd_sc_hd__decap_4
XFILLER_0_85_20 VGND VGND VPWR VPWR sky130_fd_sc_hd__decap_4
X_6163_ net131 _2872_ VGND VGND VPWR VPWR _2873_ sky130_fd_sc_hd__xor2_1
XFILLER_0_0_685 VPWR VGND VPWR VGND sky130_ef_sc_hd__decap_12
X_5114_ registers\[28\]\[12\] registers\[29\]\[12\] registers\[30\]\[12\] registers\[31\]\[12\]
+ _1798_ _1799_ VGND VGND VPWR VPWR _1870_ sky130_fd_sc_hd__mux4_1
X_6094_ _2806_ _2807_ VGND VGND VPWR VPWR _2808_ sky130_fd_sc_hd__or2_2
X_5045_ _1801_ _1804_ _1714_ VGND VGND VPWR VPWR _1805_ sky130_fd_sc_hd__mux2_1
XFILLER_0_18_80 VGND VGND VPWR VPWR sky130_fd_sc_hd__fill_2
XFILLER_0_26_3 VGND VGND VPWR VPWR sky130_fd_sc_hd__decap_4
XANTENNA__7659__B net12 VGND VGND VPWR VPWR sky130_fd_sc_hd__diode_2
X_8804_ clknet_leaf_29_clk _0925_ VGND VGND VPWR VPWR registers\[13\]\[4\] sky130_fd_sc_hd__dfxtp_1
XANTENNA__4364__A _1135_ VGND VGND VPWR VPWR sky130_fd_sc_hd__diode_2
X_6996_ _3119_ registers\[14\]\[24\] _3383_ VGND VGND VPWR VPWR _3388_ sky130_fd_sc_hd__mux2_1
XTAP_TAPCELL_ROW_36_731 VGND VPWR sky130_fd_sc_hd__tapvpwrvgnd_1
X_5947_ _2606_ _2668_ _2460_ VGND VGND VPWR VPWR _2669_ sky130_fd_sc_hd__mux2_1
XFILLER_0_48_622 VGND VGND VPWR VPWR sky130_fd_sc_hd__fill_1
XANTENNA__4837__S1 _1379_ VGND VGND VPWR VPWR sky130_fd_sc_hd__diode_2
XANTENNA__6600__A1 _2958_ VGND VGND VPWR VPWR sky130_fd_sc_hd__diode_2
X_8735_ clknet_leaf_10_clk _0856_ VGND VGND VPWR VPWR registers\[10\]\[31\] sky130_fd_sc_hd__dfxtp_1
X_8666_ clknet_leaf_90_clk _0787_ VGND VGND VPWR VPWR registers\[7\]\[26\] sky130_fd_sc_hd__dfxtp_1
XFILLER_0_35_305 VGND VGND VPWR VPWR sky130_fd_sc_hd__fill_2
X_7617_ _3733_ VGND VGND VPWR VPWR _0228_ sky130_fd_sc_hd__clkbuf_1
X_5878_ _2404_ _2587_ _2570_ _2411_ VGND VGND VPWR VPWR _2604_ sky130_fd_sc_hd__o22a_1
XFILLER_0_75_496 VGND VGND VPWR VPWR sky130_fd_sc_hd__decap_4
XFILLER_0_63_636 VGND VGND VPWR VPWR sky130_fd_sc_hd__decap_3
XFILLER_0_63_625 VGND VGND VPWR VPWR sky130_fd_sc_hd__fill_1
XTAP_TAPCELL_ROW_97_1519 VGND VPWR sky130_fd_sc_hd__tapvpwrvgnd_1
X_4829_ _1597_ _1598_ _1346_ VGND VGND VPWR VPWR _1599_ sky130_fd_sc_hd__mux2_1
X_8597_ clknet_leaf_85_clk _0718_ VGND VGND VPWR VPWR registers\[3\]\[21\] sky130_fd_sc_hd__dfxtp_1
X_7548_ _3092_ registers\[22\]\[11\] _3695_ VGND VGND VPWR VPWR _3697_ sky130_fd_sc_hd__mux2_1
XFILLER_0_90_477 VGND VGND VPWR VPWR sky130_fd_sc_hd__decap_6
XFILLER_0_62_168 VGND VGND VPWR VPWR sky130_fd_sc_hd__decap_3
XFILLER_0_43_360 VGND VGND VPWR VPWR sky130_fd_sc_hd__fill_2
X_7479_ _3660_ VGND VGND VPWR VPWR _0163_ sky130_fd_sc_hd__clkbuf_1
XFILLER_0_43_393 VGND VGND VPWR VPWR sky130_fd_sc_hd__fill_2
XANTENNA__7614__S _3731_ VGND VGND VPWR VPWR sky130_fd_sc_hd__diode_2
XFILLER_0_113_281 VGND VGND VPWR VPWR sky130_fd_sc_hd__fill_2
XANTENNA__5014__S1 _1775_ VGND VGND VPWR VPWR sky130_fd_sc_hd__diode_2
XFILLER_0_101_432 VGND VGND VPWR VPWR sky130_fd_sc_hd__fill_2
XFILLER_0_101_410 VGND VGND VPWR VPWR sky130_fd_sc_hd__fill_2
X_9218_ clknet_leaf_0_clk _0315_ VGND VGND VPWR VPWR registers\[26\]\[2\] sky130_fd_sc_hd__dfxtp_1
XFILLER_0_31_555 VGND VGND VPWR VPWR sky130_fd_sc_hd__fill_2
XANTENNA__7616__A0 _3092_ VGND VGND VPWR VPWR sky130_fd_sc_hd__diode_2
XANTENNA__5134__S _1695_ VGND VGND VPWR VPWR sky130_fd_sc_hd__diode_2
XANTENNA__4539__A _1127_ VGND VGND VPWR VPWR sky130_fd_sc_hd__diode_2
XANTENNA__6419__A1 _3022_ VGND VGND VPWR VPWR sky130_fd_sc_hd__diode_2
X_9149_ clknet_leaf_104_clk _0246_ VGND VGND VPWR VPWR registers\[23\]\[29\] sky130_fd_sc_hd__dfxtp_1
XANTENNA__4773__S0 _1404_ VGND VGND VPWR VPWR sky130_fd_sc_hd__diode_2
XANTENNA__4525__S0 _1126_ VGND VGND VPWR VPWR sky130_fd_sc_hd__diode_2
XANTENNA__8445__S _4164_ VGND VGND VPWR VPWR sky130_fd_sc_hd__diode_2
XTAP_TAPCELL_ROW_106_1637 VGND VPWR sky130_fd_sc_hd__tapvpwrvgnd_1
XFILLER_0_85_205 VGND VGND VPWR VPWR sky130_fd_sc_hd__fill_1
XANTENNA__4274__A _1072_ VGND VGND VPWR VPWR sky130_fd_sc_hd__diode_2
XFILLER_0_58_419 VGND VGND VPWR VPWR sky130_fd_sc_hd__fill_1
XFILLER_0_39_611 VGND VGND VPWR VPWR sky130_fd_sc_hd__fill_2
XANTENNA__4828__S1 _1383_ VGND VGND VPWR VPWR sky130_fd_sc_hd__diode_2
XFILLER_0_39_633 VGND VGND VPWR VPWR sky130_fd_sc_hd__fill_2
XFILLER_0_109_532 VGND VGND VPWR VPWR sky130_fd_sc_hd__decap_8
XFILLER_0_109_521 VGND VGND VPWR VPWR sky130_fd_sc_hd__fill_2
XFILLER_0_38_132 VGND VGND VPWR VPWR sky130_fd_sc_hd__fill_2
XTAP_TAPCELL_ROW_14_436 VGND VPWR sky130_fd_sc_hd__tapvpwrvgnd_1
XTAP_TAPCELL_ROW_14_447 VGND VPWR sky130_fd_sc_hd__tapvpwrvgnd_1
XANTENNA__8180__S _4031_ VGND VGND VPWR VPWR sky130_fd_sc_hd__diode_2
XFILLER_0_109_565 VGND VGND VPWR VPWR sky130_fd_sc_hd__fill_1
XFILLER_0_109_554 VGND VGND VPWR VPWR sky130_fd_sc_hd__decap_4
XFILLER_0_109_543 VGND VGND VPWR VPWR sky130_fd_sc_hd__fill_2
XANTENNA__5158__A1 _1714_ VGND VGND VPWR VPWR sky130_fd_sc_hd__diode_2
XANTENNA__8344__A1 _3437_ VGND VGND VPWR VPWR sky130_fd_sc_hd__diode_2
XANTENNA__5309__S _1695_ VGND VGND VPWR VPWR sky130_fd_sc_hd__diode_2
XANTENNA__4905__A1 _1631_ VGND VGND VPWR VPWR sky130_fd_sc_hd__diode_2
XANTENNA__5253__S1 _1997_ VGND VGND VPWR VPWR sky130_fd_sc_hd__diode_2
XFILLER_0_61_190 VGND VGND VPWR VPWR sky130_fd_sc_hd__fill_2
XFILLER_0_1_416 VGND VGND VPWR VPWR sky130_fd_sc_hd__decap_3
XTAP_TAPCELL_ROW_117_1777 VGND VPWR sky130_fd_sc_hd__tapvpwrvgnd_1
XANTENNA__6658__A1 _3020_ VGND VGND VPWR VPWR sky130_fd_sc_hd__diode_2
XFILLER_0_39_57 VGND VGND VPWR VPWR sky130_fd_sc_hd__decap_4
XANTENNA__7607__A0 _3083_ VGND VGND VPWR VPWR sky130_fd_sc_hd__diode_2
XANTENNA__5044__S _1695_ VGND VGND VPWR VPWR sky130_fd_sc_hd__diode_2
XANTENNA__4764__S0 _1404_ VGND VGND VPWR VPWR sky130_fd_sc_hd__diode_2
XANTENNA__4883__S _1634_ VGND VGND VPWR VPWR sky130_fd_sc_hd__diode_2
XFILLER_0_55_78 VGND VGND VPWR VPWR sky130_fd_sc_hd__decap_3
XFILLER_0_77_706 VPWR VGND VPWR VGND sky130_ef_sc_hd__decap_12
XFILLER_0_12_9 VGND VGND VPWR VPWR sky130_fd_sc_hd__fill_2
XFILLER_0_71_11 VPWR VGND VPWR VGND sky130_ef_sc_hd__decap_12
X_6850_ _3287_ VGND VGND VPWR VPWR _3310_ sky130_fd_sc_hd__buf_6
XTAP_TAPCELL_ROW_81_1309 VGND VPWR sky130_fd_sc_hd__tapvpwrvgnd_1
X_5801_ net110 _2528_ VGND VGND VPWR VPWR _2530_ sky130_fd_sc_hd__and2_1
XPHY_EDGE_ROW_8_Right_8 VGND VGND VPWR VPWR sky130_fd_sc_hd__decap_3
X_6781_ registers\[11\]\[20\] _3003_ _3272_ VGND VGND VPWR VPWR _3273_ sky130_fd_sc_hd__mux2_1
XANTENNA__4819__S1 _1391_ VGND VGND VPWR VPWR sky130_fd_sc_hd__diode_2
XFILLER_0_119_329 VGND VGND VPWR VPWR sky130_fd_sc_hd__decap_6
X_5732_ _2238_ _2250_ net135 VGND VGND VPWR VPWR _2464_ sky130_fd_sc_hd__mux2_1
XFILLER_0_71_77 VGND VGND VPWR VPWR sky130_fd_sc_hd__fill_2
XFILLER_0_57_452 VGND VGND VPWR VPWR sky130_fd_sc_hd__fill_2
XFILLER_0_57_441 VGND VGND VPWR VPWR sky130_fd_sc_hd__decap_3
XFILLER_0_9_527 VGND VGND VPWR VPWR sky130_fd_sc_hd__fill_2
X_8520_ registers\[4\]\[20\] net28 _4211_ VGND VGND VPWR VPWR _4212_ sky130_fd_sc_hd__mux2_1
XANTENNA__4912__A _1616_ VGND VGND VPWR VPWR sky130_fd_sc_hd__diode_2
XFILLER_0_45_614 VGND VGND VPWR VPWR sky130_fd_sc_hd__fill_2
XFILLER_0_44_113 VGND VGND VPWR VPWR sky130_fd_sc_hd__fill_2
XFILLER_0_115_524 VGND VGND VPWR VPWR sky130_fd_sc_hd__fill_2
X_5663_ _2275_ _2397_ VGND VGND VPWR VPWR _2398_ sky130_fd_sc_hd__xnor2_1
X_8451_ _4152_ VGND VGND VPWR VPWR _4175_ sky130_fd_sc_hd__clkbuf_8
XFILLER_0_44_146 VGND VGND VPWR VPWR sky130_fd_sc_hd__fill_2
XFILLER_0_103_708 VGND VGND VPWR VPWR sky130_fd_sc_hd__decap_3
X_7402_ _3619_ VGND VGND VPWR VPWR _0127_ sky130_fd_sc_hd__clkbuf_1
X_5594_ _2321_ _2322_ _2327_ _2328_ VGND VGND VPWR VPWR _2329_ sky130_fd_sc_hd__a31o_1
X_8382_ _4138_ VGND VGND VPWR VPWR _0588_ sky130_fd_sc_hd__clkbuf_1
XFILLER_0_60_617 VGND VGND VPWR VPWR sky130_fd_sc_hd__fill_2
X_4614_ _1372_ _1380_ _1388_ _1395_ VGND VGND VPWR VPWR _1396_ sky130_fd_sc_hd__a2bb2o_1
XFILLER_0_4_232 VGND VGND VPWR VPWR sky130_fd_sc_hd__fill_2
XANTENNA__8099__A0 _2991_ VGND VGND VPWR VPWR sky130_fd_sc_hd__diode_2
X_7333_ _3582_ VGND VGND VPWR VPWR _0095_ sky130_fd_sc_hd__clkbuf_1
X_4545_ _1140_ _1329_ VGND VGND VPWR VPWR _1330_ sky130_fd_sc_hd__or2_1
XFILLER_0_4_243 VGND VGND VPWR VPWR sky130_fd_sc_hd__fill_2
XFILLER_0_25_393 VPWR VGND VPWR VGND sky130_ef_sc_hd__decap_12
XFILLER_0_13_577 VGND VGND VPWR VPWR sky130_fd_sc_hd__decap_4
X_4476_ _1116_ _1264_ _1122_ VGND VGND VPWR VPWR _1265_ sky130_fd_sc_hd__o21a_1
X_7264_ registers\[18\]\[6\] _3447_ _3539_ VGND VGND VPWR VPWR _3546_ sky130_fd_sc_hd__mux2_1
XFILLER_0_96_52 VGND VGND VPWR VPWR sky130_fd_sc_hd__fill_2
X_9003_ clknet_leaf_51_clk _0100_ VGND VGND VPWR VPWR registers\[1\]\[11\] sky130_fd_sc_hd__dfxtp_1
XTAP_TAPCELL_ROW_92_1449 VGND VPWR sky130_fd_sc_hd__tapvpwrvgnd_1
XANTENNA__5462__B _1166_ VGND VGND VPWR VPWR sky130_fd_sc_hd__diode_2
XFILLER_0_40_396 VGND VGND VPWR VPWR sky130_fd_sc_hd__decap_6
XFILLER_0_110_251 VGND VGND VPWR VPWR sky130_fd_sc_hd__fill_1
X_7195_ _3509_ VGND VGND VPWR VPWR _0030_ sky130_fd_sc_hd__clkbuf_1
XFILLER_0_96_85 VGND VGND VPWR VPWR sky130_fd_sc_hd__decap_3
X_6215_ _2919_ _2920_ _2429_ VGND VGND VPWR VPWR _2922_ sky130_fd_sc_hd__o21a_1
XPHY_EDGE_ROW_39_Right_39 VGND VGND VPWR VPWR sky130_fd_sc_hd__decap_3
XANTENNA__4755__S0 _1323_ VGND VGND VPWR VPWR sky130_fd_sc_hd__diode_2
X_6146_ _1500_ _2825_ _2707_ VGND VGND VPWR VPWR _2857_ sky130_fd_sc_hd__a21oi_1
XANTENNA__4507__S0 _1160_ VGND VGND VPWR VPWR sky130_fd_sc_hd__diode_2
X_6077_ _2784_ _2785_ _2791_ VGND VGND VPWR VPWR net62 sky130_fd_sc_hd__o21ai_1
X_5028_ registers\[12\]\[7\] registers\[13\]\[7\] registers\[14\]\[7\] registers\[15\]\[7\]
+ _1705_ _1706_ VGND VGND VPWR VPWR _1789_ sky130_fd_sc_hd__mux4_1
XANTENNA__5180__S0 _1763_ VGND VGND VPWR VPWR sky130_fd_sc_hd__diode_2
XFILLER_0_95_514 VGND VGND VPWR VPWR sky130_fd_sc_hd__fill_2
XFILLER_0_68_717 VGND VGND VPWR VPWR sky130_fd_sc_hd__fill_2
X_6979_ _3102_ registers\[14\]\[16\] _3372_ VGND VGND VPWR VPWR _3379_ sky130_fd_sc_hd__mux2_1
XANTENNA__7609__S _3720_ VGND VGND VPWR VPWR sky130_fd_sc_hd__diode_2
XPHY_EDGE_ROW_48_Right_48 VGND VGND VPWR VPWR sky130_fd_sc_hd__decap_3
XFILLER_0_48_463 VGND VGND VPWR VPWR sky130_fd_sc_hd__fill_2
XANTENNA__6513__S _3111_ VGND VGND VPWR VPWR sky130_fd_sc_hd__diode_2
X_8718_ clknet_leaf_39_clk _0839_ VGND VGND VPWR VPWR registers\[10\]\[14\] sky130_fd_sc_hd__dfxtp_1
XTAP_TAPCELL_ROW_101_1578 VGND VPWR sky130_fd_sc_hd__tapvpwrvgnd_1
XTAP_TAPCELL_ROW_101_1567 VGND VPWR sky130_fd_sc_hd__tapvpwrvgnd_1
XFILLER_0_90_230 VGND VGND VPWR VPWR sky130_fd_sc_hd__fill_2
X_8649_ clknet_leaf_18_clk _0770_ VGND VGND VPWR VPWR registers\[7\]\[9\] sky130_fd_sc_hd__dfxtp_1
XTAP_TAPCELL_ROW_11_406 VGND VPWR sky130_fd_sc_hd__tapvpwrvgnd_1
XFILLER_0_35_135 VGND VGND VPWR VPWR sky130_fd_sc_hd__fill_2
XANTENNA__5235__S1 _1720_ VGND VGND VPWR VPWR sky130_fd_sc_hd__diode_2
XFILLER_0_51_617 VGND VGND VPWR VPWR sky130_fd_sc_hd__fill_2
XFILLER_0_44_680 VGND VGND VPWR VPWR sky130_fd_sc_hd__fill_2
XANTENNA__7837__A0 _3108_ VGND VGND VPWR VPWR sky130_fd_sc_hd__diode_2
XPHY_EDGE_ROW_57_Right_57 VGND VGND VPWR VPWR sky130_fd_sc_hd__decap_3
XANTENNA__8175__S _4020_ VGND VGND VPWR VPWR sky130_fd_sc_hd__diode_2
XANTENNA__6484__A net25 VGND VGND VPWR VPWR sky130_fd_sc_hd__diode_2
XTAP_TAPCELL_ROW_19_506 VGND VPWR sky130_fd_sc_hd__tapvpwrvgnd_1
XTAP_TAPCELL_ROW_67_1131 VGND VPWR sky130_fd_sc_hd__tapvpwrvgnd_1
XFILLER_0_25_48 VGND VGND VPWR VPWR sky130_fd_sc_hd__fill_2
XFILLER_0_86_547 VGND VGND VPWR VPWR sky130_fd_sc_hd__fill_1
XPHY_EDGE_ROW_66_Right_66 VGND VGND VPWR VPWR sky130_fd_sc_hd__decap_3
XANTENNA__7519__S _3647_ VGND VGND VPWR VPWR sky130_fd_sc_hd__diode_2
XPHY_EDGE_ROW_4_Left_124 VGND VGND VPWR VPWR sky130_fd_sc_hd__decap_3
XANTENNA__6423__S _3029_ VGND VGND VPWR VPWR sky130_fd_sc_hd__diode_2
XTAP_TAPCELL_ROW_119_1817 VGND VPWR sky130_fd_sc_hd__tapvpwrvgnd_1
XTAP_TAPCELL_ROW_119_1806 VGND VPWR sky130_fd_sc_hd__tapvpwrvgnd_1
XFILLER_0_54_477 VGND VGND VPWR VPWR sky130_fd_sc_hd__fill_1
XFILLER_0_41_105 VGND VGND VPWR VPWR sky130_fd_sc_hd__decap_4
XANTENNA__5563__A _1780_ VGND VGND VPWR VPWR sky130_fd_sc_hd__diode_2
XTAP_TAPCELL_ROW_78_1271 VGND VPWR sky130_fd_sc_hd__tapvpwrvgnd_1
XPHY_EDGE_ROW_75_Right_75 VGND VGND VPWR VPWR sky130_fd_sc_hd__decap_3
XANTENNA__7254__S _3539_ VGND VGND VPWR VPWR sky130_fd_sc_hd__diode_2
X_4330_ _1125_ VGND VGND VPWR VPWR _1126_ sky130_fd_sc_hd__clkbuf_8
XFILLER_0_50_694 VGND VGND VPWR VPWR sky130_fd_sc_hd__decap_6
XFILLER_0_22_374 VGND VGND VPWR VPWR sky130_fd_sc_hd__fill_2
X_4261_ a2[0] VGND VGND VPWR VPWR _1060_ sky130_fd_sc_hd__buf_4
X_6000_ _2714_ _2711_ _2717_ VGND VGND VPWR VPWR _2719_ sky130_fd_sc_hd__o21ai_1
XANTENNA__5502__S _1072_ VGND VGND VPWR VPWR sky130_fd_sc_hd__diode_2
XPHY_EDGE_ROW_84_Right_84 VGND VGND VPWR VPWR sky130_fd_sc_hd__decap_3
XANTENNA__5162__S0 _1806_ VGND VGND VPWR VPWR sky130_fd_sc_hd__diode_2
X_7951_ _3910_ VGND VGND VPWR VPWR _0385_ sky130_fd_sc_hd__clkbuf_1
XFILLER_0_82_43 VGND VGND VPWR VPWR sky130_fd_sc_hd__fill_1
XFILLER_0_77_514 VGND VGND VPWR VPWR sky130_fd_sc_hd__fill_2
X_6902_ _3094_ registers\[13\]\[12\] _3335_ VGND VGND VPWR VPWR _3338_ sky130_fd_sc_hd__mux2_1
X_7882_ _3085_ registers\[27\]\[8\] _3865_ VGND VGND VPWR VPWR _3874_ sky130_fd_sc_hd__mux2_1
X_6833_ _3301_ VGND VGND VPWR VPWR _0900_ sky130_fd_sc_hd__clkbuf_1
XFILLER_0_82_98 VGND VGND VPWR VPWR sky130_fd_sc_hd__fill_2
XFILLER_0_82_76 VGND VGND VPWR VPWR sky130_fd_sc_hd__fill_2
XFILLER_0_77_547 VGND VGND VPWR VPWR sky130_fd_sc_hd__decap_3
XANTENNA__4290__B2 _1034_ VGND VGND VPWR VPWR sky130_fd_sc_hd__diode_2
XFILLER_0_92_506 VGND VGND VPWR VPWR sky130_fd_sc_hd__fill_2
XPHY_EDGE_ROW_59_Left_179 VGND VGND VPWR VPWR sky130_fd_sc_hd__decap_3
XFILLER_0_119_137 VGND VGND VPWR VPWR sky130_fd_sc_hd__decap_3
X_9552_ clknet_leaf_63_clk _0649_ VGND VGND VPWR VPWR registers\[4\]\[16\] sky130_fd_sc_hd__dfxtp_1
X_6764_ registers\[11\]\[12\] _2987_ _3261_ VGND VGND VPWR VPWR _3264_ sky130_fd_sc_hd__mux2_1
XFILLER_0_57_271 VGND VGND VPWR VPWR sky130_fd_sc_hd__decap_3
XANTENNA__6333__S _3004_ VGND VGND VPWR VPWR sky130_fd_sc_hd__diode_2
X_6695_ _3227_ VGND VGND VPWR VPWR _0836_ sky130_fd_sc_hd__clkbuf_1
X_9483_ clknet_leaf_50_clk _0580_ VGND VGND VPWR VPWR registers\[5\]\[11\] sky130_fd_sc_hd__dfxtp_1
X_5715_ _2325_ _2326_ _1070_ VGND VGND VPWR VPWR _2448_ sky130_fd_sc_hd__a21o_1
X_8503_ registers\[4\]\[12\] net19 _4200_ VGND VGND VPWR VPWR _4203_ sky130_fd_sc_hd__mux2_1
X_8434_ _4166_ VGND VGND VPWR VPWR _0612_ sky130_fd_sc_hd__clkbuf_1
X_5646_ _2253_ _2254_ _2380_ VGND VGND VPWR VPWR _2381_ sky130_fd_sc_hd__a21bo_1
XFILLER_0_5_530 VGND VGND VPWR VPWR sky130_fd_sc_hd__fill_2
XFILLER_0_17_179 VGND VGND VPWR VPWR sky130_fd_sc_hd__fill_2
XFILLER_0_33_617 VGND VGND VPWR VPWR sky130_fd_sc_hd__fill_1
XFILLER_0_103_505 VGND VGND VPWR VPWR sky130_fd_sc_hd__fill_2
XPHY_EDGE_ROW_93_Right_93 VGND VGND VPWR VPWR sky130_fd_sc_hd__decap_3
XANTENNA__5542__A1 _2269_ VGND VGND VPWR VPWR sky130_fd_sc_hd__diode_2
X_5577_ _2267_ _2310_ _2312_ VGND VGND VPWR VPWR _2313_ sky130_fd_sc_hd__a21oi_1
X_8365_ registers\[5\]\[11\] _3458_ _4128_ VGND VGND VPWR VPWR _4130_ sky130_fd_sc_hd__mux2_1
XFILLER_0_41_661 VGND VGND VPWR VPWR sky130_fd_sc_hd__fill_2
XANTENNA__4788__S _1381_ VGND VGND VPWR VPWR sky130_fd_sc_hd__diode_2
XFILLER_0_5_585 VGND VGND VPWR VPWR sky130_fd_sc_hd__fill_2
XFILLER_0_13_341 VGND VGND VPWR VPWR sky130_fd_sc_hd__fill_1
XANTENNA__7164__S _3477_ VGND VGND VPWR VPWR sky130_fd_sc_hd__diode_2
X_8296_ _4093_ VGND VGND VPWR VPWR _0547_ sky130_fd_sc_hd__clkbuf_1
X_4528_ _1159_ _1313_ VGND VGND VPWR VPWR _1314_ sky130_fd_sc_hd__nand2_1
X_7316_ registers\[18\]\[31\] _3499_ _3538_ VGND VGND VPWR VPWR _3573_ sky130_fd_sc_hd__mux2_1
X_4459_ _1116_ _1246_ _1248_ _1122_ VGND VGND VPWR VPWR _1249_ sky130_fd_sc_hd__o211a_1
XPHY_EDGE_ROW_68_Left_188 VGND VGND VPWR VPWR sky130_fd_sc_hd__decap_3
X_7247_ _3536_ VGND VGND VPWR VPWR _0055_ sky130_fd_sc_hd__clkbuf_1
XANTENNA__5920__B _2394_ VGND VGND VPWR VPWR sky130_fd_sc_hd__diode_2
X_7178_ net40 VGND VGND VPWR VPWR _3499_ sky130_fd_sc_hd__buf_2
X_6129_ _2298_ _2763_ VGND VGND VPWR VPWR _2841_ sky130_fd_sc_hd__nand2_1
XPHY_EDGE_ROW_77_Left_197 VGND VGND VPWR VPWR sky130_fd_sc_hd__decap_3
XTAP_TAPCELL_ROW_44_829 VGND VPWR sky130_fd_sc_hd__tapvpwrvgnd_1
XANTENNA__5648__A _2267_ VGND VGND VPWR VPWR sky130_fd_sc_hd__diode_2
XFILLER_0_55_208 VGND VGND VPWR VPWR sky130_fd_sc_hd__decap_3
XANTENNA__5456__S1 _2127_ VGND VGND VPWR VPWR sky130_fd_sc_hd__diode_2
XTAP_TAPCELL_ROW_62_1061 VGND VPWR sky130_fd_sc_hd__tapvpwrvgnd_1
XTAP_TAPCELL_ROW_24_575 VGND VPWR sky130_fd_sc_hd__tapvpwrvgnd_1
XFILLER_0_36_433 VGND VGND VPWR VPWR sky130_fd_sc_hd__decap_3
XANTENNA__5781__B2 _2270_ VGND VGND VPWR VPWR sky130_fd_sc_hd__diode_2
XFILLER_0_91_583 VGND VGND VPWR VPWR sky130_fd_sc_hd__fill_1
XFILLER_0_36_477 VGND VGND VPWR VPWR sky130_fd_sc_hd__decap_4
XFILLER_0_106_343 VGND VGND VPWR VPWR sky130_fd_sc_hd__fill_1
XANTENNA__4967__S0 _1631_ VGND VGND VPWR VPWR sky130_fd_sc_hd__diode_2
XANTENNA__4698__S _1124_ VGND VGND VPWR VPWR sky130_fd_sc_hd__diode_2
XTAP_TAPCELL_ROW_114_1747 VGND VPWR sky130_fd_sc_hd__tapvpwrvgnd_1
XTAP_TAPCELL_ROW_114_1736 VGND VPWR sky130_fd_sc_hd__tapvpwrvgnd_1
XANTENNA__4741__C1 _1109_ VGND VGND VPWR VPWR sky130_fd_sc_hd__diode_2
XFILLER_0_32_694 VGND VGND VPWR VPWR sky130_fd_sc_hd__decap_3
XANTENNA__6089__A2 _1454_ VGND VGND VPWR VPWR sky130_fd_sc_hd__diode_2
XFILLER_0_31_193 VGND VGND VPWR VPWR sky130_fd_sc_hd__fill_2
XANTENNA__7802__S _3829_ VGND VGND VPWR VPWR sky130_fd_sc_hd__diode_2
XANTENNA__5392__S0 _2126_ VGND VGND VPWR VPWR sky130_fd_sc_hd__diode_2
XFILLER_0_52_24 VGND VGND VPWR VPWR sky130_fd_sc_hd__fill_2
XANTENNA__8538__A1 net37 VGND VGND VPWR VPWR sky130_fd_sc_hd__diode_2
XFILLER_0_74_506 VGND VGND VPWR VPWR sky130_fd_sc_hd__fill_2
XFILLER_0_117_608 VGND VGND VPWR VPWR sky130_fd_sc_hd__fill_2
XFILLER_0_67_580 VGND VGND VPWR VPWR sky130_fd_sc_hd__decap_6
XANTENNA__5447__S1 _2120_ VGND VGND VPWR VPWR sky130_fd_sc_hd__diode_2
XANTENNA__5772__A1 _2399_ VGND VGND VPWR VPWR sky130_fd_sc_hd__diode_2
XFILLER_0_27_422 VGND VGND VPWR VPWR sky130_fd_sc_hd__fill_2
XFILLER_0_82_561 VGND VGND VPWR VPWR sky130_fd_sc_hd__fill_2
X_5500_ _2220_ _2235_ VGND VGND VPWR VPWR _2236_ sky130_fd_sc_hd__nand2_1
XFILLER_0_15_617 VGND VGND VPWR VPWR sky130_fd_sc_hd__fill_2
X_6480_ _3103_ VGND VGND VPWR VPWR _0745_ sky130_fd_sc_hd__clkbuf_1
XFILLER_0_42_436 VGND VGND VPWR VPWR sky130_fd_sc_hd__decap_4
XFILLER_0_112_302 VGND VGND VPWR VPWR sky130_fd_sc_hd__decap_4
XANTENNA__4958__S0 _1678_ VGND VGND VPWR VPWR sky130_fd_sc_hd__diode_2
X_5431_ registers\[20\]\[30\] registers\[21\]\[30\] registers\[22\]\[30\] registers\[23\]\[30\]
+ _1996_ _1997_ VGND VGND VPWR VPWR _2169_ sky130_fd_sc_hd__mux4_1
X_8150_ registers\[9\]\[6\] _3447_ _4009_ VGND VGND VPWR VPWR _4016_ sky130_fd_sc_hd__mux2_1
XANTENNA__4401__S _1132_ VGND VGND VPWR VPWR sky130_fd_sc_hd__diode_2
XFILLER_0_50_480 VGND VGND VPWR VPWR sky130_fd_sc_hd__fill_2
XFILLER_0_23_683 VGND VGND VPWR VPWR sky130_fd_sc_hd__decap_3
X_5362_ _2102_ _2103_ _2031_ VGND VGND VPWR VPWR _2104_ sky130_fd_sc_hd__mux2_1
X_7101_ net44 VGND VGND VPWR VPWR _3447_ sky130_fd_sc_hd__buf_2
XFILLER_0_100_519 VGND VGND VPWR VPWR sky130_fd_sc_hd__fill_1
X_4313_ _1073_ VGND VGND VPWR VPWR _1109_ sky130_fd_sc_hd__buf_8
X_8081_ _3979_ VGND VGND VPWR VPWR _0446_ sky130_fd_sc_hd__clkbuf_1
XFILLER_0_50_491 VGND VGND VPWR VPWR sky130_fd_sc_hd__fill_1
XFILLER_0_2_577 VGND VGND VPWR VPWR sky130_fd_sc_hd__decap_3
X_7032_ _3407_ VGND VGND VPWR VPWR _0993_ sky130_fd_sc_hd__clkbuf_1
X_5293_ _2035_ _2036_ _2037_ _2038_ _1689_ _1701_ VGND VGND VPWR VPWR _2039_ sky130_fd_sc_hd__mux4_1
XANTENNA__7712__S _3779_ VGND VGND VPWR VPWR sky130_fd_sc_hd__diode_2
X_4244_ net6 _1043_ _1034_ VGND VGND VPWR VPWR _1044_ sky130_fd_sc_hd__o21a_1
XANTENNA__5383__S0 _2119_ VGND VGND VPWR VPWR sky130_fd_sc_hd__diode_2
XFILLER_0_93_53 VGND VGND VPWR VPWR sky130_fd_sc_hd__fill_1
X_8983_ clknet_leaf_75_clk _0080_ VGND VGND VPWR VPWR registers\[18\]\[23\] sky130_fd_sc_hd__dfxtp_1
X_7934_ _2958_ registers\[28\]\[0\] _3901_ VGND VGND VPWR VPWR _3902_ sky130_fd_sc_hd__mux2_1
X_7865_ _3864_ VGND VGND VPWR VPWR _3865_ sky130_fd_sc_hd__clkbuf_8
XFILLER_0_92_303 VGND VGND VPWR VPWR sky130_fd_sc_hd__fill_2
XANTENNA__4372__A _1166_ VGND VGND VPWR VPWR sky130_fd_sc_hd__diode_2
XFILLER_0_58_580 VGND VGND VPWR VPWR sky130_fd_sc_hd__decap_4
X_6816_ _3292_ VGND VGND VPWR VPWR _0892_ sky130_fd_sc_hd__clkbuf_1
XANTENNA__5438__S1 _1969_ VGND VGND VPWR VPWR sky130_fd_sc_hd__diode_2
XFILLER_0_9_110 VGND VGND VPWR VPWR sky130_fd_sc_hd__fill_2
XFILLER_0_18_400 VGND VGND VPWR VPWR sky130_fd_sc_hd__fill_2
XANTENNA__7386__C net13 VGND VGND VPWR VPWR sky130_fd_sc_hd__diode_2
X_7796_ _3359_ _3755_ VGND VGND VPWR VPWR _3828_ sky130_fd_sc_hd__nand2_4
X_6747_ registers\[11\]\[4\] _2970_ _3250_ VGND VGND VPWR VPWR _3255_ sky130_fd_sc_hd__mux2_1
XANTENNA__6960__A0 _3083_ VGND VGND VPWR VPWR sky130_fd_sc_hd__diode_2
X_9535_ clknet_leaf_11_clk _0632_ VGND VGND VPWR VPWR registers\[8\]\[31\] sky130_fd_sc_hd__dfxtp_1
XANTENNA__6998__S _3383_ VGND VGND VPWR VPWR sky130_fd_sc_hd__diode_2
XFILLER_0_73_561 VGND VGND VPWR VPWR sky130_fd_sc_hd__decap_3
XFILLER_0_61_712 VGND VGND VPWR VPWR sky130_fd_sc_hd__fill_2
XFILLER_0_45_263 VGND VGND VPWR VPWR sky130_fd_sc_hd__fill_1
XFILLER_0_9_198 VGND VGND VPWR VPWR sky130_fd_sc_hd__fill_2
XTAP_TAPCELL_ROW_21_534 VGND VPWR sky130_fd_sc_hd__tapvpwrvgnd_1
X_6678_ _3218_ VGND VGND VPWR VPWR _0828_ sky130_fd_sc_hd__clkbuf_1
X_9466_ clknet_leaf_77_clk _0563_ VGND VGND VPWR VPWR registers\[31\]\[26\] sky130_fd_sc_hd__dfxtp_1
XFILLER_0_33_414 VGND VGND VPWR VPWR sky130_fd_sc_hd__fill_2
XFILLER_0_33_447 VGND VGND VPWR VPWR sky130_fd_sc_hd__fill_1
X_5629_ net138 _2345_ _2363_ VGND VGND VPWR VPWR _2364_ sky130_fd_sc_hd__a21oi_1
X_8417_ _4157_ VGND VGND VPWR VPWR _0604_ sky130_fd_sc_hd__clkbuf_1
X_9397_ clknet_leaf_83_clk _0494_ VGND VGND VPWR VPWR registers\[9\]\[21\] sky130_fd_sc_hd__dfxtp_1
XFILLER_0_103_335 VGND VGND VPWR VPWR sky130_fd_sc_hd__fill_1
X_8348_ registers\[5\]\[3\] _3441_ _4117_ VGND VGND VPWR VPWR _4121_ sky130_fd_sc_hd__mux2_1
XFILLER_0_14_694 VGND VGND VPWR VPWR sky130_fd_sc_hd__fill_2
XANTENNA__7268__A1 _3451_ VGND VGND VPWR VPWR sky130_fd_sc_hd__diode_2
XANTENNA__7622__S _3731_ VGND VGND VPWR VPWR sky130_fd_sc_hd__diode_2
X_8279_ _4084_ VGND VGND VPWR VPWR _0539_ sky130_fd_sc_hd__clkbuf_1
XANTENNA__5142__S _1752_ VGND VGND VPWR VPWR sky130_fd_sc_hd__diode_2
XPHY_EDGE_ROW_85_Left_205 VGND VGND VPWR VPWR sky130_fd_sc_hd__decap_3
XANTENNA__6243__A2 _2515_ VGND VGND VPWR VPWR sky130_fd_sc_hd__diode_2
XTAP_TAPCELL_ROW_29_634 VGND VPWR sky130_fd_sc_hd__tapvpwrvgnd_1
XTAP_TAPCELL_ROW_1_270 VGND VPWR sky130_fd_sc_hd__tapvpwrvgnd_1
XFILLER_0_68_333 VGND VGND VPWR VPWR sky130_fd_sc_hd__fill_2
XTAP_TAPCELL_ROW_57_998 VGND VPWR sky130_fd_sc_hd__tapvpwrvgnd_1
XFILLER_0_56_506 VGND VGND VPWR VPWR sky130_fd_sc_hd__fill_2
XFILLER_0_37_720 VGND VGND VPWR VPWR sky130_fd_sc_hd__decap_6
XANTENNA__5378__A _2097_ VGND VGND VPWR VPWR sky130_fd_sc_hd__diode_2
XANTENNA__7069__S _3420_ VGND VGND VPWR VPWR sky130_fd_sc_hd__diode_2
XFILLER_0_49_591 VGND VGND VPWR VPWR sky130_fd_sc_hd__fill_2
XFILLER_0_22_38 VGND VGND VPWR VPWR sky130_fd_sc_hd__fill_2
XFILLER_0_119_490 VGND VGND VPWR VPWR sky130_fd_sc_hd__fill_1
XANTENNA__5754__A1 net139 VGND VGND VPWR VPWR sky130_fd_sc_hd__diode_2
XFILLER_0_64_572 VGND VGND VPWR VPWR sky130_fd_sc_hd__fill_2
XFILLER_0_52_701 VGND VGND VPWR VPWR sky130_fd_sc_hd__decap_4
XFILLER_0_24_403 VGND VGND VPWR VPWR sky130_fd_sc_hd__fill_2
XFILLER_0_36_230 VGND VGND VPWR VPWR sky130_fd_sc_hd__fill_2
XPHY_EDGE_ROW_94_Left_214 VGND VGND VPWR VPWR sky130_fd_sc_hd__decap_3
XFILLER_0_91_391 VGND VGND VPWR VPWR sky130_fd_sc_hd__fill_1
XFILLER_0_64_583 VGND VGND VPWR VPWR sky130_fd_sc_hd__decap_3
XANTENNA__6002__A _2317_ VGND VGND VPWR VPWR sky130_fd_sc_hd__diode_2
XANTENNA__5317__S _1695_ VGND VGND VPWR VPWR sky130_fd_sc_hd__diode_2
XFILLER_0_11_108 VGND VGND VPWR VPWR sky130_fd_sc_hd__fill_2
XTAP_TAPCELL_ROW_75_1230 VGND VPWR sky130_fd_sc_hd__tapvpwrvgnd_1
XANTENNA__5841__A _1108_ VGND VGND VPWR VPWR sky130_fd_sc_hd__diode_2
XTAP_TAPCELL_ROW_9_370 VGND VPWR sky130_fd_sc_hd__tapvpwrvgnd_1
XFILLER_0_20_686 VGND VGND VPWR VPWR sky130_fd_sc_hd__fill_2
XTAP_TAPCELL_ROW_9_381 VGND VPWR sky130_fd_sc_hd__tapvpwrvgnd_1
XFILLER_0_47_79 VGND VGND VPWR VPWR sky130_fd_sc_hd__fill_2
XFILLER_0_47_57 VGND VGND VPWR VPWR sky130_fd_sc_hd__fill_2
XANTENNA__4493__A1 _1132_ VGND VGND VPWR VPWR sky130_fd_sc_hd__diode_2
XANTENNA__4891__S _1627_ VGND VGND VPWR VPWR sky130_fd_sc_hd__diode_2
XFILLER_0_2_37 VPWR VGND VPWR VGND sky130_ef_sc_hd__decap_12
XANTENNA__7431__A1 _3476_ VGND VGND VPWR VPWR sky130_fd_sc_hd__diode_2
XANTENNA__8363__S _4128_ VGND VGND VPWR VPWR sky130_fd_sc_hd__diode_2
X_5980_ _2630_ _2698_ VGND VGND VPWR VPWR _2700_ sky130_fd_sc_hd__nand2_1
XTAP_TAPCELL_ROW_86_1381 VGND VPWR sky130_fd_sc_hd__tapvpwrvgnd_1
XFILLER_0_63_89 VGND VGND VPWR VPWR sky130_fd_sc_hd__fill_2
X_4931_ registers\[12\]\[3\] registers\[13\]\[3\] registers\[14\]\[3\] registers\[15\]\[3\]
+ _1690_ _1692_ VGND VGND VPWR VPWR _1696_ sky130_fd_sc_hd__mux4_1
X_7650_ _3750_ VGND VGND VPWR VPWR _0244_ sky130_fd_sc_hd__clkbuf_1
XANTENNA__5288__A _2034_ VGND VGND VPWR VPWR sky130_fd_sc_hd__diode_2
X_4862_ registers\[12\]\[0\] registers\[13\]\[0\] registers\[14\]\[0\] registers\[15\]\[0\]
+ _1628_ _1629_ VGND VGND VPWR VPWR _1630_ sky130_fd_sc_hd__mux4_1
X_6601_ _3176_ VGND VGND VPWR VPWR _0793_ sky130_fd_sc_hd__clkbuf_1
XFILLER_0_74_369 VGND VGND VPWR VPWR sky130_fd_sc_hd__fill_2
X_9320_ clknet_leaf_16_clk _0417_ VGND VGND VPWR VPWR registers\[2\]\[8\] sky130_fd_sc_hd__dfxtp_1
XFILLER_0_7_636 VGND VGND VPWR VPWR sky130_fd_sc_hd__decap_3
XFILLER_0_6_102 VGND VGND VPWR VPWR sky130_fd_sc_hd__fill_1
X_4793_ registers\[4\]\[28\] registers\[5\]\[28\] registers\[6\]\[28\] registers\[7\]\[28\]
+ _1550_ _1551_ VGND VGND VPWR VPWR _1565_ sky130_fd_sc_hd__mux4_1
X_7581_ _3125_ registers\[22\]\[27\] _3706_ VGND VGND VPWR VPWR _3714_ sky130_fd_sc_hd__mux2_1
XFILLER_0_82_380 VGND VGND VPWR VPWR sky130_fd_sc_hd__fill_2
XFILLER_0_70_531 VGND VGND VPWR VPWR sky130_fd_sc_hd__fill_1
X_6532_ registers\[7\]\[1\] _2964_ _3137_ VGND VGND VPWR VPWR _3139_ sky130_fd_sc_hd__mux2_1
XFILLER_0_12_71 VGND VGND VPWR VPWR sky130_fd_sc_hd__fill_2
X_6463_ net18 VGND VGND VPWR VPWR _3092_ sky130_fd_sc_hd__buf_2
XFILLER_0_88_20 VGND VGND VPWR VPWR sky130_fd_sc_hd__decap_3
X_9251_ clknet_leaf_23_clk _0348_ VGND VGND VPWR VPWR registers\[27\]\[3\] sky130_fd_sc_hd__dfxtp_1
XFILLER_0_12_93 VGND VGND VPWR VPWR sky130_fd_sc_hd__decap_3
XFILLER_0_113_633 VPWR VGND VPWR VGND sky130_ef_sc_hd__decap_12
XFILLER_0_88_64 VGND VGND VPWR VPWR sky130_fd_sc_hd__fill_2
XFILLER_0_70_586 VGND VGND VPWR VPWR sky130_fd_sc_hd__fill_2
XFILLER_0_70_575 VGND VGND VPWR VPWR sky130_fd_sc_hd__fill_1
X_8202_ registers\[9\]\[31\] _3499_ _4008_ VGND VGND VPWR VPWR _4043_ sky130_fd_sc_hd__mux2_1
X_5414_ registers\[20\]\[29\] registers\[21\]\[29\] registers\[22\]\[29\] registers\[23\]\[29\]
+ _2072_ _2073_ VGND VGND VPWR VPWR _2153_ sky130_fd_sc_hd__mux4_1
Xoutput100 net100 VGND VGND VPWR VPWR rd1[27] sky130_fd_sc_hd__buf_1
X_9182_ clknet_leaf_98_clk _0279_ VGND VGND VPWR VPWR registers\[24\]\[30\] sky130_fd_sc_hd__dfxtp_1
XFILLER_0_100_316 VGND VGND VPWR VPWR sky130_fd_sc_hd__fill_2
XANTENNA__5208__A2_N _1950_ VGND VGND VPWR VPWR sky130_fd_sc_hd__diode_2
X_6394_ registers\[3\]\[17\] _2997_ _3041_ VGND VGND VPWR VPWR _3049_ sky130_fd_sc_hd__mux2_1
Xoutput122 net122 VGND VGND VPWR VPWR rd2[18] sky130_fd_sc_hd__buf_1
Xoutput133 net133 VGND VGND VPWR VPWR rd2[28] sky130_fd_sc_hd__buf_1
X_8133_ _4006_ VGND VGND VPWR VPWR _0471_ sky130_fd_sc_hd__clkbuf_1
XFILLER_0_2_352 VGND VGND VPWR VPWR sky130_fd_sc_hd__fill_2
Xoutput111 net111 VGND VGND VPWR VPWR rd1[8] sky130_fd_sc_hd__buf_1
Xoutput144 net144 VGND VGND VPWR VPWR rd2[9] sky130_fd_sc_hd__buf_1
X_5345_ registers\[28\]\[25\] registers\[29\]\[25\] registers\[30\]\[25\] registers\[31\]\[25\]
+ _2027_ _2028_ VGND VGND VPWR VPWR _2088_ sky130_fd_sc_hd__mux4_1
XFILLER_0_11_686 VGND VGND VPWR VPWR sky130_fd_sc_hd__decap_8
XANTENNA__8538__S _4211_ VGND VGND VPWR VPWR sky130_fd_sc_hd__diode_2
X_8064_ registers\[2\]\[30\] _3497_ _3936_ VGND VGND VPWR VPWR _3970_ sky130_fd_sc_hd__mux2_1
X_5276_ registers\[12\]\[21\] registers\[13\]\[21\] registers\[14\]\[21\] registers\[15\]\[21\]
+ _2020_ _2021_ VGND VGND VPWR VPWR _2023_ sky130_fd_sc_hd__mux4_1
XANTENNA__7670__A1 _3443_ VGND VGND VPWR VPWR sky130_fd_sc_hd__diode_2
X_4227_ a2[1] VGND VGND VPWR VPWR _1027_ sky130_fd_sc_hd__clkbuf_4
X_7015_ _3065_ registers\[15\]\[0\] _3398_ VGND VGND VPWR VPWR _3399_ sky130_fd_sc_hd__mux2_1
XANTENNA__7422__A1 _3468_ VGND VGND VPWR VPWR sky130_fd_sc_hd__diode_2
X_8966_ clknet_leaf_34_clk _0063_ VGND VGND VPWR VPWR registers\[18\]\[6\] sky130_fd_sc_hd__dfxtp_1
XFILLER_0_78_653 VGND VGND VPWR VPWR sky130_fd_sc_hd__fill_2
XFILLER_0_78_642 VGND VGND VPWR VPWR sky130_fd_sc_hd__fill_2
X_7917_ _3892_ VGND VGND VPWR VPWR _0369_ sky130_fd_sc_hd__clkbuf_1
XFILLER_0_77_163 VGND VGND VPWR VPWR sky130_fd_sc_hd__decap_3
XTAP_TAPCELL_ROW_54_957 VGND VPWR sky130_fd_sc_hd__tapvpwrvgnd_1
X_8897_ clknet_leaf_107_clk _1018_ VGND VGND VPWR VPWR registers\[16\]\[1\] sky130_fd_sc_hd__dfxtp_1
XFILLER_0_65_325 VGND VGND VPWR VPWR sky130_fd_sc_hd__decap_8
X_7848_ _3119_ registers\[26\]\[24\] _3851_ VGND VGND VPWR VPWR _3856_ sky130_fd_sc_hd__mux2_1
XFILLER_0_108_449 VGND VGND VPWR VPWR sky130_fd_sc_hd__decap_4
XFILLER_0_93_689 VPWR VGND VPWR VGND sky130_ef_sc_hd__decap_12
XFILLER_0_53_509 VGND VGND VPWR VPWR sky130_fd_sc_hd__decap_3
X_7779_ _3819_ VGND VGND VPWR VPWR _0304_ sky130_fd_sc_hd__clkbuf_1
XFILLER_0_34_701 VGND VGND VPWR VPWR sky130_fd_sc_hd__fill_2
X_9518_ clknet_leaf_39_clk _0615_ VGND VGND VPWR VPWR registers\[8\]\[14\] sky130_fd_sc_hd__dfxtp_1
XFILLER_0_80_328 VGND VGND VPWR VPWR sky130_fd_sc_hd__fill_1
XFILLER_0_104_611 VGND VGND VPWR VPWR sky130_fd_sc_hd__fill_2
X_9449_ clknet_leaf_7_clk _0546_ VGND VGND VPWR VPWR registers\[31\]\[9\] sky130_fd_sc_hd__dfxtp_1
XFILLER_0_116_493 VGND VGND VPWR VPWR sky130_fd_sc_hd__fill_1
XFILLER_0_104_677 VGND VGND VPWR VPWR sky130_fd_sc_hd__fill_2
XTAP_TAPCELL_ROW_111_1706 VGND VPWR sky130_fd_sc_hd__tapvpwrvgnd_1
XFILLER_0_103_176 VGND VGND VPWR VPWR sky130_fd_sc_hd__fill_2
XTAP_TAPCELL_ROW_6_340 VGND VPWR sky130_fd_sc_hd__tapvpwrvgnd_1
XFILLER_0_108_29 VGND VGND VPWR VPWR sky130_fd_sc_hd__fill_2
XANTENNA__5672__B1 _2321_ VGND VGND VPWR VPWR sky130_fd_sc_hd__diode_2
XTAP_TAPCELL_ROW_70_1171 VGND VPWR sky130_fd_sc_hd__tapvpwrvgnd_1
XFILLER_0_17_38 VGND VGND VPWR VPWR sky130_fd_sc_hd__fill_2
XANTENNA__4570__S1 _1128_ VGND VGND VPWR VPWR sky130_fd_sc_hd__diode_2
XTAP_TAPCELL_ROW_109_1679 VGND VPWR sky130_fd_sc_hd__tapvpwrvgnd_1
XFILLER_0_84_612 VGND VGND VPWR VPWR sky130_fd_sc_hd__fill_2
XFILLER_0_84_601 VGND VGND VPWR VPWR sky130_fd_sc_hd__fill_2
XFILLER_0_29_517 VGND VGND VPWR VPWR sky130_fd_sc_hd__fill_2
XFILLER_0_84_645 VGND VGND VPWR VPWR sky130_fd_sc_hd__fill_2
XANTENNA__5727__A1 _2429_ VGND VGND VPWR VPWR sky130_fd_sc_hd__diode_2
XFILLER_0_56_369 VGND VGND VPWR VPWR sky130_fd_sc_hd__decap_3
XFILLER_0_37_550 VGND VGND VPWR VPWR sky130_fd_sc_hd__fill_2
XANTENNA__7527__S _3684_ VGND VGND VPWR VPWR sky130_fd_sc_hd__diode_2
XFILLER_0_114_408 VGND VGND VPWR VPWR sky130_fd_sc_hd__fill_2
XANTENNA__5836__A net135 VGND VGND VPWR VPWR sky130_fd_sc_hd__diode_2
Xinput13 a3[4] VGND VGND VPWR VPWR net13 sky130_fd_sc_hd__clkbuf_2
Xinput46 wd3[8] VGND VGND VPWR VPWR net46 sky130_fd_sc_hd__clkbuf_2
Xinput24 wd3[17] VGND VGND VPWR VPWR net24 sky130_fd_sc_hd__buf_2
Xinput35 wd3[27] VGND VGND VPWR VPWR net35 sky130_fd_sc_hd__buf_2
XFILLER_0_52_531 VGND VGND VPWR VPWR sky130_fd_sc_hd__fill_1
XFILLER_0_3_105 VGND VGND VPWR VPWR sky130_fd_sc_hd__decap_6
XFILLER_0_52_575 VGND VGND VPWR VPWR sky130_fd_sc_hd__decap_3
XANTENNA__7262__S _3539_ VGND VGND VPWR VPWR sky130_fd_sc_hd__diode_2
XANTENNA__8358__S _4117_ VGND VGND VPWR VPWR sky130_fd_sc_hd__diode_2
XANTENNA__4886__S _1631_ VGND VGND VPWR VPWR sky130_fd_sc_hd__diode_2
X_5130_ registers\[16\]\[13\] registers\[17\]\[13\] registers\[18\]\[13\] registers\[19\]\[13\]
+ _1883_ _1774_ VGND VGND VPWR VPWR _1885_ sky130_fd_sc_hd__mux4_1
X_5061_ _1690_ VGND VGND VPWR VPWR _1820_ sky130_fd_sc_hd__clkbuf_8
XFILLER_0_42_9 VGND VGND VPWR VPWR sky130_fd_sc_hd__fill_1
XFILLER_0_74_33 VPWR VGND VPWR VGND sky130_ef_sc_hd__decap_12
XANTENNA__4561__S1 _1153_ VGND VGND VPWR VPWR sky130_fd_sc_hd__diode_2
XANTENNA_clkbuf_leaf_74_clk_A clknet_4_11_0_clk VGND VGND VPWR VPWR sky130_fd_sc_hd__diode_2
XANTENNA__8093__S _3984_ VGND VGND VPWR VPWR sky130_fd_sc_hd__diode_2
XANTENNA__6606__S _3175_ VGND VGND VPWR VPWR sky130_fd_sc_hd__diode_2
X_8820_ clknet_leaf_77_clk _0941_ VGND VGND VPWR VPWR registers\[13\]\[20\] sky130_fd_sc_hd__dfxtp_1
XANTENNA__7498__A _3647_ VGND VGND VPWR VPWR sky130_fd_sc_hd__diode_2
X_8751_ clknet_leaf_44_clk _0872_ VGND VGND VPWR VPWR registers\[11\]\[15\] sky130_fd_sc_hd__dfxtp_1
X_5963_ _2662_ _2665_ _2683_ VGND VGND VPWR VPWR _2684_ sky130_fd_sc_hd__a21o_1
X_4914_ _1629_ VGND VGND VPWR VPWR _1679_ sky130_fd_sc_hd__clkbuf_4
X_7702_ _3778_ VGND VGND VPWR VPWR _0268_ sky130_fd_sc_hd__clkbuf_1
XFILLER_0_59_152 VGND VGND VPWR VPWR sky130_fd_sc_hd__fill_2
XFILLER_0_47_314 VGND VGND VPWR VPWR sky130_fd_sc_hd__decap_4
X_8682_ clknet_leaf_40_clk _0803_ VGND VGND VPWR VPWR registers\[0\]\[10\] sky130_fd_sc_hd__dfxtp_1
X_5894_ _2490_ _2618_ _2465_ _2449_ VGND VGND VPWR VPWR _2619_ sky130_fd_sc_hd__o2bb2a_1
XFILLER_0_75_656 VGND VGND VPWR VPWR sky130_fd_sc_hd__fill_2
XTAP_TAPCELL_ROW_51_927 VGND VPWR sky130_fd_sc_hd__tapvpwrvgnd_1
XTAP_TAPCELL_ROW_51_916 VGND VPWR sky130_fd_sc_hd__tapvpwrvgnd_1
XANTENNA_clkbuf_leaf_89_clk_A clknet_4_8_0_clk VGND VGND VPWR VPWR sky130_fd_sc_hd__diode_2
XFILLER_0_118_725 VGND VGND VPWR VPWR sky130_fd_sc_hd__decap_8
XFILLER_0_114_83 VGND VGND VPWR VPWR sky130_fd_sc_hd__fill_1
X_7633_ _3741_ VGND VGND VPWR VPWR _0236_ sky130_fd_sc_hd__clkbuf_1
X_4845_ _1381_ _1613_ _1372_ VGND VGND VPWR VPWR _1614_ sky130_fd_sc_hd__o21a_1
XANTENNA__7437__S _3634_ VGND VGND VPWR VPWR sky130_fd_sc_hd__diode_2
XANTENNA__5746__A _1725_ VGND VGND VPWR VPWR sky130_fd_sc_hd__diode_2
X_7564_ _3108_ registers\[22\]\[19\] _3695_ VGND VGND VPWR VPWR _3705_ sky130_fd_sc_hd__mux2_1
X_4776_ _1438_ _1540_ _1548_ VGND VGND VPWR VPWR _1549_ sky130_fd_sc_hd__a21o_1
XFILLER_0_28_583 VGND VGND VPWR VPWR sky130_fd_sc_hd__fill_2
XTAP_TAPCELL_ROW_31_662 VGND VPWR sky130_fd_sc_hd__tapvpwrvgnd_1
XTAP_TAPCELL_ROW_99_1550 VGND VPWR sky130_fd_sc_hd__tapvpwrvgnd_1
XANTENNA_clkbuf_leaf_12_clk_A clknet_4_3_0_clk VGND VGND VPWR VPWR sky130_fd_sc_hd__diode_2
X_9303_ clknet_leaf_70_clk _0400_ VGND VGND VPWR VPWR registers\[28\]\[23\] sky130_fd_sc_hd__dfxtp_1
X_6515_ net36 VGND VGND VPWR VPWR _3127_ sky130_fd_sc_hd__clkbuf_2
X_7495_ _3668_ VGND VGND VPWR VPWR _0171_ sky130_fd_sc_hd__clkbuf_1
XFILLER_0_113_463 VGND VGND VPWR VPWR sky130_fd_sc_hd__fill_2
X_6446_ _3080_ VGND VGND VPWR VPWR _0734_ sky130_fd_sc_hd__clkbuf_1
X_9234_ clknet_leaf_71_clk _0331_ VGND VGND VPWR VPWR registers\[26\]\[18\] sky130_fd_sc_hd__dfxtp_1
X_9165_ clknet_leaf_57_clk _0262_ VGND VGND VPWR VPWR registers\[24\]\[13\] sky130_fd_sc_hd__dfxtp_1
X_6377_ registers\[3\]\[9\] _2980_ _3030_ VGND VGND VPWR VPWR _3040_ sky130_fd_sc_hd__mux2_1
XFILLER_0_2_160 VGND VGND VPWR VPWR sky130_fd_sc_hd__fill_2
XFILLER_0_100_135 VGND VGND VPWR VPWR sky130_fd_sc_hd__decap_3
XANTENNA_clkbuf_leaf_27_clk_A clknet_4_5_0_clk VGND VGND VPWR VPWR sky130_fd_sc_hd__diode_2
X_9096_ clknet_leaf_7_clk _0193_ VGND VGND VPWR VPWR registers\[22\]\[8\] sky130_fd_sc_hd__dfxtp_1
X_5328_ _1968_ VGND VGND VPWR VPWR _2072_ sky130_fd_sc_hd__buf_4
X_8116_ _3008_ registers\[30\]\[22\] _3995_ VGND VGND VPWR VPWR _3998_ sky130_fd_sc_hd__mux2_1
X_8047_ _3961_ VGND VGND VPWR VPWR _0430_ sky130_fd_sc_hd__clkbuf_1
Xclkbuf_4_5_0_clk clknet_0_clk VGND VGND VPWR VPWR clknet_4_5_0_clk sky130_fd_sc_hd__clkbuf_8
X_5259_ registers\[8\]\[20\] registers\[9\]\[20\] registers\[10\]\[20\] registers\[11\]\[20\]
+ _1758_ _1760_ VGND VGND VPWR VPWR _2007_ sky130_fd_sc_hd__mux4_1
XFILLER_0_97_214 VGND VGND VPWR VPWR sky130_fd_sc_hd__decap_4
XTAP_TAPCELL_ROW_39_762 VGND VPWR sky130_fd_sc_hd__tapvpwrvgnd_1
XANTENNA__6516__S _3111_ VGND VGND VPWR VPWR sky130_fd_sc_hd__diode_2
XANTENNA__5420__S _2019_ VGND VGND VPWR VPWR sky130_fd_sc_hd__diode_2
X_8949_ clknet_leaf_77_clk _0046_ VGND VGND VPWR VPWR registers\[17\]\[21\] sky130_fd_sc_hd__dfxtp_1
XFILLER_0_78_494 VGND VGND VPWR VPWR sky130_fd_sc_hd__fill_1
XFILLER_0_65_100 VGND VGND VPWR VPWR sky130_fd_sc_hd__fill_2
XFILLER_0_38_325 VGND VGND VPWR VPWR sky130_fd_sc_hd__fill_2
XFILLER_0_108_213 VGND VGND VPWR VPWR sky130_fd_sc_hd__decap_6
XFILLER_0_108_257 VGND VGND VPWR VPWR sky130_fd_sc_hd__fill_2
XANTENNA__6382__A1 _2985_ VGND VGND VPWR VPWR sky130_fd_sc_hd__diode_2
XANTENNA__7347__S _3586_ VGND VGND VPWR VPWR sky130_fd_sc_hd__diode_2
XANTENNA__4560__A _1148_ VGND VGND VPWR VPWR sky130_fd_sc_hd__diode_2
XFILLER_0_34_520 VGND VGND VPWR VPWR sky130_fd_sc_hd__fill_2
XFILLER_0_108_279 VGND VGND VPWR VPWR sky130_fd_sc_hd__fill_1
XFILLER_0_34_553 VGND VGND VPWR VPWR sky130_fd_sc_hd__fill_2
XTAP_TAPCELL_ROW_59_1022 VGND VPWR sky130_fd_sc_hd__tapvpwrvgnd_1
XFILLER_0_21_203 VGND VGND VPWR VPWR sky130_fd_sc_hd__fill_1
XFILLER_0_21_225 VGND VGND VPWR VPWR sky130_fd_sc_hd__fill_2
XTAP_TAPCELL_ROW_72_1200 VGND VPWR sky130_fd_sc_hd__tapvpwrvgnd_1
XANTENNA__6487__A net26 VGND VGND VPWR VPWR sky130_fd_sc_hd__diode_2
XANTENNA__5287__A1_N _1960_ VGND VGND VPWR VPWR sky130_fd_sc_hd__diode_2
XFILLER_0_100_680 VGND VGND VPWR VPWR sky130_fd_sc_hd__decap_3
XANTENNA__7810__S _3829_ VGND VGND VPWR VPWR sky130_fd_sc_hd__diode_2
XANTENNA__4448__A1 _1025_ VGND VGND VPWR VPWR sky130_fd_sc_hd__diode_2
XFILLER_0_89_704 VGND VGND VPWR VPWR sky130_fd_sc_hd__decap_6
XANTENNA__4543__S1 _1135_ VGND VGND VPWR VPWR sky130_fd_sc_hd__diode_2
XANTENNA_clkload5_A clknet_4_6_0_clk VGND VGND VPWR VPWR sky130_fd_sc_hd__diode_2
XANTENNA__6070__B1 _2420_ VGND VGND VPWR VPWR sky130_fd_sc_hd__diode_2
XTAP_TAPCELL_ROW_83_1340 VGND VPWR sky130_fd_sc_hd__tapvpwrvgnd_1
XFILLER_0_57_634 VGND VGND VPWR VPWR sky130_fd_sc_hd__decap_6
XTAP_TAPCELL_ROW_17_478 VGND VPWR sky130_fd_sc_hd__tapvpwrvgnd_1
XFILLER_0_8_219 VGND VGND VPWR VPWR sky130_fd_sc_hd__decap_4
XFILLER_0_29_369 VGND VGND VPWR VPWR sky130_fd_sc_hd__fill_2
XANTENNA__5566__A _1725_ VGND VGND VPWR VPWR sky130_fd_sc_hd__diode_2
XANTENNA__6373__A1 _2976_ VGND VGND VPWR VPWR sky130_fd_sc_hd__diode_2
X_4630_ registers\[0\]\[19\] registers\[1\]\[19\] registers\[2\]\[19\] registers\[3\]\[19\]
+ _1347_ _1348_ VGND VGND VPWR VPWR _1411_ sky130_fd_sc_hd__mux4_1
XFILLER_0_114_3 VGND VGND VPWR VPWR sky130_fd_sc_hd__decap_8
XFILLER_0_72_659 VGND VGND VPWR VPWR sky130_fd_sc_hd__decap_3
XFILLER_0_25_531 VGND VGND VPWR VPWR sky130_fd_sc_hd__fill_2
X_6300_ _2990_ VGND VGND VPWR VPWR _0678_ sky130_fd_sc_hd__clkbuf_1
XFILLER_0_71_169 VGND VGND VPWR VPWR sky130_fd_sc_hd__fill_2
XFILLER_0_69_22 VGND VGND VPWR VPWR sky130_fd_sc_hd__fill_2
X_4561_ _1340_ _1341_ _1342_ _1343_ _1344_ _1153_ VGND VGND VPWR VPWR _1345_ sky130_fd_sc_hd__mux4_1
XFILLER_0_4_447 VGND VGND VPWR VPWR sky130_fd_sc_hd__fill_1
XFILLER_0_13_715 VGND VGND VPWR VPWR sky130_fd_sc_hd__decap_8
X_7280_ _3554_ VGND VGND VPWR VPWR _0070_ sky130_fd_sc_hd__clkbuf_1
X_4492_ registers\[0\]\[12\] registers\[1\]\[12\] registers\[2\]\[12\] registers\[3\]\[12\]
+ _1201_ _1204_ VGND VGND VPWR VPWR _1280_ sky130_fd_sc_hd__mux4_1
XFILLER_0_69_44 VGND VGND VPWR VPWR sky130_fd_sc_hd__fill_2
XFILLER_0_69_33 VGND VGND VPWR VPWR sky130_fd_sc_hd__fill_2
XFILLER_0_12_214 VGND VGND VPWR VPWR sky130_fd_sc_hd__fill_2
XFILLER_0_12_236 VGND VGND VPWR VPWR sky130_fd_sc_hd__fill_2
X_6231_ _2670_ _2766_ VGND VGND VPWR VPWR _2937_ sky130_fd_sc_hd__nor2_1
XANTENNA__8088__S _3973_ VGND VGND VPWR VPWR sky130_fd_sc_hd__diode_2
XFILLER_0_12_269 VGND VGND VPWR VPWR sky130_fd_sc_hd__decap_3
XFILLER_0_110_466 VGND VGND VPWR VPWR sky130_fd_sc_hd__fill_2
XFILLER_0_100_85 VGND VGND VPWR VPWR sky130_fd_sc_hd__fill_1
XTAP_TAPCELL_ROW_94_1480 VGND VPWR sky130_fd_sc_hd__tapvpwrvgnd_1
X_6162_ _2515_ _2871_ VGND VGND VPWR VPWR _2872_ sky130_fd_sc_hd__nand2_1
XFILLER_0_40_589 VGND VGND VPWR VPWR sky130_fd_sc_hd__decap_4
X_5113_ _1867_ _1868_ _1695_ VGND VGND VPWR VPWR _1869_ sky130_fd_sc_hd__mux2_1
XFILLER_0_0_697 VGND VGND VPWR VPWR sky130_fd_sc_hd__decap_3
XFILLER_0_85_76 VGND VGND VPWR VPWR sky130_fd_sc_hd__fill_2
XFILLER_0_85_65 VGND VGND VPWR VPWR sky130_fd_sc_hd__fill_2
X_6093_ _2805_ _2802_ VGND VGND VPWR VPWR _2807_ sky130_fd_sc_hd__and2b_1
XANTENNA__7720__S _3779_ VGND VGND VPWR VPWR sky130_fd_sc_hd__diode_2
XFILLER_0_109_61 VGND VGND VPWR VPWR sky130_fd_sc_hd__fill_1
X_5044_ _1802_ _1803_ _1695_ VGND VGND VPWR VPWR _1804_ sky130_fd_sc_hd__mux2_1
XFILLER_0_79_225 VGND VGND VPWR VPWR sky130_fd_sc_hd__decap_6
XANTENNA__6336__S _3004_ VGND VGND VPWR VPWR sky130_fd_sc_hd__diode_2
XANTENNA__7659__C net13 VGND VGND VPWR VPWR sky130_fd_sc_hd__diode_2
X_8803_ clknet_leaf_20_clk _0924_ VGND VGND VPWR VPWR registers\[13\]\[3\] sky130_fd_sc_hd__dfxtp_1
XANTENNA__8050__A1 _3483_ VGND VGND VPWR VPWR sky130_fd_sc_hd__diode_2
XTAP_TAPCELL_ROW_36_721 VGND VPWR sky130_fd_sc_hd__tapvpwrvgnd_1
XFILLER_0_95_729 VGND VGND VPWR VPWR sky130_fd_sc_hd__fill_1
XANTENNA__4298__S0 _1060_ VGND VGND VPWR VPWR sky130_fd_sc_hd__diode_2
X_6995_ _3387_ VGND VGND VPWR VPWR _0976_ sky130_fd_sc_hd__clkbuf_1
XTAP_TAPCELL_ROW_36_732 VGND VPWR sky130_fd_sc_hd__tapvpwrvgnd_1
X_5946_ _2633_ _2667_ _2307_ VGND VGND VPWR VPWR _2668_ sky130_fd_sc_hd__mux2_1
XFILLER_0_48_645 VGND VGND VPWR VPWR sky130_fd_sc_hd__fill_2
X_8734_ clknet_leaf_11_clk _0855_ VGND VGND VPWR VPWR registers\[10\]\[30\] sky130_fd_sc_hd__dfxtp_1
X_5877_ _2414_ _2567_ _2276_ VGND VGND VPWR VPWR _2603_ sky130_fd_sc_hd__o21a_1
X_8665_ clknet_leaf_87_clk _0786_ VGND VGND VPWR VPWR registers\[7\]\[25\] sky130_fd_sc_hd__dfxtp_1
X_7616_ _3092_ registers\[23\]\[11\] _3731_ VGND VGND VPWR VPWR _3733_ sky130_fd_sc_hd__mux2_1
XFILLER_0_90_401 VGND VGND VPWR VPWR sky130_fd_sc_hd__decap_3
XFILLER_0_75_486 VGND VGND VPWR VPWR sky130_fd_sc_hd__fill_2
X_4828_ registers\[0\]\[30\] registers\[1\]\[30\] registers\[2\]\[30\] registers\[3\]\[30\]
+ _1382_ _1383_ VGND VGND VPWR VPWR _1598_ sky130_fd_sc_hd__mux4_1
XANTENNA__7167__S _3477_ VGND VGND VPWR VPWR sky130_fd_sc_hd__diode_2
XFILLER_0_16_531 VGND VGND VPWR VPWR sky130_fd_sc_hd__fill_1
X_8596_ clknet_leaf_91_clk _0717_ VGND VGND VPWR VPWR registers\[3\]\[20\] sky130_fd_sc_hd__dfxtp_1
XANTENNA__4470__S0 _1197_ VGND VGND VPWR VPWR sky130_fd_sc_hd__diode_2
X_7547_ _3696_ VGND VGND VPWR VPWR _0195_ sky130_fd_sc_hd__clkbuf_1
XFILLER_0_71_670 VGND VGND VPWR VPWR sky130_fd_sc_hd__fill_2
XFILLER_0_7_285 VGND VGND VPWR VPWR sky130_fd_sc_hd__fill_2
XFILLER_0_16_553 VGND VGND VPWR VPWR sky130_fd_sc_hd__decap_6
X_4759_ _1438_ _1524_ _1532_ VGND VGND VPWR VPWR _1533_ sky130_fd_sc_hd__a21o_1
X_7478_ _3089_ registers\[21\]\[10\] _3659_ VGND VGND VPWR VPWR _3660_ sky130_fd_sc_hd__mux2_1
X_9217_ clknet_leaf_109_clk _0314_ VGND VGND VPWR VPWR registers\[26\]\[1\] sky130_fd_sc_hd__dfxtp_1
XFILLER_0_3_480 VGND VGND VPWR VPWR sky130_fd_sc_hd__fill_1
X_6429_ _3068_ VGND VGND VPWR VPWR _3069_ sky130_fd_sc_hd__buf_6
XFILLER_0_101_444 VGND VGND VPWR VPWR sky130_fd_sc_hd__fill_2
XFILLER_0_101_477 VGND VGND VPWR VPWR sky130_fd_sc_hd__fill_2
X_9148_ clknet_leaf_104_clk _0245_ VGND VGND VPWR VPWR registers\[23\]\[28\] sky130_fd_sc_hd__dfxtp_1
XANTENNA__4773__S1 _1405_ VGND VGND VPWR VPWR sky130_fd_sc_hd__diode_2
XANTENNA__7630__S _3731_ VGND VGND VPWR VPWR sky130_fd_sc_hd__diode_2
X_9079_ clknet_leaf_75_clk _0176_ VGND VGND VPWR VPWR registers\[21\]\[23\] sky130_fd_sc_hd__dfxtp_1
XANTENNA__4525__S1 _1128_ VGND VGND VPWR VPWR sky130_fd_sc_hd__diode_2
XANTENNA__4555__A _1204_ VGND VGND VPWR VPWR sky130_fd_sc_hd__diode_2
XTAP_TAPCELL_ROW_106_1638 VGND VPWR sky130_fd_sc_hd__tapvpwrvgnd_1
XFILLER_0_98_589 VGND VGND VPWR VPWR sky130_fd_sc_hd__fill_2
XFILLER_0_39_645 VGND VGND VPWR VPWR sky130_fd_sc_hd__fill_2
XFILLER_0_78_291 VGND VGND VPWR VPWR sky130_fd_sc_hd__fill_1
XFILLER_0_66_453 VGND VGND VPWR VPWR sky130_fd_sc_hd__fill_1
XFILLER_0_66_442 VGND VGND VPWR VPWR sky130_fd_sc_hd__fill_2
XTAP_TAPCELL_ROW_14_437 VGND VPWR sky130_fd_sc_hd__tapvpwrvgnd_1
XFILLER_0_81_401 VGND VGND VPWR VPWR sky130_fd_sc_hd__fill_2
XANTENNA__5386__A _2109_ VGND VGND VPWR VPWR sky130_fd_sc_hd__diode_2
XFILLER_0_81_434 VGND VGND VPWR VPWR sky130_fd_sc_hd__decap_3
XFILLER_0_54_659 VGND VGND VPWR VPWR sky130_fd_sc_hd__fill_2
XFILLER_0_26_339 VGND VGND VPWR VPWR sky130_fd_sc_hd__decap_3
XFILLER_0_62_670 VGND VGND VPWR VPWR sky130_fd_sc_hd__fill_2
XFILLER_0_41_309 VGND VGND VPWR VPWR sky130_fd_sc_hd__decap_3
XFILLER_0_34_361 VGND VGND VPWR VPWR sky130_fd_sc_hd__decap_3
XANTENNA__4461__S0 _1110_ VGND VGND VPWR VPWR sky130_fd_sc_hd__diode_2
XFILLER_0_22_512 VGND VGND VPWR VPWR sky130_fd_sc_hd__fill_2
XTAP_TAPCELL_ROW_117_1778 VGND VPWR sky130_fd_sc_hd__tapvpwrvgnd_1
XFILLER_0_1_439 VGND VGND VPWR VPWR sky130_fd_sc_hd__decap_6
XANTENNA__4764__S1 _1391_ VGND VGND VPWR VPWR sky130_fd_sc_hd__diode_2
XFILLER_0_55_68 VGND VGND VPWR VPWR sky130_fd_sc_hd__fill_1
XFILLER_0_55_57 VGND VGND VPWR VPWR sky130_fd_sc_hd__fill_2
XANTENNA__4465__A _1254_ VGND VGND VPWR VPWR sky130_fd_sc_hd__diode_2
XFILLER_0_76_217 VGND VGND VPWR VPWR sky130_fd_sc_hd__fill_2
XANTENNA__8371__S _4128_ VGND VGND VPWR VPWR sky130_fd_sc_hd__diode_2
X_5800_ net110 _2528_ VGND VGND VPWR VPWR _2529_ sky130_fd_sc_hd__or2_1
XFILLER_0_71_23 VGND VGND VPWR VPWR sky130_fd_sc_hd__decap_8
X_6780_ _3249_ VGND VGND VPWR VPWR _3272_ sky130_fd_sc_hd__clkbuf_8
X_5731_ net138 _2461_ _2462_ _2362_ VGND VGND VPWR VPWR _2463_ sky130_fd_sc_hd__a211o_1
XFILLER_0_9_539 VGND VGND VPWR VPWR sky130_fd_sc_hd__decap_3
XFILLER_0_115_514 VGND VGND VPWR VPWR sky130_fd_sc_hd__fill_1
X_5662_ _1660_ _2396_ VGND VGND VPWR VPWR _2397_ sky130_fd_sc_hd__xnor2_2
X_8450_ _4174_ VGND VGND VPWR VPWR _0620_ sky130_fd_sc_hd__clkbuf_1
XANTENNA__7543__A0 _3087_ VGND VGND VPWR VPWR sky130_fd_sc_hd__diode_2
XFILLER_0_45_659 VGND VGND VPWR VPWR sky130_fd_sc_hd__fill_2
XFILLER_0_44_136 VGND VGND VPWR VPWR sky130_fd_sc_hd__fill_2
XFILLER_0_5_712 VPWR VGND VPWR VGND sky130_ef_sc_hd__decap_12
X_7401_ registers\[20\]\[6\] _3447_ _3612_ VGND VGND VPWR VPWR _3619_ sky130_fd_sc_hd__mux2_1
X_8381_ registers\[5\]\[19\] _3474_ _4128_ VGND VGND VPWR VPWR _4138_ sky130_fd_sc_hd__mux2_1
X_5593_ net15 VGND VGND VPWR VPWR _2328_ sky130_fd_sc_hd__inv_2
XFILLER_0_60_607 VGND VGND VPWR VPWR sky130_fd_sc_hd__decap_8
XFILLER_0_53_670 VGND VGND VPWR VPWR sky130_fd_sc_hd__fill_2
X_4613_ _1389_ _1394_ _1143_ VGND VGND VPWR VPWR _1395_ sky130_fd_sc_hd__a21oi_1
XTAP_TAPCELL_ROW_41_790 VGND VPWR sky130_fd_sc_hd__tapvpwrvgnd_1
XFILLER_0_32_309 VGND VGND VPWR VPWR sky130_fd_sc_hd__decap_4
X_7332_ registers\[1\]\[6\] _3447_ _3575_ VGND VGND VPWR VPWR _3582_ sky130_fd_sc_hd__mux2_1
XANTENNA__4452__S0 _1110_ VGND VGND VPWR VPWR sky130_fd_sc_hd__diode_2
X_4544_ registers\[4\]\[15\] registers\[5\]\[15\] registers\[6\]\[15\] registers\[7\]\[15\]
+ _1136_ _1137_ VGND VGND VPWR VPWR _1329_ sky130_fd_sc_hd__mux4_1
XFILLER_0_53_692 VGND VGND VPWR VPWR sky130_fd_sc_hd__fill_1
XFILLER_0_52_180 VGND VGND VPWR VPWR sky130_fd_sc_hd__decap_3
X_7263_ _3545_ VGND VGND VPWR VPWR _0062_ sky130_fd_sc_hd__clkbuf_1
XFILLER_0_40_342 VGND VGND VPWR VPWR sky130_fd_sc_hd__fill_2
XFILLER_0_13_556 VGND VGND VPWR VPWR sky130_fd_sc_hd__fill_1
X_4475_ registers\[12\]\[11\] registers\[13\]\[11\] registers\[14\]\[11\] registers\[15\]\[11\]
+ _1125_ _1127_ VGND VGND VPWR VPWR _1264_ sky130_fd_sc_hd__mux4_1
X_9002_ clknet_leaf_40_clk _0099_ VGND VGND VPWR VPWR registers\[1\]\[10\] sky130_fd_sc_hd__dfxtp_1
X_6214_ _2919_ _2920_ VGND VGND VPWR VPWR _2921_ sky130_fd_sc_hd__nand2_1
XFILLER_0_110_274 VGND VGND VPWR VPWR sky130_fd_sc_hd__fill_2
X_7194_ registers\[17\]\[5\] _3445_ _3503_ VGND VGND VPWR VPWR _3509_ sky130_fd_sc_hd__mux2_1
XANTENNA__4755__S1 _1324_ VGND VGND VPWR VPWR sky130_fd_sc_hd__diode_2
X_6145_ _2084_ _2827_ _2829_ _2837_ VGND VGND VPWR VPWR _2856_ sky130_fd_sc_hd__o22a_1
XFILLER_0_29_80 VGND VGND VPWR VPWR sky130_fd_sc_hd__fill_2
X_6076_ _2362_ _2492_ _2788_ _2498_ _2790_ VGND VGND VPWR VPWR _2791_ sky130_fd_sc_hd__o221a_1
X_5027_ registers\[8\]\[7\] registers\[9\]\[7\] registers\[10\]\[7\] registers\[11\]\[7\]
+ _1678_ _1679_ VGND VGND VPWR VPWR _1788_ sky130_fd_sc_hd__mux4_1
XANTENNA__4507__S1 _1161_ VGND VGND VPWR VPWR sky130_fd_sc_hd__diode_2
XANTENNA__5180__S1 _1765_ VGND VGND VPWR VPWR sky130_fd_sc_hd__diode_2
XANTENNA__8023__A1 _3455_ VGND VGND VPWR VPWR sky130_fd_sc_hd__diode_2
XTAP_TAPCELL_ROW_49_890 VGND VPWR sky130_fd_sc_hd__tapvpwrvgnd_1
X_8717_ clknet_leaf_50_clk _0838_ VGND VGND VPWR VPWR registers\[10\]\[13\] sky130_fd_sc_hd__dfxtp_1
X_6978_ _3378_ VGND VGND VPWR VPWR _0968_ sky130_fd_sc_hd__clkbuf_1
XFILLER_0_36_604 VGND VGND VPWR VPWR sky130_fd_sc_hd__decap_3
X_5929_ _2616_ _2651_ _2293_ VGND VGND VPWR VPWR _2652_ sky130_fd_sc_hd__mux2_1
XFILLER_0_0_81 VGND VGND VPWR VPWR sky130_fd_sc_hd__decap_3
XTAP_TAPCELL_ROW_101_1568 VGND VPWR sky130_fd_sc_hd__tapvpwrvgnd_1
XFILLER_0_90_242 VGND VGND VPWR VPWR sky130_fd_sc_hd__fill_2
X_8648_ clknet_leaf_17_clk _0769_ VGND VGND VPWR VPWR registers\[7\]\[8\] sky130_fd_sc_hd__dfxtp_1
XFILLER_0_63_445 VGND VGND VPWR VPWR sky130_fd_sc_hd__decap_3
XTAP_TAPCELL_ROW_11_407 VGND VPWR sky130_fd_sc_hd__tapvpwrvgnd_1
XFILLER_0_36_659 VGND VGND VPWR VPWR sky130_fd_sc_hd__fill_1
XANTENNA__4348__B1 _1143_ VGND VGND VPWR VPWR sky130_fd_sc_hd__diode_2
XFILLER_0_90_253 VGND VGND VPWR VPWR sky130_fd_sc_hd__decap_3
X_8579_ clknet_leaf_21_clk _0700_ VGND VGND VPWR VPWR registers\[3\]\[3\] sky130_fd_sc_hd__dfxtp_1
XFILLER_0_8_583 VGND VGND VPWR VPWR sky130_fd_sc_hd__fill_2
XFILLER_0_23_309 VGND VGND VPWR VPWR sky130_fd_sc_hd__fill_2
XFILLER_0_31_397 VGND VGND VPWR VPWR sky130_fd_sc_hd__decap_4
XANTENNA__8456__S _4175_ VGND VGND VPWR VPWR sky130_fd_sc_hd__diode_2
XANTENNA__8262__A1 _3491_ VGND VGND VPWR VPWR sky130_fd_sc_hd__diode_2
XANTENNA_input22_A wd3[15] VGND VGND VPWR VPWR sky130_fd_sc_hd__diode_2
XANTENNA__5076__A1 _1741_ VGND VGND VPWR VPWR sky130_fd_sc_hd__diode_2
XFILLER_0_116_29 VPWR VGND VPWR VGND sky130_ef_sc_hd__decap_12
XTAP_TAPCELL_ROW_19_507 VGND VPWR sky130_fd_sc_hd__tapvpwrvgnd_1
XANTENNA__8014__A1 _3447_ VGND VGND VPWR VPWR sky130_fd_sc_hd__diode_2
XFILLER_0_86_504 VGND VGND VPWR VPWR sky130_fd_sc_hd__fill_2
XTAP_TAPCELL_ROW_67_1132 VGND VPWR sky130_fd_sc_hd__tapvpwrvgnd_1
XFILLER_0_59_729 VGND VGND VPWR VPWR sky130_fd_sc_hd__fill_1
XANTENNA__6704__S _3225_ VGND VGND VPWR VPWR sky130_fd_sc_hd__diode_2
XANTENNA__4587__B1 _1142_ VGND VGND VPWR VPWR sky130_fd_sc_hd__diode_2
XANTENNA_output109_A net109 VGND VGND VPWR VPWR sky130_fd_sc_hd__diode_2
XFILLER_0_109_341 VGND VGND VPWR VPWR sky130_fd_sc_hd__fill_1
XFILLER_0_82_721 VGND VGND VPWR VPWR sky130_fd_sc_hd__decap_6
XFILLER_0_66_250 VGND VGND VPWR VPWR sky130_fd_sc_hd__fill_2
XANTENNA__4682__S0 _1418_ VGND VGND VPWR VPWR sky130_fd_sc_hd__diode_2
XTAP_TAPCELL_ROW_119_1807 VGND VPWR sky130_fd_sc_hd__tapvpwrvgnd_1
XFILLER_0_66_294 VGND VGND VPWR VPWR sky130_fd_sc_hd__fill_1
XANTENNA__7525__A0 _3065_ VGND VGND VPWR VPWR sky130_fd_sc_hd__diode_2
XTAP_TAPCELL_ROW_119_1818 VGND VPWR sky130_fd_sc_hd__tapvpwrvgnd_1
XFILLER_0_109_396 VGND VGND VPWR VPWR sky130_fd_sc_hd__decap_4
XFILLER_0_81_253 VGND VGND VPWR VPWR sky130_fd_sc_hd__decap_8
XFILLER_0_54_467 VGND VGND VPWR VPWR sky130_fd_sc_hd__fill_2
XANTENNA__5844__A _2276_ VGND VGND VPWR VPWR sky130_fd_sc_hd__diode_2
XANTENNA__7535__S _3684_ VGND VGND VPWR VPWR sky130_fd_sc_hd__diode_2
XANTENNA__4434__S0 _1053_ VGND VGND VPWR VPWR sky130_fd_sc_hd__diode_2
XANTENNA__5563__B _2213_ VGND VGND VPWR VPWR sky130_fd_sc_hd__diode_2
XTAP_TAPCELL_ROW_78_1272 VGND VPWR sky130_fd_sc_hd__tapvpwrvgnd_1
XFILLER_0_105_591 VGND VGND VPWR VPWR sky130_fd_sc_hd__fill_1
XFILLER_0_50_673 VGND VGND VPWR VPWR sky130_fd_sc_hd__fill_1
X_4260_ _1055_ _1056_ _1057_ _1058_ net6 _1024_ VGND VGND VPWR VPWR _1059_ sky130_fd_sc_hd__mux4_2
XFILLER_0_5_48 VGND VGND VPWR VPWR sky130_fd_sc_hd__decap_3
XPHY_EDGE_ROW_105_Left_225 VGND VGND VPWR VPWR sky130_fd_sc_hd__decap_3
XFILLER_0_66_78 VGND VGND VPWR VPWR sky130_fd_sc_hd__fill_2
XANTENNA__7270__S _3539_ VGND VGND VPWR VPWR sky130_fd_sc_hd__diode_2
XANTENNA__5162__S1 _1759_ VGND VGND VPWR VPWR sky130_fd_sc_hd__diode_2
X_7950_ _2978_ registers\[28\]\[8\] _3901_ VGND VGND VPWR VPWR _3910_ sky130_fd_sc_hd__mux2_1
X_6901_ _3337_ VGND VGND VPWR VPWR _0932_ sky130_fd_sc_hd__clkbuf_1
XFILLER_0_89_353 VPWR VGND VPWR VGND sky130_ef_sc_hd__decap_12
X_7881_ _3873_ VGND VGND VPWR VPWR _0352_ sky130_fd_sc_hd__clkbuf_1
XFILLER_0_49_206 VGND VGND VPWR VPWR sky130_fd_sc_hd__decap_3
X_6832_ registers\[12\]\[11\] _2985_ _3299_ VGND VGND VPWR VPWR _3301_ sky130_fd_sc_hd__mux2_1
XFILLER_0_89_397 VGND VGND VPWR VPWR sky130_fd_sc_hd__decap_3
XANTENNA__6614__S _3175_ VGND VGND VPWR VPWR sky130_fd_sc_hd__diode_2
XTAP_TAPCELL_ROW_46_860 VGND VPWR sky130_fd_sc_hd__tapvpwrvgnd_1
XFILLER_0_15_60 VGND VGND VPWR VPWR sky130_fd_sc_hd__decap_4
XPHY_EDGE_ROW_114_Left_234 VGND VGND VPWR VPWR sky130_fd_sc_hd__decap_3
X_6763_ _3263_ VGND VGND VPWR VPWR _0868_ sky130_fd_sc_hd__clkbuf_1
XFILLER_0_92_518 VGND VGND VPWR VPWR sky130_fd_sc_hd__fill_2
X_9551_ clknet_leaf_47_clk _0648_ VGND VGND VPWR VPWR registers\[4\]\[15\] sky130_fd_sc_hd__dfxtp_1
XFILLER_0_57_261 VGND VGND VPWR VPWR sky130_fd_sc_hd__fill_1
X_6694_ registers\[10\]\[11\] _2985_ _3225_ VGND VGND VPWR VPWR _3227_ sky130_fd_sc_hd__mux2_1
X_8502_ _4202_ VGND VGND VPWR VPWR _0644_ sky130_fd_sc_hd__clkbuf_1
X_9482_ clknet_leaf_40_clk _0579_ VGND VGND VPWR VPWR registers\[5\]\[10\] sky130_fd_sc_hd__dfxtp_1
X_5714_ _2356_ _2358_ VGND VGND VPWR VPWR _2447_ sky130_fd_sc_hd__and2_1
XFILLER_0_115_333 VGND VGND VPWR VPWR sky130_fd_sc_hd__decap_3
XFILLER_0_115_311 VGND VGND VPWR VPWR sky130_fd_sc_hd__fill_1
X_8433_ registers\[8\]\[11\] net18 _4164_ VGND VGND VPWR VPWR _4166_ sky130_fd_sc_hd__mux2_1
X_5645_ _1049_ _2259_ VGND VGND VPWR VPWR _2380_ sky130_fd_sc_hd__or2_1
XFILLER_0_45_489 VPWR VGND VPWR VGND sky130_ef_sc_hd__decap_12
XFILLER_0_45_478 VGND VGND VPWR VPWR sky130_fd_sc_hd__fill_1
XFILLER_0_17_169 VGND VGND VPWR VPWR sky130_fd_sc_hd__fill_1
XFILLER_0_86_3 VGND VGND VPWR VPWR sky130_fd_sc_hd__fill_2
XFILLER_0_60_415 VGND VGND VPWR VPWR sky130_fd_sc_hd__fill_2
XANTENNA__7445__S _3634_ VGND VGND VPWR VPWR sky130_fd_sc_hd__diode_2
XFILLER_0_26_670 VGND VGND VPWR VPWR sky130_fd_sc_hd__fill_2
XFILLER_0_103_539 VGND VGND VPWR VPWR sky130_fd_sc_hd__fill_2
X_5576_ _2220_ _2311_ VGND VGND VPWR VPWR _2312_ sky130_fd_sc_hd__nor2_1
X_8364_ _4129_ VGND VGND VPWR VPWR _0579_ sky130_fd_sc_hd__clkbuf_1
X_8295_ _2982_ registers\[31\]\[10\] _4092_ VGND VGND VPWR VPWR _4093_ sky130_fd_sc_hd__mux2_1
X_4527_ _1311_ _1312_ _1140_ VGND VGND VPWR VPWR _1313_ sky130_fd_sc_hd__mux2_1
XFILLER_0_41_695 VGND VGND VPWR VPWR sky130_fd_sc_hd__fill_1
XFILLER_0_41_673 VGND VGND VPWR VPWR sky130_fd_sc_hd__fill_2
X_7315_ _3572_ VGND VGND VPWR VPWR _0087_ sky130_fd_sc_hd__clkbuf_1
XFILLER_0_111_561 VGND VGND VPWR VPWR sky130_fd_sc_hd__fill_2
X_4458_ _1131_ _1247_ VGND VGND VPWR VPWR _1248_ sky130_fd_sc_hd__or2_1
X_7246_ registers\[17\]\[30\] _3497_ _3502_ VGND VGND VPWR VPWR _3536_ sky130_fd_sc_hd__mux2_1
XFILLER_0_13_397 VGND VGND VPWR VPWR sky130_fd_sc_hd__fill_1
X_7177_ _3498_ VGND VGND VPWR VPWR _0023_ sky130_fd_sc_hd__clkbuf_1
XANTENNA__8276__S _4081_ VGND VGND VPWR VPWR sky130_fd_sc_hd__diode_2
X_4389_ _1135_ _1182_ _1142_ VGND VGND VPWR VPWR _1183_ sky130_fd_sc_hd__a21oi_1
X_6128_ _2838_ _2839_ VGND VGND VPWR VPWR _2840_ sky130_fd_sc_hd__nor2_1
XANTENNA__5058__B2 _1754_ VGND VGND VPWR VPWR sky130_fd_sc_hd__diode_2
X_6059_ _1995_ _2751_ VGND VGND VPWR VPWR _2775_ sky130_fd_sc_hd__or2_1
XFILLER_0_68_504 VGND VGND VPWR VPWR sky130_fd_sc_hd__fill_1
XFILLER_0_68_537 VGND VGND VPWR VPWR sky130_fd_sc_hd__fill_1
XFILLER_0_76_581 VGND VGND VPWR VPWR sky130_fd_sc_hd__fill_2
XANTENNA__4664__S0 _1427_ VGND VGND VPWR VPWR sky130_fd_sc_hd__diode_2
XFILLER_0_91_540 VGND VGND VPWR VPWR sky130_fd_sc_hd__fill_2
XTAP_TAPCELL_ROW_62_1062 VGND VPWR sky130_fd_sc_hd__tapvpwrvgnd_1
XTAP_TAPCELL_ROW_24_565 VGND VPWR sky130_fd_sc_hd__tapvpwrvgnd_1
XTAP_TAPCELL_ROW_24_576 VGND VPWR sky130_fd_sc_hd__tapvpwrvgnd_1
XFILLER_0_106_322 VGND VGND VPWR VPWR sky130_fd_sc_hd__decap_6
XFILLER_0_51_404 VGND VGND VPWR VPWR sky130_fd_sc_hd__fill_1
XFILLER_0_11_18 VGND VGND VPWR VPWR sky130_fd_sc_hd__fill_1
XFILLER_0_36_456 VGND VGND VPWR VPWR sky130_fd_sc_hd__fill_2
XFILLER_0_36_467 VGND VGND VPWR VPWR sky130_fd_sc_hd__fill_2
XANTENNA__7355__S _3586_ VGND VGND VPWR VPWR sky130_fd_sc_hd__diode_2
XANTENNA__5664__A _2276_ VGND VGND VPWR VPWR sky130_fd_sc_hd__diode_2
XANTENNA__4967__S1 _1655_ VGND VGND VPWR VPWR sky130_fd_sc_hd__diode_2
XFILLER_0_51_459 VGND VGND VPWR VPWR sky130_fd_sc_hd__fill_2
XTAP_TAPCELL_ROW_114_1737 VGND VPWR sky130_fd_sc_hd__tapvpwrvgnd_1
XFILLER_0_31_161 VGND VGND VPWR VPWR sky130_fd_sc_hd__fill_1
XANTENNA__8186__S _4031_ VGND VGND VPWR VPWR sky130_fd_sc_hd__diode_2
XANTENNA__5392__S1 _2127_ VGND VGND VPWR VPWR sky130_fd_sc_hd__diode_2
XANTENNA__7090__S _3435_ VGND VGND VPWR VPWR sky130_fd_sc_hd__diode_2
XANTENNA__6797__A1 _3020_ VGND VGND VPWR VPWR sky130_fd_sc_hd__diode_2
XANTENNA__7994__A0 _3022_ VGND VGND VPWR VPWR sky130_fd_sc_hd__diode_2
XFILLER_0_99_673 VGND VGND VPWR VPWR sky130_fd_sc_hd__decap_4
XFILLER_0_99_651 VGND VGND VPWR VPWR sky130_fd_sc_hd__fill_2
XANTENNA__5839__A _1108_ VGND VGND VPWR VPWR sky130_fd_sc_hd__diode_2
XFILLER_0_86_301 VGND VGND VPWR VPWR sky130_fd_sc_hd__decap_3
XANTENNA__7746__A0 _3085_ VGND VGND VPWR VPWR sky130_fd_sc_hd__diode_2
XANTENNA__4743__A _1517_ VGND VGND VPWR VPWR sky130_fd_sc_hd__diode_2
XFILLER_0_74_529 VGND VGND VPWR VPWR sky130_fd_sc_hd__decap_3
XFILLER_0_27_412 VGND VGND VPWR VPWR sky130_fd_sc_hd__fill_1
XANTENNA__4655__S0 _1433_ VGND VGND VPWR VPWR sky130_fd_sc_hd__diode_2
XFILLER_0_116_119 VGND VGND VPWR VPWR sky130_fd_sc_hd__fill_1
XFILLER_0_109_160 VGND VGND VPWR VPWR sky130_fd_sc_hd__fill_2
XFILLER_0_42_404 VGND VGND VPWR VPWR sky130_fd_sc_hd__fill_2
XANTENNA__4407__S0 _1198_ VGND VGND VPWR VPWR sky130_fd_sc_hd__diode_2
XFILLER_0_82_595 VGND VGND VPWR VPWR sky130_fd_sc_hd__fill_1
XANTENNA__5574__A _1676_ VGND VGND VPWR VPWR sky130_fd_sc_hd__diode_2
XFILLER_0_54_286 VGND VGND VPWR VPWR sky130_fd_sc_hd__decap_4
X_5430_ _2168_ VGND VGND VPWR VPWR net102 sky130_fd_sc_hd__inv_2
XFILLER_0_15_629 VGND VGND VPWR VPWR sky130_fd_sc_hd__fill_2
XANTENNA__4958__S1 _1679_ VGND VGND VPWR VPWR sky130_fd_sc_hd__diode_2
XFILLER_0_42_459 VGND VGND VPWR VPWR sky130_fd_sc_hd__fill_2
XFILLER_0_14_139 VGND VGND VPWR VPWR sky130_fd_sc_hd__fill_1
XFILLER_0_23_673 VGND VGND VPWR VPWR sky130_fd_sc_hd__fill_1
X_5361_ registers\[16\]\[26\] registers\[17\]\[26\] registers\[18\]\[26\] registers\[19\]\[26\]
+ _1996_ _1997_ VGND VGND VPWR VPWR _2103_ sky130_fd_sc_hd__mux4_1
X_4312_ _1108_ VGND VGND VPWR VPWR net138 sky130_fd_sc_hd__clkbuf_4
X_7100_ _3446_ VGND VGND VPWR VPWR _1022_ sky130_fd_sc_hd__clkbuf_1
X_8080_ _2972_ registers\[30\]\[5\] _3973_ VGND VGND VPWR VPWR _3979_ sky130_fd_sc_hd__mux2_1
XANTENNA__8474__A1 net40 VGND VGND VPWR VPWR sky130_fd_sc_hd__diode_2
X_5292_ registers\[20\]\[22\] registers\[21\]\[22\] registers\[22\]\[22\] registers\[23\]\[22\]
+ _1810_ _1811_ VGND VGND VPWR VPWR _2038_ sky130_fd_sc_hd__mux4_1
X_7031_ _3085_ registers\[15\]\[8\] _3398_ VGND VGND VPWR VPWR _3407_ sky130_fd_sc_hd__mux2_1
X_4243_ registers\[8\]\[0\] registers\[9\]\[0\] registers\[10\]\[0\] registers\[11\]\[0\]
+ _1026_ _1027_ VGND VGND VPWR VPWR _1043_ sky130_fd_sc_hd__mux4_1
XANTENNA__5383__S1 _2120_ VGND VGND VPWR VPWR sky130_fd_sc_hd__diode_2
XFILLER_0_93_32 VGND VGND VPWR VPWR sky130_fd_sc_hd__fill_1
XANTENNA__4248__C1 net8 VGND VGND VPWR VPWR sky130_fd_sc_hd__diode_2
X_8982_ clknet_leaf_95_clk _0079_ VGND VGND VPWR VPWR registers\[18\]\[22\] sky130_fd_sc_hd__dfxtp_1
X_7933_ _3900_ VGND VGND VPWR VPWR _3901_ sky130_fd_sc_hd__clkbuf_8
XANTENNA__4653__A _1320_ VGND VGND VPWR VPWR sky130_fd_sc_hd__diode_2
X_7864_ _3396_ _3755_ VGND VGND VPWR VPWR _3864_ sky130_fd_sc_hd__nand2_4
X_6815_ registers\[12\]\[3\] _2968_ _3288_ VGND VGND VPWR VPWR _3292_ sky130_fd_sc_hd__mux2_1
X_7795_ _3827_ VGND VGND VPWR VPWR _0312_ sky130_fd_sc_hd__clkbuf_1
XFILLER_0_107_108 VGND VGND VPWR VPWR sky130_fd_sc_hd__fill_2
X_6746_ _3254_ VGND VGND VPWR VPWR _0860_ sky130_fd_sc_hd__clkbuf_1
X_9534_ clknet_leaf_11_clk _0631_ VGND VGND VPWR VPWR registers\[8\]\[30\] sky130_fd_sc_hd__dfxtp_1
XTAP_TAPCELL_ROW_21_535 VGND VPWR sky130_fd_sc_hd__tapvpwrvgnd_1
XFILLER_0_115_141 VGND VGND VPWR VPWR sky130_fd_sc_hd__fill_2
XFILLER_0_60_212 VGND VGND VPWR VPWR sky130_fd_sc_hd__decap_4
X_6677_ registers\[10\]\[3\] _2968_ _3214_ VGND VGND VPWR VPWR _3218_ sky130_fd_sc_hd__mux2_1
XFILLER_0_45_275 VGND VGND VPWR VPWR sky130_fd_sc_hd__decap_3
X_9465_ clknet_leaf_81_clk _0562_ VGND VGND VPWR VPWR registers\[31\]\[25\] sky130_fd_sc_hd__dfxtp_1
X_5628_ _2298_ _2354_ _2361_ _2362_ VGND VGND VPWR VPWR _2363_ sky130_fd_sc_hd__a211o_1
X_8416_ registers\[8\]\[3\] net41 _4153_ VGND VGND VPWR VPWR _4157_ sky130_fd_sc_hd__mux2_1
X_9396_ clknet_leaf_84_clk _0493_ VGND VGND VPWR VPWR registers\[9\]\[20\] sky130_fd_sc_hd__dfxtp_1
X_5559_ _1089_ VGND VGND VPWR VPWR _2295_ sky130_fd_sc_hd__clkbuf_4
XANTENNA__4723__B1 _1109_ VGND VGND VPWR VPWR sky130_fd_sc_hd__diode_2
X_8347_ _4120_ VGND VGND VPWR VPWR _0571_ sky130_fd_sc_hd__clkbuf_1
XANTENNA__7903__S _3876_ VGND VGND VPWR VPWR sky130_fd_sc_hd__diode_2
XFILLER_0_13_194 VGND VGND VPWR VPWR sky130_fd_sc_hd__fill_2
X_8278_ _2966_ registers\[31\]\[2\] _4081_ VGND VGND VPWR VPWR _4084_ sky130_fd_sc_hd__mux2_1
XANTENNA__7204__A _3502_ VGND VGND VPWR VPWR sky130_fd_sc_hd__diode_2
XANTENNA__5423__S _2076_ VGND VGND VPWR VPWR sky130_fd_sc_hd__diode_2
XANTENNA__6519__S _3111_ VGND VGND VPWR VPWR sky130_fd_sc_hd__diode_2
X_7229_ _3527_ VGND VGND VPWR VPWR _0046_ sky130_fd_sc_hd__clkbuf_1
XANTENNA__7976__A0 _3003_ VGND VGND VPWR VPWR sky130_fd_sc_hd__diode_2
XTAP_TAPCELL_ROW_29_635 VGND VPWR sky130_fd_sc_hd__tapvpwrvgnd_1
XANTENNA__5659__A net15 VGND VGND VPWR VPWR sky130_fd_sc_hd__diode_2
XFILLER_0_68_301 VGND VGND VPWR VPWR sky130_fd_sc_hd__decap_4
XANTENNA__4885__S0 _1628_ VGND VGND VPWR VPWR sky130_fd_sc_hd__diode_2
XFILLER_0_95_142 VGND VGND VPWR VPWR sky130_fd_sc_hd__fill_2
XANTENNA__4563__A _1126_ VGND VGND VPWR VPWR sky130_fd_sc_hd__diode_2
XTAP_TAPCELL_ROW_57_999 VGND VPWR sky130_fd_sc_hd__tapvpwrvgnd_1
XTAP_TAPCELL_ROW_1_271 VGND VPWR sky130_fd_sc_hd__tapvpwrvgnd_1
XFILLER_0_56_529 VGND VGND VPWR VPWR sky130_fd_sc_hd__decap_3
XFILLER_0_83_337 VGND VGND VPWR VPWR sky130_fd_sc_hd__decap_3
XANTENNA__4637__S0 _1415_ VGND VGND VPWR VPWR sky130_fd_sc_hd__diode_2
XFILLER_0_119_480 VGND VGND VPWR VPWR sky130_fd_sc_hd__fill_2
XFILLER_0_52_713 VPWR VGND VPWR VGND sky130_ef_sc_hd__decap_12
XFILLER_0_3_309 VGND VGND VPWR VPWR sky130_fd_sc_hd__fill_1
XFILLER_0_36_264 VGND VGND VPWR VPWR sky130_fd_sc_hd__fill_2
XANTENNA__4502__S _1117_ VGND VGND VPWR VPWR sky130_fd_sc_hd__diode_2
XFILLER_0_106_163 VGND VGND VPWR VPWR sky130_fd_sc_hd__fill_2
XTAP_TAPCELL_ROW_75_1231 VGND VPWR sky130_fd_sc_hd__tapvpwrvgnd_1
XANTENNA__8456__A1 net30 VGND VGND VPWR VPWR sky130_fd_sc_hd__diode_2
XFILLER_0_32_481 VGND VGND VPWR VPWR sky130_fd_sc_hd__fill_2
XANTENNA__5841__B _2317_ VGND VGND VPWR VPWR sky130_fd_sc_hd__diode_2
XANTENNA__7114__A _3434_ VGND VGND VPWR VPWR sky130_fd_sc_hd__diode_2
XFILLER_0_47_25 VGND VGND VPWR VPWR sky130_fd_sc_hd__fill_1
XTAP_TAPCELL_ROW_9_371 VGND VPWR sky130_fd_sc_hd__tapvpwrvgnd_1
XTAP_TAPCELL_ROW_9_382 VGND VPWR sky130_fd_sc_hd__tapvpwrvgnd_1
XANTENNA__5333__S _2076_ VGND VGND VPWR VPWR sky130_fd_sc_hd__diode_2
XANTENNA__4738__A _1344_ VGND VGND VPWR VPWR sky130_fd_sc_hd__diode_2
XANTENNA__8208__A1 _3437_ VGND VGND VPWR VPWR sky130_fd_sc_hd__diode_2
XFILLER_0_2_27 VGND VGND VPWR VPWR sky130_fd_sc_hd__fill_1
XFILLER_0_2_49 VPWR VGND VPWR VGND sky130_ef_sc_hd__decap_12
XFILLER_0_99_481 VGND VGND VPWR VPWR sky130_fd_sc_hd__fill_2
XFILLER_0_63_57 VGND VGND VPWR VPWR sky130_fd_sc_hd__decap_3
XFILLER_0_63_46 VGND VGND VPWR VPWR sky130_fd_sc_hd__fill_1
X_4930_ _1627_ VGND VGND VPWR VPWR _1695_ sky130_fd_sc_hd__buf_6
XFILLER_0_87_654 VGND VGND VPWR VPWR sky130_fd_sc_hd__fill_2
XTAP_TAPCELL_ROW_86_1382 VGND VPWR sky130_fd_sc_hd__tapvpwrvgnd_1
XFILLER_0_86_120 VGND VGND VPWR VPWR sky130_fd_sc_hd__fill_2
XTAP_TAPCELL_ROW_86_1371 VGND VPWR sky130_fd_sc_hd__tapvpwrvgnd_1
XFILLER_0_86_175 VGND VGND VPWR VPWR sky130_fd_sc_hd__fill_2
XFILLER_0_86_164 VGND VGND VPWR VPWR sky130_fd_sc_hd__fill_2
XFILLER_0_59_389 VGND VGND VPWR VPWR sky130_fd_sc_hd__decap_3
XFILLER_0_47_518 VGND VGND VPWR VPWR sky130_fd_sc_hd__fill_2
X_4861_ _1618_ VGND VGND VPWR VPWR _1629_ sky130_fd_sc_hd__clkbuf_4
XFILLER_0_19_209 VGND VGND VPWR VPWR sky130_fd_sc_hd__fill_1
XFILLER_0_86_197 VPWR VGND VPWR VGND sky130_ef_sc_hd__decap_12
XFILLER_0_86_186 VGND VGND VPWR VPWR sky130_fd_sc_hd__fill_2
X_6600_ registers\[0\]\[0\] _2958_ _3175_ VGND VGND VPWR VPWR _3176_ sky130_fd_sc_hd__mux2_1
XFILLER_0_27_220 VGND VGND VPWR VPWR sky130_fd_sc_hd__fill_2
XFILLER_0_117_428 VGND VGND VPWR VPWR sky130_fd_sc_hd__fill_2
XFILLER_0_7_648 VGND VGND VPWR VPWR sky130_fd_sc_hd__fill_2
XFILLER_0_6_114 VGND VGND VPWR VPWR sky130_fd_sc_hd__fill_1
X_4792_ _1389_ _1563_ VGND VGND VPWR VPWR _1564_ sky130_fd_sc_hd__nor2_1
X_7580_ _3713_ VGND VGND VPWR VPWR _0211_ sky130_fd_sc_hd__clkbuf_1
XFILLER_0_103_85 VGND VGND VPWR VPWR sky130_fd_sc_hd__fill_1
X_6531_ _3138_ VGND VGND VPWR VPWR _0761_ sky130_fd_sc_hd__clkbuf_1
XFILLER_0_15_437 VGND VGND VPWR VPWR sky130_fd_sc_hd__decap_4
X_6462_ _3091_ VGND VGND VPWR VPWR _0739_ sky130_fd_sc_hd__clkbuf_1
XANTENNA__6155__C1 _2560_ VGND VGND VPWR VPWR sky130_fd_sc_hd__diode_2
XFILLER_0_42_234 VGND VGND VPWR VPWR sky130_fd_sc_hd__decap_4
XFILLER_0_15_459 VGND VGND VPWR VPWR sky130_fd_sc_hd__fill_2
XFILLER_0_27_297 VGND VGND VPWR VPWR sky130_fd_sc_hd__fill_1
X_9250_ clknet_leaf_0_clk _0347_ VGND VGND VPWR VPWR registers\[27\]\[2\] sky130_fd_sc_hd__dfxtp_1
XFILLER_0_113_656 VPWR VGND VPWR VGND sky130_ef_sc_hd__decap_12
XFILLER_0_113_645 VGND VGND VPWR VPWR sky130_fd_sc_hd__decap_8
XFILLER_0_88_54 VGND VGND VPWR VPWR sky130_fd_sc_hd__decap_4
XFILLER_0_88_32 VGND VGND VPWR VPWR sky130_fd_sc_hd__decap_6
X_6393_ _3048_ VGND VGND VPWR VPWR _0713_ sky130_fd_sc_hd__clkbuf_1
X_8201_ _4042_ VGND VGND VPWR VPWR _0503_ sky130_fd_sc_hd__clkbuf_1
X_9181_ clknet_leaf_103_clk _0278_ VGND VGND VPWR VPWR registers\[24\]\[29\] sky130_fd_sc_hd__dfxtp_1
X_5413_ _2152_ VGND VGND VPWR VPWR net101 sky130_fd_sc_hd__inv_2
Xoutput101 net101 VGND VGND VPWR VPWR rd1[28] sky130_fd_sc_hd__buf_1
XANTENNA__8447__A1 net25 VGND VGND VPWR VPWR sky130_fd_sc_hd__diode_2
Xoutput123 net123 VGND VGND VPWR VPWR rd2[19] sky130_fd_sc_hd__buf_1
Xoutput134 net134 VGND VGND VPWR VPWR rd2[29] sky130_fd_sc_hd__buf_1
X_5344_ _2085_ _2086_ _1768_ VGND VGND VPWR VPWR _2087_ sky130_fd_sc_hd__mux2_1
XFILLER_0_2_342 VGND VGND VPWR VPWR sky130_fd_sc_hd__decap_4
XANTENNA__4800__S0 _1555_ VGND VGND VPWR VPWR sky130_fd_sc_hd__diode_2
Xoutput112 net112 VGND VGND VPWR VPWR rd1[9] sky130_fd_sc_hd__buf_1
X_8132_ _3024_ registers\[30\]\[30\] _3972_ VGND VGND VPWR VPWR _4006_ sky130_fd_sc_hd__mux2_1
XFILLER_0_100_339 VGND VGND VPWR VPWR sky130_fd_sc_hd__fill_2
X_8063_ _3969_ VGND VGND VPWR VPWR _0438_ sky130_fd_sc_hd__clkbuf_1
X_5275_ registers\[8\]\[21\] registers\[9\]\[21\] registers\[10\]\[21\] registers\[11\]\[21\]
+ _2020_ _2021_ VGND VGND VPWR VPWR _2022_ sky130_fd_sc_hd__mux4_1
XANTENNA__6339__S _3004_ VGND VGND VPWR VPWR sky130_fd_sc_hd__diode_2
XANTENNA__4648__A _1321_ VGND VGND VPWR VPWR sky130_fd_sc_hd__diode_2
X_7014_ _3397_ VGND VGND VPWR VPWR _3398_ sky130_fd_sc_hd__clkbuf_8
X_4226_ a2[0] VGND VGND VPWR VPWR _1026_ sky130_fd_sc_hd__buf_4
X_8965_ clknet_leaf_27_clk _0062_ VGND VGND VPWR VPWR registers\[18\]\[5\] sky130_fd_sc_hd__dfxtp_1
X_7916_ _3119_ registers\[27\]\[24\] _3887_ VGND VGND VPWR VPWR _3892_ sky130_fd_sc_hd__mux2_1
X_8896_ clknet_leaf_112_clk _1017_ VGND VGND VPWR VPWR registers\[16\]\[0\] sky130_fd_sc_hd__dfxtp_1
XFILLER_0_65_315 VGND VGND VPWR VPWR sky130_fd_sc_hd__decap_8
XTAP_TAPCELL_ROW_54_958 VGND VPWR sky130_fd_sc_hd__tapvpwrvgnd_1
XANTENNA__7186__A1 _3437_ VGND VGND VPWR VPWR sky130_fd_sc_hd__diode_2
XFILLER_0_19_710 VGND VGND VPWR VPWR sky130_fd_sc_hd__decap_3
X_7847_ _3855_ VGND VGND VPWR VPWR _0336_ sky130_fd_sc_hd__clkbuf_1
XFILLER_0_92_123 VGND VGND VPWR VPWR sky130_fd_sc_hd__fill_1
XFILLER_0_65_337 VGND VGND VPWR VPWR sky130_fd_sc_hd__decap_4
XANTENNA__4619__S0 _1338_ VGND VGND VPWR VPWR sky130_fd_sc_hd__diode_2
XANTENNA__5292__S0 _1810_ VGND VGND VPWR VPWR sky130_fd_sc_hd__diode_2
X_7778_ _3117_ registers\[25\]\[23\] _3815_ VGND VGND VPWR VPWR _3819_ sky130_fd_sc_hd__mux2_1
X_9517_ clknet_leaf_50_clk _0614_ VGND VGND VPWR VPWR registers\[8\]\[13\] sky130_fd_sc_hd__dfxtp_1
XFILLER_0_80_318 VGND VGND VPWR VPWR sky130_fd_sc_hd__fill_2
X_6729_ registers\[10\]\[28\] _3020_ _3236_ VGND VGND VPWR VPWR _3245_ sky130_fd_sc_hd__mux2_1
XFILLER_0_18_275 VGND VGND VPWR VPWR sky130_fd_sc_hd__decap_4
XFILLER_0_18_286 VGND VGND VPWR VPWR sky130_fd_sc_hd__fill_2
XFILLER_0_104_601 VGND VGND VPWR VPWR sky130_fd_sc_hd__fill_1
XANTENNA__4322__S _1117_ VGND VGND VPWR VPWR sky130_fd_sc_hd__diode_2
X_9448_ clknet_leaf_20_clk _0545_ VGND VGND VPWR VPWR registers\[31\]\[8\] sky130_fd_sc_hd__dfxtp_1
Xclkbuf_leaf_112_clk clknet_4_0_0_clk VGND VGND VPWR VPWR clknet_leaf_112_clk sky130_fd_sc_hd__clkbuf_8
XFILLER_0_33_223 VGND VGND VPWR VPWR sky130_fd_sc_hd__fill_1
XFILLER_0_104_645 VGND VGND VPWR VPWR sky130_fd_sc_hd__fill_2
XFILLER_0_104_634 VGND VGND VPWR VPWR sky130_fd_sc_hd__fill_2
XFILLER_0_104_689 VGND VGND VPWR VPWR sky130_fd_sc_hd__decap_8
X_9379_ clknet_leaf_21_clk _0476_ VGND VGND VPWR VPWR registers\[9\]\[3\] sky130_fd_sc_hd__dfxtp_1
XFILLER_0_14_470 VGND VGND VPWR VPWR sky130_fd_sc_hd__fill_2
XTAP_TAPCELL_ROW_111_1707 VGND VPWR sky130_fd_sc_hd__tapvpwrvgnd_1
XANTENNA__5153__S _1682_ VGND VGND VPWR VPWR sky130_fd_sc_hd__diode_2
XANTENNA__5661__B _2395_ VGND VGND VPWR VPWR sky130_fd_sc_hd__diode_2
XTAP_TAPCELL_ROW_6_341 VGND VPWR sky130_fd_sc_hd__tapvpwrvgnd_1
XANTENNA__5672__A1 net124 VGND VGND VPWR VPWR sky130_fd_sc_hd__diode_2
XTAP_TAPCELL_ROW_70_1172 VGND VPWR sky130_fd_sc_hd__tapvpwrvgnd_1
XANTENNA__8464__S _4175_ VGND VGND VPWR VPWR sky130_fd_sc_hd__diode_2
XFILLER_0_96_440 VGND VGND VPWR VPWR sky130_fd_sc_hd__fill_1
XFILLER_0_69_665 VGND VGND VPWR VPWR sky130_fd_sc_hd__decap_6
XANTENNA__7808__S _3829_ VGND VGND VPWR VPWR sky130_fd_sc_hd__diode_2
XFILLER_0_68_197 VGND VGND VPWR VPWR sky130_fd_sc_hd__fill_2
XANTENNA__5283__S0 _2027_ VGND VGND VPWR VPWR sky130_fd_sc_hd__diode_2
XANTENNA__8126__A0 _3018_ VGND VGND VPWR VPWR sky130_fd_sc_hd__diode_2
XANTENNA__6013__A _2490_ VGND VGND VPWR VPWR sky130_fd_sc_hd__diode_2
Xinput25 wd3[18] VGND VGND VPWR VPWR net25 sky130_fd_sc_hd__buf_2
Xinput36 wd3[28] VGND VGND VPWR VPWR net36 sky130_fd_sc_hd__buf_2
Xinput14 alu_op[0] VGND VGND VPWR VPWR net14 sky130_fd_sc_hd__clkbuf_4
Xclkbuf_leaf_103_clk clknet_4_8_0_clk VGND VGND VPWR VPWR clknet_leaf_103_clk sky130_fd_sc_hd__clkbuf_8
XFILLER_0_4_629 VGND VGND VPWR VPWR sky130_fd_sc_hd__fill_2
XANTENNA__4232__S _1031_ VGND VGND VPWR VPWR sky130_fd_sc_hd__diode_2
Xinput47 wd3[9] VGND VGND VPWR VPWR net47 sky130_fd_sc_hd__clkbuf_2
XFILLER_0_52_565 VGND VGND VPWR VPWR sky130_fd_sc_hd__decap_3
XFILLER_0_52_598 VGND VGND VPWR VPWR sky130_fd_sc_hd__fill_2
XANTENNA__7543__S _3684_ VGND VGND VPWR VPWR sky130_fd_sc_hd__diode_2
XANTENNA__6667__B net48 VGND VGND VPWR VPWR sky130_fd_sc_hd__diode_2
XANTENNA__6159__S _2460_ VGND VGND VPWR VPWR sky130_fd_sc_hd__diode_2
X_5060_ _1819_ VGND VGND VPWR VPWR net111 sky130_fd_sc_hd__inv_2
XTAP_TAPCELL_ROW_88_1400 VGND VPWR sky130_fd_sc_hd__tapvpwrvgnd_1
XFILLER_0_74_45 VGND VGND VPWR VPWR sky130_fd_sc_hd__fill_1
X_8750_ clknet_leaf_39_clk _0871_ VGND VGND VPWR VPWR registers\[11\]\[14\] sky130_fd_sc_hd__dfxtp_1
XFILLER_0_90_11 VGND VGND VPWR VPWR sky130_fd_sc_hd__decap_8
X_5962_ _1913_ _2661_ VGND VGND VPWR VPWR _2683_ sky130_fd_sc_hd__nor2_1
XFILLER_0_90_33 VGND VGND VPWR VPWR sky130_fd_sc_hd__fill_1
XFILLER_0_90_22 VGND VGND VPWR VPWR sky130_fd_sc_hd__decap_6
X_4913_ _1628_ VGND VGND VPWR VPWR _1678_ sky130_fd_sc_hd__buf_4
X_7701_ registers\[24\]\[19\] _3474_ _3768_ VGND VGND VPWR VPWR _3778_ sky130_fd_sc_hd__mux2_1
XFILLER_0_59_164 VGND VGND VPWR VPWR sky130_fd_sc_hd__fill_2
XFILLER_0_114_51 VGND VGND VPWR VPWR sky130_fd_sc_hd__fill_2
X_5893_ _2540_ _2617_ _2403_ VGND VGND VPWR VPWR _2618_ sky130_fd_sc_hd__mux2_1
XFILLER_0_75_624 VGND VGND VPWR VPWR sky130_fd_sc_hd__decap_4
X_8681_ clknet_leaf_17_clk _0802_ VGND VGND VPWR VPWR registers\[0\]\[9\] sky130_fd_sc_hd__dfxtp_1
XFILLER_0_59_175 VGND VGND VPWR VPWR sky130_fd_sc_hd__decap_3
XTAP_TAPCELL_ROW_51_928 VGND VPWR sky130_fd_sc_hd__tapvpwrvgnd_1
XTAP_TAPCELL_ROW_51_917 VGND VPWR sky130_fd_sc_hd__tapvpwrvgnd_1
XANTENNA__7718__S _3779_ VGND VGND VPWR VPWR sky130_fd_sc_hd__diode_2
XFILLER_0_117_214 VGND VGND VPWR VPWR sky130_fd_sc_hd__fill_1
XFILLER_0_74_145 VGND VGND VPWR VPWR sky130_fd_sc_hd__decap_8
X_7632_ _3108_ registers\[23\]\[19\] _3731_ VGND VGND VPWR VPWR _3741_ sky130_fd_sc_hd__mux2_1
X_4844_ _1611_ _1612_ _1513_ VGND VGND VPWR VPWR _1613_ sky130_fd_sc_hd__mux2_1
X_7563_ _3704_ VGND VGND VPWR VPWR _0203_ sky130_fd_sc_hd__clkbuf_1
X_4775_ _1542_ _1544_ _1547_ _1389_ _1109_ VGND VGND VPWR VPWR _1548_ sky130_fd_sc_hd__o221a_1
XTAP_TAPCELL_ROW_99_1551 VGND VPWR sky130_fd_sc_hd__tapvpwrvgnd_1
XFILLER_0_99_53 VGND VGND VPWR VPWR sky130_fd_sc_hd__decap_3
XTAP_TAPCELL_ROW_99_1540 VGND VPWR sky130_fd_sc_hd__tapvpwrvgnd_1
X_9302_ clknet_leaf_93_clk _0399_ VGND VGND VPWR VPWR registers\[28\]\[22\] sky130_fd_sc_hd__dfxtp_1
X_6514_ _3126_ VGND VGND VPWR VPWR _0756_ sky130_fd_sc_hd__clkbuf_1
XTAP_TAPCELL_ROW_31_663 VGND VPWR sky130_fd_sc_hd__tapvpwrvgnd_1
X_9233_ clknet_leaf_55_clk _0330_ VGND VGND VPWR VPWR registers\[26\]\[17\] sky130_fd_sc_hd__dfxtp_1
X_7494_ _3106_ registers\[21\]\[18\] _3659_ VGND VGND VPWR VPWR _3668_ sky130_fd_sc_hd__mux2_1
XFILLER_0_15_278 VGND VGND VPWR VPWR sky130_fd_sc_hd__fill_2
X_6445_ _3079_ registers\[29\]\[5\] _3069_ VGND VGND VPWR VPWR _3080_ sky130_fd_sc_hd__mux2_1
XFILLER_0_70_395 VGND VGND VPWR VPWR sky130_fd_sc_hd__fill_2
XANTENNA__7453__S _3611_ VGND VGND VPWR VPWR sky130_fd_sc_hd__diode_2
X_9164_ clknet_leaf_43_clk _0261_ VGND VGND VPWR VPWR registers\[24\]\[12\] sky130_fd_sc_hd__dfxtp_1
X_6376_ _3039_ VGND VGND VPWR VPWR _0705_ sky130_fd_sc_hd__clkbuf_1
X_9095_ clknet_leaf_24_clk _0192_ VGND VGND VPWR VPWR registers\[22\]\[7\] sky130_fd_sc_hd__dfxtp_1
X_5327_ _2067_ _2070_ _2019_ VGND VGND VPWR VPWR _2071_ sky130_fd_sc_hd__mux2_1
X_8115_ _3997_ VGND VGND VPWR VPWR _0462_ sky130_fd_sc_hd__clkbuf_1
X_8046_ registers\[2\]\[21\] _3479_ _3959_ VGND VGND VPWR VPWR _3961_ sky130_fd_sc_hd__mux2_1
XTAP_TAPCELL_ROW_3_300 VGND VPWR sky130_fd_sc_hd__tapvpwrvgnd_1
X_5258_ _1856_ _2005_ _1701_ VGND VGND VPWR VPWR _2006_ sky130_fd_sc_hd__o21a_1
XANTENNA__8284__S _4081_ VGND VGND VPWR VPWR sky130_fd_sc_hd__diode_2
X_5189_ _1939_ _1940_ _1752_ VGND VGND VPWR VPWR _1941_ sky130_fd_sc_hd__mux2_1
XFILLER_0_3_81 VPWR VGND VPWR VGND sky130_ef_sc_hd__decap_12
X_8948_ clknet_leaf_73_clk _0045_ VGND VGND VPWR VPWR registers\[17\]\[20\] sky130_fd_sc_hd__dfxtp_1
XTAP_TAPCELL_ROW_39_763 VGND VPWR sky130_fd_sc_hd__tapvpwrvgnd_1
XFILLER_0_66_613 VGND VGND VPWR VPWR sky130_fd_sc_hd__fill_2
XANTENNA__5002__A _1691_ VGND VGND VPWR VPWR sky130_fd_sc_hd__diode_2
XFILLER_0_38_304 VGND VGND VPWR VPWR sky130_fd_sc_hd__fill_1
XANTENNA__7628__S _3731_ VGND VGND VPWR VPWR sky130_fd_sc_hd__diode_2
X_8879_ clknet_leaf_45_clk _1000_ VGND VGND VPWR VPWR registers\[15\]\[15\] sky130_fd_sc_hd__dfxtp_1
XFILLER_0_66_668 VGND VGND VPWR VPWR sky130_fd_sc_hd__fill_2
XANTENNA__6532__S _3137_ VGND VGND VPWR VPWR sky130_fd_sc_hd__diode_2
XANTENNA__4841__A _1389_ VGND VGND VPWR VPWR sky130_fd_sc_hd__diode_2
XFILLER_0_108_236 VGND VGND VPWR VPWR sky130_fd_sc_hd__fill_2
XFILLER_0_80_115 VGND VGND VPWR VPWR sky130_fd_sc_hd__fill_1
XANTENNA__5265__S0 _1968_ VGND VGND VPWR VPWR sky130_fd_sc_hd__diode_2
XFILLER_0_116_291 VGND VGND VPWR VPWR sky130_fd_sc_hd__decap_3
XTAP_TAPCELL_ROW_59_1023 VGND VPWR sky130_fd_sc_hd__tapvpwrvgnd_1
XFILLER_0_34_565 VGND VGND VPWR VPWR sky130_fd_sc_hd__fill_2
XFILLER_0_34_587 VGND VGND VPWR VPWR sky130_fd_sc_hd__fill_1
XFILLER_0_104_464 VGND VGND VPWR VPWR sky130_fd_sc_hd__fill_2
XANTENNA__6134__A2 _2587_ VGND VGND VPWR VPWR sky130_fd_sc_hd__diode_2
XFILLER_0_0_109 VGND VGND VPWR VPWR sky130_fd_sc_hd__decap_3
XTAP_TAPCELL_ROW_72_1201 VGND VPWR sky130_fd_sc_hd__tapvpwrvgnd_1
XFILLER_0_21_259 VGND VGND VPWR VPWR sky130_fd_sc_hd__decap_3
XFILLER_0_119_29 VPWR VGND VPWR VGND sky130_ef_sc_hd__decap_12
XFILLER_0_100_692 VGND VGND VPWR VPWR sky130_fd_sc_hd__decap_6
XANTENNA_output139_A net139 VGND VGND VPWR VPWR sky130_fd_sc_hd__diode_2
XANTENNA__8194__S _4031_ VGND VGND VPWR VPWR sky130_fd_sc_hd__diode_2
XFILLER_0_89_727 VGND VGND VPWR VPWR sky130_fd_sc_hd__fill_1
XFILLER_0_44_26 VGND VGND VPWR VPWR sky130_fd_sc_hd__fill_2
XFILLER_0_69_462 VGND VGND VPWR VPWR sky130_fd_sc_hd__fill_1
XFILLER_0_96_281 VGND VGND VPWR VPWR sky130_fd_sc_hd__fill_2
XFILLER_0_84_421 VGND VGND VPWR VPWR sky130_fd_sc_hd__decap_4
XTAP_TAPCELL_ROW_83_1341 VGND VPWR sky130_fd_sc_hd__tapvpwrvgnd_1
XFILLER_0_56_101 VGND VGND VPWR VPWR sky130_fd_sc_hd__fill_2
XTAP_TAPCELL_ROW_17_479 VGND VPWR sky130_fd_sc_hd__tapvpwrvgnd_1
XANTENNA__6442__S _3069_ VGND VGND VPWR VPWR sky130_fd_sc_hd__diode_2
XFILLER_0_84_454 VGND VGND VPWR VPWR sky130_fd_sc_hd__fill_2
XFILLER_0_56_145 VGND VGND VPWR VPWR sky130_fd_sc_hd__decap_3
XFILLER_0_84_498 VGND VGND VPWR VPWR sky130_fd_sc_hd__fill_2
XFILLER_0_37_370 VGND VGND VPWR VPWR sky130_fd_sc_hd__decap_4
XFILLER_0_115_729 VGND VGND VPWR VPWR sky130_fd_sc_hd__decap_4
X_4560_ _1148_ VGND VGND VPWR VPWR _1344_ sky130_fd_sc_hd__clkbuf_8
XFILLER_0_72_649 VGND VGND VPWR VPWR sky130_fd_sc_hd__fill_1
XFILLER_0_25_521 VGND VGND VPWR VPWR sky130_fd_sc_hd__fill_1
XFILLER_0_114_239 VGND VGND VPWR VPWR sky130_fd_sc_hd__decap_8
XANTENNA__7273__S _3550_ VGND VGND VPWR VPWR sky130_fd_sc_hd__diode_2
XANTENNA__8369__S _4128_ VGND VGND VPWR VPWR sky130_fd_sc_hd__diode_2
X_4491_ _1148_ _1278_ VGND VGND VPWR VPWR _1279_ sky130_fd_sc_hd__or2_1
XANTENNA__7322__A1 _3437_ VGND VGND VPWR VPWR sky130_fd_sc_hd__diode_2
XFILLER_0_12_226 VGND VGND VPWR VPWR sky130_fd_sc_hd__fill_2
XANTENNA__4897__S _1621_ VGND VGND VPWR VPWR sky130_fd_sc_hd__diode_2
X_6230_ net138 _2932_ _2935_ VGND VGND VPWR VPWR _2936_ sky130_fd_sc_hd__a21oi_1
XFILLER_0_0_621 VGND VGND VPWR VPWR sky130_fd_sc_hd__fill_1
XFILLER_0_12_248 VGND VGND VPWR VPWR sky130_fd_sc_hd__fill_2
XFILLER_0_100_75 VGND VGND VPWR VPWR sky130_fd_sc_hd__decap_3
XANTENNA__5884__A1 _2399_ VGND VGND VPWR VPWR sky130_fd_sc_hd__diode_2
XTAP_TAPCELL_ROW_94_1481 VGND VPWR sky130_fd_sc_hd__tapvpwrvgnd_1
X_6161_ net129 net130 _2209_ _2815_ VGND VGND VPWR VPWR _2871_ sky130_fd_sc_hd__or4_1
X_5112_ registers\[16\]\[12\] registers\[17\]\[12\] registers\[18\]\[12\] registers\[19\]\[12\]
+ _1798_ _1799_ VGND VGND VPWR VPWR _1868_ sky130_fd_sc_hd__mux4_1
X_6092_ _2802_ _2805_ VGND VGND VPWR VPWR _2806_ sky130_fd_sc_hd__and2b_1
X_5043_ registers\[24\]\[8\] registers\[25\]\[8\] registers\[26\]\[8\] registers\[27\]\[8\]
+ _1798_ _1799_ VGND VGND VPWR VPWR _1803_ sky130_fd_sc_hd__mux4_1
XANTENNA__4926__A _1618_ VGND VGND VPWR VPWR sky130_fd_sc_hd__diode_2
XANTENNA_clkbuf_4_7_0_clk_A clknet_0_clk VGND VGND VPWR VPWR sky130_fd_sc_hd__diode_2
XANTENNA__7389__A1 _3433_ VGND VGND VPWR VPWR sky130_fd_sc_hd__diode_2
X_8802_ clknet_leaf_2_clk _0923_ VGND VGND VPWR VPWR registers\[13\]\[2\] sky130_fd_sc_hd__dfxtp_1
XANTENNA__4298__S1 _1061_ VGND VGND VPWR VPWR sky130_fd_sc_hd__diode_2
X_6994_ _3117_ registers\[14\]\[23\] _3383_ VGND VGND VPWR VPWR _3387_ sky130_fd_sc_hd__mux2_1
XTAP_TAPCELL_ROW_36_722 VGND VPWR sky130_fd_sc_hd__tapvpwrvgnd_1
XTAP_TAPCELL_ROW_36_733 VGND VPWR sky130_fd_sc_hd__tapvpwrvgnd_1
X_5945_ _2280_ _2284_ VGND VGND VPWR VPWR _2667_ sky130_fd_sc_hd__nand2_1
XFILLER_0_87_281 VGND VGND VPWR VPWR sky130_fd_sc_hd__fill_2
XFILLER_0_75_421 VGND VGND VPWR VPWR sky130_fd_sc_hd__decap_4
X_8733_ clknet_leaf_105_clk _0854_ VGND VGND VPWR VPWR registers\[10\]\[29\] sky130_fd_sc_hd__dfxtp_1
X_5876_ _2600_ _2601_ VGND VGND VPWR VPWR _2602_ sky130_fd_sc_hd__nor2_1
X_8664_ clknet_leaf_88_clk _0785_ VGND VGND VPWR VPWR registers\[7\]\[24\] sky130_fd_sc_hd__dfxtp_1
XFILLER_0_8_710 VGND VGND VPWR VPWR sky130_fd_sc_hd__fill_2
X_7615_ _3732_ VGND VGND VPWR VPWR _0227_ sky130_fd_sc_hd__clkbuf_1
X_4827_ registers\[4\]\[30\] registers\[5\]\[30\] registers\[6\]\[30\] registers\[7\]\[30\]
+ _1433_ _1434_ VGND VGND VPWR VPWR _1597_ sky130_fd_sc_hd__mux4_1
XFILLER_0_8_732 VGND VGND VPWR VPWR sky130_fd_sc_hd__fill_1
XFILLER_0_106_729 VGND VGND VPWR VPWR sky130_fd_sc_hd__fill_1
X_8595_ clknet_leaf_13_clk _0716_ VGND VGND VPWR VPWR registers\[3\]\[19\] sky130_fd_sc_hd__dfxtp_1
X_7546_ _3089_ registers\[22\]\[10\] _3695_ VGND VGND VPWR VPWR _3696_ sky130_fd_sc_hd__mux2_1
X_4758_ _1159_ _1527_ _1531_ _1109_ VGND VGND VPWR VPWR _1532_ sky130_fd_sc_hd__o211a_1
XFILLER_0_31_502 VGND VGND VPWR VPWR sky130_fd_sc_hd__fill_2
XANTENNA__4470__S1 _1203_ VGND VGND VPWR VPWR sky130_fd_sc_hd__diode_2
XANTENNA__5492__A net113 VGND VGND VPWR VPWR sky130_fd_sc_hd__diode_2
X_7477_ _3647_ VGND VGND VPWR VPWR _3659_ sky130_fd_sc_hd__clkbuf_8
X_4689_ _1461_ _1463_ _1466_ _1379_ _1143_ VGND VGND VPWR VPWR _1467_ sky130_fd_sc_hd__a221o_1
XFILLER_0_31_535 VGND VGND VPWR VPWR sky130_fd_sc_hd__fill_1
XFILLER_0_101_423 VGND VGND VPWR VPWR sky130_fd_sc_hd__decap_3
X_9216_ clknet_leaf_111_clk _0313_ VGND VGND VPWR VPWR registers\[26\]\[0\] sky130_fd_sc_hd__dfxtp_1
X_6428_ _3066_ _3067_ VGND VGND VPWR VPWR _3068_ sky130_fd_sc_hd__nand2_4
X_9147_ clknet_leaf_102_clk _0244_ VGND VGND VPWR VPWR registers\[23\]\[27\] sky130_fd_sc_hd__dfxtp_1
XANTENNA__7077__A0 _3131_ VGND VGND VPWR VPWR sky130_fd_sc_hd__diode_2
X_6359_ registers\[3\]\[0\] _2958_ _3030_ VGND VGND VPWR VPWR _3031_ sky130_fd_sc_hd__mux2_1
X_9078_ clknet_leaf_90_clk _0175_ VGND VGND VPWR VPWR registers\[21\]\[22\] sky130_fd_sc_hd__dfxtp_1
X_8029_ registers\[2\]\[13\] _3462_ _3948_ VGND VGND VPWR VPWR _3952_ sky130_fd_sc_hd__mux2_1
XTAP_TAPCELL_ROW_106_1639 VGND VPWR sky130_fd_sc_hd__tapvpwrvgnd_1
XFILLER_0_14_29 VGND VGND VPWR VPWR sky130_fd_sc_hd__fill_2
XFILLER_0_39_668 VGND VGND VPWR VPWR sky130_fd_sc_hd__fill_1
XANTENNA__6262__S _2962_ VGND VGND VPWR VPWR sky130_fd_sc_hd__diode_2
XANTENNA__8043__A _3936_ VGND VGND VPWR VPWR sky130_fd_sc_hd__diode_2
XFILLER_0_66_465 VGND VGND VPWR VPWR sky130_fd_sc_hd__fill_2
XANTENNA__5238__S0 _1883_ VGND VGND VPWR VPWR sky130_fd_sc_hd__diode_2
XTAP_TAPCELL_ROW_14_438 VGND VPWR sky130_fd_sc_hd__tapvpwrvgnd_1
XFILLER_0_47_690 VGND VGND VPWR VPWR sky130_fd_sc_hd__fill_1
XANTENNA__4461__S1 _1112_ VGND VGND VPWR VPWR sky130_fd_sc_hd__diode_2
XANTENNA__7093__S _3435_ VGND VGND VPWR VPWR sky130_fd_sc_hd__diode_2
XANTENNA_clkbuf_leaf_73_clk_A clknet_4_11_0_clk VGND VGND VPWR VPWR sky130_fd_sc_hd__diode_2
XANTENNA__7304__A1 _3487_ VGND VGND VPWR VPWR sky130_fd_sc_hd__diode_2
XTAP_TAPCELL_ROW_117_1779 VGND VPWR sky130_fd_sc_hd__tapvpwrvgnd_1
XFILLER_0_10_719 VPWR VGND VPWR VGND sky130_ef_sc_hd__decap_12
XANTENNA__5866__A1 _1835_ VGND VGND VPWR VPWR sky130_fd_sc_hd__diode_2
XANTENNA__7821__S _3840_ VGND VGND VPWR VPWR sky130_fd_sc_hd__diode_2
XANTENNA_clkbuf_leaf_88_clk_A clknet_4_8_0_clk VGND VGND VPWR VPWR sky130_fd_sc_hd__diode_2
XANTENNA_clkbuf_leaf_11_clk_A clknet_4_3_0_clk VGND VGND VPWR VPWR sky130_fd_sc_hd__diode_2
XFILLER_0_119_309 VPWR VGND VPWR VGND sky130_ef_sc_hd__decap_12
XFILLER_0_71_35 VGND VGND VPWR VPWR sky130_fd_sc_hd__decap_3
XFILLER_0_69_281 VGND VGND VPWR VPWR sky130_fd_sc_hd__decap_4
X_5730_ _2294_ _2298_ _2309_ _2321_ VGND VGND VPWR VPWR _2462_ sky130_fd_sc_hd__a22o_1
XANTENNA_clkbuf_leaf_26_clk_A clknet_4_4_0_clk VGND VGND VPWR VPWR sky130_fd_sc_hd__diode_2
XFILLER_0_71_68 VGND VGND VPWR VPWR sky130_fd_sc_hd__fill_2
XFILLER_0_71_57 VGND VGND VPWR VPWR sky130_fd_sc_hd__decap_4
XANTENNA__7268__S _3539_ VGND VGND VPWR VPWR sky130_fd_sc_hd__diode_2
XFILLER_0_29_134 VGND VGND VPWR VPWR sky130_fd_sc_hd__fill_2
XFILLER_0_17_329 VGND VGND VPWR VPWR sky130_fd_sc_hd__decap_4
X_7400_ _3618_ VGND VGND VPWR VPWR _0126_ sky130_fd_sc_hd__clkbuf_1
XFILLER_0_72_446 VGND VGND VPWR VPWR sky130_fd_sc_hd__decap_3
X_5661_ _1071_ _2395_ VGND VGND VPWR VPWR _2396_ sky130_fd_sc_hd__xnor2_1
XFILLER_0_57_498 VGND VGND VPWR VPWR sky130_fd_sc_hd__decap_4
XANTENNA__6900__S _3335_ VGND VGND VPWR VPWR sky130_fd_sc_hd__diode_2
XTAP_TAPCELL_ROW_96_1510 VGND VPWR sky130_fd_sc_hd__tapvpwrvgnd_1
Xclkbuf_4_4_0_clk clknet_0_clk VGND VGND VPWR VPWR clknet_4_4_0_clk sky130_fd_sc_hd__clkbuf_8
X_5592_ _2308_ _2325_ _2326_ VGND VGND VPWR VPWR _2327_ sky130_fd_sc_hd__and3_1
X_4612_ _1392_ _1393_ _1346_ VGND VGND VPWR VPWR _1394_ sky130_fd_sc_hd__mux2_1
X_8380_ _4137_ VGND VGND VPWR VPWR _0587_ sky130_fd_sc_hd__clkbuf_1
XTAP_TAPCELL_ROW_41_791 VGND VPWR sky130_fd_sc_hd__tapvpwrvgnd_1
XFILLER_0_5_724 VGND VGND VPWR VPWR sky130_fd_sc_hd__decap_4
XFILLER_0_4_201 VGND VGND VPWR VPWR sky130_fd_sc_hd__fill_1
XFILLER_0_13_502 VGND VGND VPWR VPWR sky130_fd_sc_hd__fill_2
XANTENNA__8099__S _3984_ VGND VGND VPWR VPWR sky130_fd_sc_hd__diode_2
XFILLER_0_115_559 VGND VGND VPWR VPWR sky130_fd_sc_hd__fill_1
X_7331_ _3581_ VGND VGND VPWR VPWR _0094_ sky130_fd_sc_hd__clkbuf_1
XANTENNA__4452__S1 _1112_ VGND VGND VPWR VPWR sky130_fd_sc_hd__diode_2
X_4543_ _1322_ _1325_ _1326_ _1327_ _1132_ _1135_ VGND VGND VPWR VPWR _1328_ sky130_fd_sc_hd__mux4_1
XFILLER_0_13_524 VGND VGND VPWR VPWR sky130_fd_sc_hd__fill_2
XFILLER_0_25_384 VGND VGND VPWR VPWR sky130_fd_sc_hd__fill_2
XFILLER_0_102_209 VGND VGND VPWR VPWR sky130_fd_sc_hd__fill_1
X_7262_ registers\[18\]\[5\] _3445_ _3539_ VGND VGND VPWR VPWR _3545_ sky130_fd_sc_hd__mux2_1
XFILLER_0_52_192 VGND VGND VPWR VPWR sky130_fd_sc_hd__fill_2
XANTENNA__6201__A _2152_ VGND VGND VPWR VPWR sky130_fd_sc_hd__diode_2
XFILLER_0_4_289 VGND VGND VPWR VPWR sky130_fd_sc_hd__fill_1
XFILLER_0_20_72 VGND VGND VPWR VPWR sky130_fd_sc_hd__decap_4
XFILLER_0_20_94 VGND VGND VPWR VPWR sky130_fd_sc_hd__decap_3
X_4474_ _1131_ _1262_ VGND VGND VPWR VPWR _1263_ sky130_fd_sc_hd__or2_1
X_9001_ clknet_leaf_16_clk _0098_ VGND VGND VPWR VPWR registers\[1\]\[9\] sky130_fd_sc_hd__dfxtp_1
X_6213_ _2909_ _2912_ VGND VGND VPWR VPWR _2920_ sky130_fd_sc_hd__or2_1
XFILLER_0_40_365 VGND VGND VPWR VPWR sky130_fd_sc_hd__fill_2
XANTENNA__5401__S0 _2097_ VGND VGND VPWR VPWR sky130_fd_sc_hd__diode_2
XFILLER_0_110_253 VGND VGND VPWR VPWR sky130_fd_sc_hd__decap_3
X_7193_ _3508_ VGND VGND VPWR VPWR _0029_ sky130_fd_sc_hd__clkbuf_1
XFILLER_0_0_462 VGND VGND VPWR VPWR sky130_fd_sc_hd__fill_2
XFILLER_0_110_297 VGND VGND VPWR VPWR sky130_fd_sc_hd__decap_4
X_6144_ _2853_ _2587_ _2854_ _2766_ _2420_ VGND VGND VPWR VPWR _2855_ sky130_fd_sc_hd__o221a_1
X_6075_ _2653_ _2692_ _2789_ _2497_ VGND VGND VPWR VPWR _2790_ sky130_fd_sc_hd__o2bb2a_1
X_5026_ _1783_ _1786_ _1634_ VGND VGND VPWR VPWR _1787_ sky130_fd_sc_hd__mux2_1
XFILLER_0_31_3 VGND VGND VPWR VPWR sky130_fd_sc_hd__fill_2
XTAP_TAPCELL_ROW_49_891 VGND VPWR sky130_fd_sc_hd__tapvpwrvgnd_1
Xclkbuf_leaf_92_clk clknet_4_9_0_clk VGND VGND VPWR VPWR clknet_leaf_92_clk sky130_fd_sc_hd__clkbuf_8
X_6977_ _3100_ registers\[14\]\[15\] _3372_ VGND VGND VPWR VPWR _3378_ sky130_fd_sc_hd__mux2_1
X_5928_ _2331_ _2340_ VGND VGND VPWR VPWR _2651_ sky130_fd_sc_hd__and2_1
X_8716_ clknet_leaf_17_clk _0837_ VGND VGND VPWR VPWR registers\[10\]\[12\] sky130_fd_sc_hd__dfxtp_1
XANTENNA__4391__A _1184_ VGND VGND VPWR VPWR sky130_fd_sc_hd__diode_2
X_8647_ clknet_leaf_33_clk _0768_ VGND VGND VPWR VPWR registers\[7\]\[7\] sky130_fd_sc_hd__dfxtp_1
XFILLER_0_106_515 VGND VGND VPWR VPWR sky130_fd_sc_hd__decap_3
XTAP_TAPCELL_ROW_101_1569 VGND VPWR sky130_fd_sc_hd__tapvpwrvgnd_1
X_5859_ _2570_ VGND VGND VPWR VPWR _2586_ sky130_fd_sc_hd__inv_2
XTAP_TAPCELL_ROW_11_408 VGND VPWR sky130_fd_sc_hd__tapvpwrvgnd_1
XANTENNA__4348__A1 _1135_ VGND VGND VPWR VPWR sky130_fd_sc_hd__diode_2
X_8578_ clknet_leaf_3_clk _0699_ VGND VGND VPWR VPWR registers\[3\]\[2\] sky130_fd_sc_hd__dfxtp_1
XFILLER_0_90_298 VGND VGND VPWR VPWR sky130_fd_sc_hd__decap_4
X_7529_ _3073_ registers\[22\]\[2\] _3684_ VGND VGND VPWR VPWR _3687_ sky130_fd_sc_hd__mux2_1
XFILLER_0_101_220 VGND VGND VPWR VPWR sky130_fd_sc_hd__fill_2
XFILLER_0_31_365 VGND VGND VPWR VPWR sky130_fd_sc_hd__fill_2
XFILLER_0_31_387 VGND VGND VPWR VPWR sky130_fd_sc_hd__fill_2
XFILLER_0_101_264 VGND VGND VPWR VPWR sky130_fd_sc_hd__fill_2
XANTENNA__7641__S _3742_ VGND VGND VPWR VPWR sky130_fd_sc_hd__diode_2
XTAP_TAPCELL_ROW_19_508 VGND VPWR sky130_fd_sc_hd__tapvpwrvgnd_1
XANTENNA_input15_A alu_op[1] VGND VGND VPWR VPWR sky130_fd_sc_hd__diode_2
XFILLER_0_98_354 VGND VGND VPWR VPWR sky130_fd_sc_hd__decap_3
XTAP_TAPCELL_ROW_67_1133 VGND VPWR sky130_fd_sc_hd__tapvpwrvgnd_1
XANTENNA__6025__A1 _1943_ VGND VGND VPWR VPWR sky130_fd_sc_hd__diode_2
Xclkbuf_leaf_83_clk clknet_4_10_0_clk VGND VGND VPWR VPWR clknet_leaf_83_clk sky130_fd_sc_hd__clkbuf_8
XANTENNA__6025__B2 _1959_ VGND VGND VPWR VPWR sky130_fd_sc_hd__diode_2
XFILLER_0_58_229 VGND VGND VPWR VPWR sky130_fd_sc_hd__decap_3
XANTENNA__4505__S _1117_ VGND VGND VPWR VPWR sky130_fd_sc_hd__diode_2
XANTENNA__4587__A1 _1135_ VGND VGND VPWR VPWR sky130_fd_sc_hd__diode_2
XTAP_TAPCELL_ROW_80_1300 VGND VPWR sky130_fd_sc_hd__tapvpwrvgnd_1
XFILLER_0_54_402 VGND VGND VPWR VPWR sky130_fd_sc_hd__decap_3
XANTENNA__4682__S1 _1419_ VGND VGND VPWR VPWR sky130_fd_sc_hd__diode_2
XFILLER_0_27_605 VGND VGND VPWR VPWR sky130_fd_sc_hd__fill_2
XTAP_TAPCELL_ROW_119_1808 VGND VPWR sky130_fd_sc_hd__tapvpwrvgnd_1
XFILLER_0_94_593 VGND VGND VPWR VPWR sky130_fd_sc_hd__fill_2
XANTENNA__7816__S _3829_ VGND VGND VPWR VPWR sky130_fd_sc_hd__diode_2
XFILLER_0_26_115 VGND VGND VPWR VPWR sky130_fd_sc_hd__fill_2
XTAP_TAPCELL_ROW_119_1819 VGND VPWR sky130_fd_sc_hd__tapvpwrvgnd_1
XFILLER_0_81_265 VGND VGND VPWR VPWR sky130_fd_sc_hd__fill_2
XFILLER_0_112_507 VGND VGND VPWR VPWR sky130_fd_sc_hd__decap_3
XFILLER_0_81_276 VGND VGND VPWR VPWR sky130_fd_sc_hd__fill_2
XANTENNA__4434__S1 _1054_ VGND VGND VPWR VPWR sky130_fd_sc_hd__diode_2
XFILLER_0_41_118 VGND VGND VPWR VPWR sky130_fd_sc_hd__fill_2
XFILLER_0_2_705 VGND VGND VPWR VPWR sky130_fd_sc_hd__fill_2
XANTENNA__7117__A net18 VGND VGND VPWR VPWR sky130_fd_sc_hd__diode_2
XFILLER_0_62_490 VGND VGND VPWR VPWR sky130_fd_sc_hd__fill_2
XFILLER_0_50_641 VGND VGND VPWR VPWR sky130_fd_sc_hd__decap_3
XTAP_TAPCELL_ROW_78_1273 VGND VPWR sky130_fd_sc_hd__tapvpwrvgnd_1
XANTENNA_output83_A net83 VGND VGND VPWR VPWR sky130_fd_sc_hd__diode_2
XTAP_TAPCELL_ROW_91_1440 VGND VPWR sky130_fd_sc_hd__tapvpwrvgnd_1
XFILLER_0_82_23 VGND VGND VPWR VPWR sky130_fd_sc_hd__fill_2
X_6900_ _3092_ registers\[13\]\[11\] _3335_ VGND VGND VPWR VPWR _3337_ sky130_fd_sc_hd__mux2_1
XFILLER_0_89_365 VGND VGND VPWR VPWR sky130_fd_sc_hd__decap_6
X_7880_ _3083_ registers\[27\]\[7\] _3865_ VGND VGND VPWR VPWR _3873_ sky130_fd_sc_hd__mux2_1
Xclkbuf_leaf_74_clk clknet_4_11_0_clk VGND VGND VPWR VPWR clknet_leaf_74_clk sky130_fd_sc_hd__clkbuf_8
X_6831_ _3300_ VGND VGND VPWR VPWR _0899_ sky130_fd_sc_hd__clkbuf_1
XTAP_TAPCELL_ROW_46_861 VGND VPWR sky130_fd_sc_hd__tapvpwrvgnd_1
XFILLER_0_106_85 VGND VGND VPWR VPWR sky130_fd_sc_hd__decap_4
X_9550_ clknet_leaf_40_clk _0647_ VGND VGND VPWR VPWR registers\[4\]\[14\] sky130_fd_sc_hd__dfxtp_1
X_6762_ registers\[11\]\[11\] _2985_ _3261_ VGND VGND VPWR VPWR _3263_ sky130_fd_sc_hd__mux2_1
X_8501_ registers\[4\]\[11\] net18 _4200_ VGND VGND VPWR VPWR _4202_ sky130_fd_sc_hd__mux2_1
XFILLER_0_17_104 VGND VGND VPWR VPWR sky130_fd_sc_hd__fill_2
X_6693_ _3226_ VGND VGND VPWR VPWR _0835_ sky130_fd_sc_hd__clkbuf_1
X_5713_ _2441_ _2444_ _2445_ VGND VGND VPWR VPWR _2446_ sky130_fd_sc_hd__mux2_1
X_9481_ clknet_leaf_17_clk _0578_ VGND VGND VPWR VPWR registers\[5\]\[9\] sky130_fd_sc_hd__dfxtp_1
XANTENNA__7726__S _3756_ VGND VGND VPWR VPWR sky130_fd_sc_hd__diode_2
X_8432_ _4165_ VGND VGND VPWR VPWR _0611_ sky130_fd_sc_hd__clkbuf_1
X_5644_ _2372_ _2378_ _1090_ VGND VGND VPWR VPWR _2379_ sky130_fd_sc_hd__mux2_1
X_8363_ registers\[5\]\[10\] _3455_ _4128_ VGND VGND VPWR VPWR _4129_ sky130_fd_sc_hd__mux2_1
XFILLER_0_26_682 VGND VGND VPWR VPWR sky130_fd_sc_hd__fill_2
XFILLER_0_103_518 VGND VGND VPWR VPWR sky130_fd_sc_hd__fill_2
XFILLER_0_79_3 VGND VGND VPWR VPWR sky130_fd_sc_hd__decap_4
X_5575_ _1704_ _2214_ VGND VGND VPWR VPWR _2311_ sky130_fd_sc_hd__or2_1
X_7314_ registers\[18\]\[30\] _3497_ _3538_ VGND VGND VPWR VPWR _3572_ sky130_fd_sc_hd__mux2_1
X_4526_ registers\[0\]\[14\] registers\[1\]\[14\] registers\[2\]\[14\] registers\[3\]\[14\]
+ _1126_ _1128_ VGND VGND VPWR VPWR _1312_ sky130_fd_sc_hd__mux4_1
X_8294_ _4080_ VGND VGND VPWR VPWR _4092_ sky130_fd_sc_hd__clkbuf_8
XFILLER_0_41_685 VGND VGND VPWR VPWR sky130_fd_sc_hd__fill_1
XFILLER_0_13_365 VGND VGND VPWR VPWR sky130_fd_sc_hd__fill_2
XFILLER_0_111_573 VGND VGND VPWR VPWR sky130_fd_sc_hd__fill_1
X_4457_ registers\[8\]\[10\] registers\[9\]\[10\] registers\[10\]\[10\] registers\[11\]\[10\]
+ _1196_ _1202_ VGND VGND VPWR VPWR _1247_ sky130_fd_sc_hd__mux4_1
X_7245_ _3535_ VGND VGND VPWR VPWR _0054_ sky130_fd_sc_hd__clkbuf_1
XANTENNA__7461__S _3648_ VGND VGND VPWR VPWR sky130_fd_sc_hd__diode_2
X_7176_ registers\[16\]\[30\] _3497_ _3434_ VGND VGND VPWR VPWR _3498_ sky130_fd_sc_hd__mux2_1
X_4388_ _1180_ _1181_ _1148_ VGND VGND VPWR VPWR _1182_ sky130_fd_sc_hd__mux2_1
X_6127_ _2829_ _2834_ _2836_ VGND VGND VPWR VPWR _2839_ sky130_fd_sc_hd__and3_1
XANTENNA_input7_A a2[3] VGND VGND VPWR VPWR sky130_fd_sc_hd__diode_2
X_6058_ _1995_ _2751_ _2740_ _1979_ VGND VGND VPWR VPWR _2774_ sky130_fd_sc_hd__a211o_1
XANTENNA__4266__B1 net7 VGND VGND VPWR VPWR sky130_fd_sc_hd__diode_2
XANTENNA__4361__S0 _1126_ VGND VGND VPWR VPWR sky130_fd_sc_hd__diode_2
X_5009_ _1655_ VGND VGND VPWR VPWR _1771_ sky130_fd_sc_hd__clkbuf_8
Xclkbuf_leaf_65_clk clknet_4_12_0_clk VGND VGND VPWR VPWR clknet_leaf_65_clk sky130_fd_sc_hd__clkbuf_8
XANTENNA__8292__S _4081_ VGND VGND VPWR VPWR sky130_fd_sc_hd__diode_2
XANTENNA__4325__S _1117_ VGND VGND VPWR VPWR sky130_fd_sc_hd__diode_2
XFILLER_0_95_357 VGND VGND VPWR VPWR sky130_fd_sc_hd__fill_1
XFILLER_0_64_711 VPWR VGND VPWR VGND sky130_ef_sc_hd__decap_12
XFILLER_0_119_673 VPWR VGND VPWR VGND sky130_ef_sc_hd__decap_12
XFILLER_0_63_221 VGND VGND VPWR VPWR sky130_fd_sc_hd__decap_3
XTAP_TAPCELL_ROW_62_1063 VGND VPWR sky130_fd_sc_hd__tapvpwrvgnd_1
XANTENNA__4664__S1 _1428_ VGND VGND VPWR VPWR sky130_fd_sc_hd__diode_2
XTAP_TAPCELL_ROW_24_566 VGND VPWR sky130_fd_sc_hd__tapvpwrvgnd_1
XTAP_TAPCELL_ROW_24_577 VGND VPWR sky130_fd_sc_hd__tapvpwrvgnd_1
XANTENNA__6540__S _3137_ VGND VGND VPWR VPWR sky130_fd_sc_hd__diode_2
XFILLER_0_106_301 VGND VGND VPWR VPWR sky130_fd_sc_hd__decap_3
XFILLER_0_63_287 VGND VGND VPWR VPWR sky130_fd_sc_hd__fill_2
XFILLER_0_63_276 VGND VGND VPWR VPWR sky130_fd_sc_hd__fill_2
XFILLER_0_51_438 VGND VGND VPWR VPWR sky130_fd_sc_hd__decap_6
XANTENNA__8180__A1 _3476_ VGND VGND VPWR VPWR sky130_fd_sc_hd__diode_2
XFILLER_0_51_449 VGND VGND VPWR VPWR sky130_fd_sc_hd__fill_2
XFILLER_0_32_630 VGND VGND VPWR VPWR sky130_fd_sc_hd__fill_2
XFILLER_0_32_652 VGND VGND VPWR VPWR sky130_fd_sc_hd__fill_2
XTAP_TAPCELL_ROW_114_1738 VGND VPWR sky130_fd_sc_hd__tapvpwrvgnd_1
XANTENNA__4741__A1 _1159_ VGND VGND VPWR VPWR sky130_fd_sc_hd__diode_2
XANTENNA_clkbuf_4_15_0_clk_A clknet_0_clk VGND VGND VPWR VPWR sky130_fd_sc_hd__diode_2
Xclkbuf_leaf_56_clk clknet_4_15_0_clk VGND VGND VPWR VPWR clknet_leaf_56_clk sky130_fd_sc_hd__clkbuf_8
XPHY_EDGE_ROW_101_Right_101 VGND VGND VPWR VPWR sky130_fd_sc_hd__decap_3
XANTENNA__4352__S0 _1111_ VGND VGND VPWR VPWR sky130_fd_sc_hd__diode_2
XANTENNA__6715__S _3236_ VGND VGND VPWR VPWR sky130_fd_sc_hd__diode_2
XFILLER_0_99_685 VGND VGND VPWR VPWR sky130_fd_sc_hd__decap_3
XTAP_TAPCELL_ROW_43_820 VGND VPWR sky130_fd_sc_hd__tapvpwrvgnd_1
XFILLER_0_82_530 VGND VGND VPWR VPWR sky130_fd_sc_hd__fill_2
XFILLER_0_67_593 VGND VGND VPWR VPWR sky130_fd_sc_hd__decap_4
XANTENNA__4655__S1 _1434_ VGND VGND VPWR VPWR sky130_fd_sc_hd__diode_2
XANTENNA__7546__S _3695_ VGND VGND VPWR VPWR sky130_fd_sc_hd__diode_2
XFILLER_0_82_541 VGND VGND VPWR VPWR sky130_fd_sc_hd__decap_6
XFILLER_0_6_318 VGND VGND VPWR VPWR sky130_fd_sc_hd__fill_1
XANTENNA__4407__S1 _1199_ VGND VGND VPWR VPWR sky130_fd_sc_hd__diode_2
XFILLER_0_82_574 VGND VGND VPWR VPWR sky130_fd_sc_hd__fill_2
XANTENNA__8171__A1 _3468_ VGND VGND VPWR VPWR sky130_fd_sc_hd__diode_2
XFILLER_0_70_725 VGND VGND VPWR VPWR sky130_fd_sc_hd__fill_2
XFILLER_0_70_714 VGND VGND VPWR VPWR sky130_fd_sc_hd__decap_4
XFILLER_0_14_129 VGND VGND VPWR VPWR sky130_fd_sc_hd__fill_2
X_5360_ registers\[20\]\[26\] registers\[21\]\[26\] registers\[22\]\[26\] registers\[23\]\[26\]
+ _1996_ _1997_ VGND VGND VPWR VPWR _2102_ sky130_fd_sc_hd__mux4_1
X_4311_ _1107_ VGND VGND VPWR VPWR _1108_ sky130_fd_sc_hd__clkbuf_4
XANTENNA__8377__S _4128_ VGND VGND VPWR VPWR sky130_fd_sc_hd__diode_2
X_5291_ registers\[16\]\[22\] registers\[17\]\[22\] registers\[18\]\[22\] registers\[19\]\[22\]
+ _1810_ _1811_ VGND VGND VPWR VPWR _2037_ sky130_fd_sc_hd__mux4_1
XFILLER_0_22_195 VGND VGND VPWR VPWR sky130_fd_sc_hd__fill_1
XANTENNA__7281__S _3550_ VGND VGND VPWR VPWR sky130_fd_sc_hd__diode_2
X_7030_ _3406_ VGND VGND VPWR VPWR _0992_ sky130_fd_sc_hd__clkbuf_1
X_4242_ _1031_ _1041_ VGND VGND VPWR VPWR _1042_ sky130_fd_sc_hd__or2_1
XANTENNA__4591__S0 _1338_ VGND VGND VPWR VPWR sky130_fd_sc_hd__diode_2
X_8981_ clknet_leaf_83_clk _0078_ VGND VGND VPWR VPWR registers\[18\]\[21\] sky130_fd_sc_hd__dfxtp_1
XFILLER_0_117_73 VGND VGND VPWR VPWR sky130_fd_sc_hd__decap_8
XFILLER_0_117_51 VGND VGND VPWR VPWR sky130_fd_sc_hd__decap_4
XANTENNA__4343__S0 _1136_ VGND VGND VPWR VPWR sky130_fd_sc_hd__diode_2
XFILLER_0_93_88 VGND VGND VPWR VPWR sky130_fd_sc_hd__decap_3
XANTENNA__6625__S _3186_ VGND VGND VPWR VPWR sky130_fd_sc_hd__diode_2
X_7932_ _3066_ _3285_ VGND VGND VPWR VPWR _3900_ sky130_fd_sc_hd__nand2_2
XFILLER_0_117_95 VPWR VGND VPWR VGND sky130_ef_sc_hd__decap_12
XFILLER_0_117_84 VGND VGND VPWR VPWR sky130_fd_sc_hd__decap_4
Xclkbuf_leaf_47_clk clknet_4_12_0_clk VGND VGND VPWR VPWR clknet_leaf_47_clk sky130_fd_sc_hd__clkbuf_8
XFILLER_0_77_346 VGND VGND VPWR VPWR sky130_fd_sc_hd__fill_2
XFILLER_0_77_335 VGND VGND VPWR VPWR sky130_fd_sc_hd__fill_1
X_7863_ _3863_ VGND VGND VPWR VPWR _0344_ sky130_fd_sc_hd__clkbuf_1
X_7794_ _3133_ registers\[25\]\[31\] _3792_ VGND VGND VPWR VPWR _3827_ sky130_fd_sc_hd__mux2_1
X_6814_ _3291_ VGND VGND VPWR VPWR _0891_ sky130_fd_sc_hd__clkbuf_1
X_6745_ registers\[11\]\[3\] _2968_ _3250_ VGND VGND VPWR VPWR _3254_ sky130_fd_sc_hd__mux2_1
XFILLER_0_45_210 VGND VGND VPWR VPWR sky130_fd_sc_hd__decap_3
XFILLER_0_9_167 VGND VGND VPWR VPWR sky130_fd_sc_hd__fill_1
X_9533_ clknet_leaf_106_clk _0630_ VGND VGND VPWR VPWR registers\[8\]\[29\] sky130_fd_sc_hd__dfxtp_1
XFILLER_0_116_621 VGND VGND VPWR VPWR sky130_fd_sc_hd__fill_2
XFILLER_0_9_178 VGND VGND VPWR VPWR sky130_fd_sc_hd__decap_3
X_9464_ clknet_leaf_86_clk _0561_ VGND VGND VPWR VPWR registers\[31\]\[24\] sky130_fd_sc_hd__dfxtp_1
XFILLER_0_18_468 VGND VGND VPWR VPWR sky130_fd_sc_hd__decap_6
XTAP_TAPCELL_ROW_21_536 VGND VPWR sky130_fd_sc_hd__tapvpwrvgnd_1
XFILLER_0_116_643 VGND VGND VPWR VPWR sky130_fd_sc_hd__fill_1
X_6676_ _3217_ VGND VGND VPWR VPWR _0827_ sky130_fd_sc_hd__clkbuf_1
X_8415_ _4156_ VGND VGND VPWR VPWR _0603_ sky130_fd_sc_hd__clkbuf_1
X_5627_ _2317_ VGND VGND VPWR VPWR _2362_ sky130_fd_sc_hd__clkbuf_4
X_9395_ clknet_leaf_14_clk _0492_ VGND VGND VPWR VPWR registers\[9\]\[19\] sky130_fd_sc_hd__dfxtp_1
XFILLER_0_45_298 VGND VGND VPWR VPWR sky130_fd_sc_hd__fill_2
XFILLER_0_5_373 VPWR VGND VPWR VGND sky130_ef_sc_hd__decap_12
XFILLER_0_14_641 VGND VGND VPWR VPWR sky130_fd_sc_hd__decap_3
XFILLER_0_33_449 VGND VGND VPWR VPWR sky130_fd_sc_hd__fill_2
XFILLER_0_103_348 VGND VGND VPWR VPWR sky130_fd_sc_hd__fill_2
X_5558_ _2289_ _2292_ _2293_ VGND VGND VPWR VPWR _2294_ sky130_fd_sc_hd__mux2_1
XANTENNA__4723__A1 _1389_ VGND VGND VPWR VPWR sky130_fd_sc_hd__diode_2
XFILLER_0_14_652 VGND VGND VPWR VPWR sky130_fd_sc_hd__fill_1
X_8346_ registers\[5\]\[2\] _3439_ _4117_ VGND VGND VPWR VPWR _4120_ sky130_fd_sc_hd__mux2_1
XFILLER_0_103_359 VGND VGND VPWR VPWR sky130_fd_sc_hd__fill_2
X_4509_ _1294_ _1295_ _1140_ VGND VGND VPWR VPWR _1296_ sky130_fd_sc_hd__mux2_1
X_8277_ _4083_ VGND VGND VPWR VPWR _0538_ sky130_fd_sc_hd__clkbuf_1
XFILLER_0_13_173 VGND VGND VPWR VPWR sky130_fd_sc_hd__fill_2
X_5489_ _2223_ _2224_ VGND VGND VPWR VPWR _2225_ sky130_fd_sc_hd__nand2_1
X_7228_ registers\[17\]\[21\] _3479_ _3525_ VGND VGND VPWR VPWR _3527_ sky130_fd_sc_hd__mux2_1
XANTENNA__5005__A _1627_ VGND VGND VPWR VPWR sky130_fd_sc_hd__diode_2
X_7159_ _3486_ VGND VGND VPWR VPWR _0017_ sky130_fd_sc_hd__clkbuf_1
XANTENNA__4334__S0 _1126_ VGND VGND VPWR VPWR sky130_fd_sc_hd__diode_2
XTAP_TAPCELL_ROW_29_636 VGND VPWR sky130_fd_sc_hd__tapvpwrvgnd_1
Xclkbuf_leaf_38_clk clknet_4_7_0_clk VGND VGND VPWR VPWR clknet_leaf_38_clk sky130_fd_sc_hd__clkbuf_8
XANTENNA__4885__S1 _1629_ VGND VGND VPWR VPWR sky130_fd_sc_hd__diode_2
XTAP_TAPCELL_ROW_1_272 VGND VPWR sky130_fd_sc_hd__tapvpwrvgnd_1
XANTENNA__4637__S1 _1416_ VGND VGND VPWR VPWR sky130_fd_sc_hd__diode_2
XFILLER_0_107_610 VGND VGND VPWR VPWR sky130_fd_sc_hd__decap_6
XANTENNA__7366__S _3597_ VGND VGND VPWR VPWR sky130_fd_sc_hd__diode_2
XFILLER_0_107_665 VGND VGND VPWR VPWR sky130_fd_sc_hd__fill_2
XFILLER_0_107_643 VGND VGND VPWR VPWR sky130_fd_sc_hd__fill_2
XFILLER_0_52_725 VGND VGND VPWR VPWR sky130_fd_sc_hd__fill_2
XFILLER_0_91_393 VGND VGND VPWR VPWR sky130_fd_sc_hd__decap_4
XFILLER_0_106_197 VGND VGND VPWR VPWR sky130_fd_sc_hd__fill_2
XFILLER_0_51_279 VGND VGND VPWR VPWR sky130_fd_sc_hd__fill_1
XFILLER_0_20_600 VGND VGND VPWR VPWR sky130_fd_sc_hd__fill_2
XTAP_TAPCELL_ROW_75_1232 VGND VPWR sky130_fd_sc_hd__tapvpwrvgnd_1
XTAP_TAPCELL_ROW_9_372 VGND VPWR sky130_fd_sc_hd__tapvpwrvgnd_1
XFILLER_0_47_48 VGND VGND VPWR VPWR sky130_fd_sc_hd__fill_2
XANTENNA__6219__A1 _2321_ VGND VGND VPWR VPWR sky130_fd_sc_hd__diode_2
XANTENNA__6445__S _3069_ VGND VGND VPWR VPWR sky130_fd_sc_hd__diode_2
Xclkbuf_leaf_29_clk clknet_4_5_0_clk VGND VGND VPWR VPWR clknet_leaf_29_clk sky130_fd_sc_hd__clkbuf_8
XFILLER_0_99_460 VGND VGND VPWR VPWR sky130_fd_sc_hd__fill_2
XFILLER_0_99_493 VGND VGND VPWR VPWR sky130_fd_sc_hd__fill_2
XFILLER_0_87_644 VGND VGND VPWR VPWR sky130_fd_sc_hd__decap_3
XTAP_TAPCELL_ROW_86_1372 VGND VPWR sky130_fd_sc_hd__tapvpwrvgnd_1
XFILLER_0_87_688 VGND VGND VPWR VPWR sky130_fd_sc_hd__fill_2
XTAP_TAPCELL_ROW_86_1383 VGND VPWR sky130_fd_sc_hd__tapvpwrvgnd_1
X_4860_ net1 VGND VGND VPWR VPWR _1628_ sky130_fd_sc_hd__buf_4
XANTENNA__8392__A1 _3485_ VGND VGND VPWR VPWR sky130_fd_sc_hd__diode_2
XFILLER_0_103_42 VGND VGND VPWR VPWR sky130_fd_sc_hd__fill_2
XFILLER_0_55_530 VGND VGND VPWR VPWR sky130_fd_sc_hd__fill_1
X_4791_ _1561_ _1562_ _1386_ VGND VGND VPWR VPWR _1563_ sky130_fd_sc_hd__mux2_1
XFILLER_0_27_254 VGND VGND VPWR VPWR sky130_fd_sc_hd__decap_3
X_6530_ registers\[7\]\[0\] _2958_ _3137_ VGND VGND VPWR VPWR _3138_ sky130_fd_sc_hd__mux2_1
XFILLER_0_103_53 VGND VGND VPWR VPWR sky130_fd_sc_hd__decap_3
XFILLER_0_113_613 VGND VGND VPWR VPWR sky130_fd_sc_hd__fill_1
X_6461_ _3089_ registers\[29\]\[10\] _3090_ VGND VGND VPWR VPWR _3091_ sky130_fd_sc_hd__mux2_1
XFILLER_0_15_449 VGND VGND VPWR VPWR sky130_fd_sc_hd__fill_1
X_6392_ registers\[3\]\[16\] _2995_ _3041_ VGND VGND VPWR VPWR _3048_ sky130_fd_sc_hd__mux2_1
X_8200_ registers\[9\]\[30\] _3497_ _4008_ VGND VGND VPWR VPWR _4042_ sky130_fd_sc_hd__mux2_1
X_5412_ _1977_ _2143_ _2147_ _2151_ VGND VGND VPWR VPWR _2152_ sky130_fd_sc_hd__o2bb2a_4
X_9180_ clknet_leaf_103_clk _0277_ VGND VGND VPWR VPWR registers\[24\]\[28\] sky130_fd_sc_hd__dfxtp_1
XFILLER_0_113_668 VGND VGND VPWR VPWR sky130_fd_sc_hd__decap_4
Xoutput113 net113 VGND VGND VPWR VPWR rd2[0] sky130_fd_sc_hd__buf_1
Xoutput124 net124 VGND VGND VPWR VPWR rd2[1] sky130_fd_sc_hd__buf_1
XFILLER_0_2_365 VGND VGND VPWR VPWR sky130_fd_sc_hd__fill_1
X_5343_ registers\[16\]\[25\] registers\[17\]\[25\] registers\[18\]\[25\] registers\[19\]\[25\]
+ _2027_ _2028_ VGND VGND VPWR VPWR _2086_ sky130_fd_sc_hd__mux4_1
XANTENNA__4800__S1 _1556_ VGND VGND VPWR VPWR sky130_fd_sc_hd__diode_2
X_8131_ _4005_ VGND VGND VPWR VPWR _0470_ sky130_fd_sc_hd__clkbuf_1
Xoutput102 net102 VGND VGND VPWR VPWR rd1[29] sky130_fd_sc_hd__buf_1
Xoutput135 net135 VGND VGND VPWR VPWR rd2[2] sky130_fd_sc_hd__buf_1
XANTENNA__4929__A _1689_ VGND VGND VPWR VPWR sky130_fd_sc_hd__diode_2
XANTENNA__7655__A0 _3131_ VGND VGND VPWR VPWR sky130_fd_sc_hd__diode_2
X_8062_ registers\[2\]\[29\] _3495_ _3959_ VGND VGND VPWR VPWR _3969_ sky130_fd_sc_hd__mux2_1
X_5274_ _1765_ VGND VGND VPWR VPWR _2021_ sky130_fd_sc_hd__clkbuf_4
X_4225_ _1024_ VGND VGND VPWR VPWR _1025_ sky130_fd_sc_hd__buf_4
X_7013_ _3396_ _3286_ VGND VGND VPWR VPWR _3397_ sky130_fd_sc_hd__nand2_2
XANTENNA__8080__A0 _2972_ VGND VGND VPWR VPWR sky130_fd_sc_hd__diode_2
X_8964_ clknet_leaf_28_clk _0061_ VGND VGND VPWR VPWR registers\[18\]\[4\] sky130_fd_sc_hd__dfxtp_1
X_7915_ _3891_ VGND VGND VPWR VPWR _0368_ sky130_fd_sc_hd__clkbuf_1
X_8895_ clknet_leaf_99_clk _1016_ VGND VGND VPWR VPWR registers\[15\]\[31\] sky130_fd_sc_hd__dfxtp_1
XFILLER_0_93_603 VGND VGND VPWR VPWR sky130_fd_sc_hd__fill_2
XTAP_TAPCELL_ROW_54_959 VGND VPWR sky130_fd_sc_hd__tapvpwrvgnd_1
X_7846_ _3117_ registers\[26\]\[23\] _3851_ VGND VGND VPWR VPWR _3855_ sky130_fd_sc_hd__mux2_1
XANTENNA__7975__A _3900_ VGND VGND VPWR VPWR sky130_fd_sc_hd__diode_2
XFILLER_0_78_699 VGND VGND VPWR VPWR sky130_fd_sc_hd__fill_1
XFILLER_0_77_187 VGND VGND VPWR VPWR sky130_fd_sc_hd__fill_2
XFILLER_0_77_176 VGND VGND VPWR VPWR sky130_fd_sc_hd__fill_2
XANTENNA__4619__S1 _1339_ VGND VGND VPWR VPWR sky130_fd_sc_hd__diode_2
XFILLER_0_108_418 VGND VGND VPWR VPWR sky130_fd_sc_hd__fill_2
X_4989_ registers\[24\]\[6\] registers\[25\]\[6\] registers\[26\]\[6\] registers\[27\]\[6\]
+ _1748_ _1749_ VGND VGND VPWR VPWR _1751_ sky130_fd_sc_hd__mux4_1
XFILLER_0_58_390 VGND VGND VPWR VPWR sky130_fd_sc_hd__fill_2
XANTENNA__5495__A net96 VGND VGND VPWR VPWR sky130_fd_sc_hd__diode_2
XANTENNA__7186__S _3503_ VGND VGND VPWR VPWR sky130_fd_sc_hd__diode_2
X_7777_ _3818_ VGND VGND VPWR VPWR _0303_ sky130_fd_sc_hd__clkbuf_1
X_9516_ clknet_leaf_43_clk _0613_ VGND VGND VPWR VPWR registers\[8\]\[12\] sky130_fd_sc_hd__dfxtp_1
X_6728_ _3244_ VGND VGND VPWR VPWR _0852_ sky130_fd_sc_hd__clkbuf_1
XANTENNA__5292__S1 _1811_ VGND VGND VPWR VPWR sky130_fd_sc_hd__diode_2
XFILLER_0_116_473 VGND VGND VPWR VPWR sky130_fd_sc_hd__decap_3
X_9447_ clknet_leaf_23_clk _0544_ VGND VGND VPWR VPWR registers\[31\]\[7\] sky130_fd_sc_hd__dfxtp_1
XFILLER_0_73_393 VGND VGND VPWR VPWR sky130_fd_sc_hd__decap_3
X_6659_ _3206_ VGND VGND VPWR VPWR _0821_ sky130_fd_sc_hd__clkbuf_1
XFILLER_0_33_213 VGND VGND VPWR VPWR sky130_fd_sc_hd__fill_1
X_9378_ clknet_leaf_5_clk _0475_ VGND VGND VPWR VPWR registers\[9\]\[2\] sky130_fd_sc_hd__dfxtp_1
XFILLER_0_21_419 VGND VGND VPWR VPWR sky130_fd_sc_hd__fill_1
XANTENNA__7914__S _3887_ VGND VGND VPWR VPWR sky130_fd_sc_hd__diode_2
X_8329_ _4110_ VGND VGND VPWR VPWR _0563_ sky130_fd_sc_hd__clkbuf_1
XTAP_TAPCELL_ROW_111_1708 VGND VPWR sky130_fd_sc_hd__tapvpwrvgnd_1
XTAP_TAPCELL_ROW_6_342 VGND VPWR sky130_fd_sc_hd__tapvpwrvgnd_1
XTAP_TAPCELL_ROW_6_331 VGND VPWR sky130_fd_sc_hd__tapvpwrvgnd_1
XTAP_TAPCELL_ROW_70_1173 VGND VPWR sky130_fd_sc_hd__tapvpwrvgnd_1
XFILLER_0_17_18 VGND VGND VPWR VPWR sky130_fd_sc_hd__fill_2
XFILLER_0_88_419 VGND VGND VPWR VPWR sky130_fd_sc_hd__fill_1
XANTENNA__6265__S _2962_ VGND VGND VPWR VPWR sky130_fd_sc_hd__diode_2
XFILLER_0_69_644 VGND VGND VPWR VPWR sky130_fd_sc_hd__fill_1
XANTENNA__4632__B1 _1143_ VGND VGND VPWR VPWR sky130_fd_sc_hd__diode_2
XFILLER_0_69_677 VGND VGND VPWR VPWR sky130_fd_sc_hd__fill_2
XFILLER_0_68_165 VGND VGND VPWR VPWR sky130_fd_sc_hd__fill_1
XFILLER_0_56_305 VGND VGND VPWR VPWR sky130_fd_sc_hd__decap_3
XANTENNA__8480__S _4189_ VGND VGND VPWR VPWR sky130_fd_sc_hd__diode_2
XFILLER_0_84_625 VGND VGND VPWR VPWR sky130_fd_sc_hd__decap_3
XFILLER_0_68_176 VGND VGND VPWR VPWR sky130_fd_sc_hd__fill_2
XANTENNA__7096__S _3435_ VGND VGND VPWR VPWR sky130_fd_sc_hd__diode_2
XFILLER_0_84_658 VGND VGND VPWR VPWR sky130_fd_sc_hd__decap_8
XANTENNA__4513__S _1148_ VGND VGND VPWR VPWR sky130_fd_sc_hd__diode_2
XANTENNA__5283__S1 _2028_ VGND VGND VPWR VPWR sky130_fd_sc_hd__diode_2
XFILLER_0_92_691 VGND VGND VPWR VPWR sky130_fd_sc_hd__fill_2
Xinput26 wd3[19] VGND VGND VPWR VPWR net26 sky130_fd_sc_hd__clkbuf_2
Xinput37 wd3[29] VGND VGND VPWR VPWR net37 sky130_fd_sc_hd__buf_2
Xinput15 alu_op[1] VGND VGND VPWR VPWR net15 sky130_fd_sc_hd__buf_4
XFILLER_0_109_7 VGND VGND VPWR VPWR sky130_fd_sc_hd__fill_2
Xinput48 we3 VGND VGND VPWR VPWR net48 sky130_fd_sc_hd__clkbuf_4
XFILLER_0_110_638 VGND VGND VPWR VPWR sky130_fd_sc_hd__fill_1
XANTENNA__5344__S _1768_ VGND VGND VPWR VPWR sky130_fd_sc_hd__diode_2
XANTENNA__4794__S0 _1550_ VGND VGND VPWR VPWR sky130_fd_sc_hd__diode_2
XFILLER_0_20_441 VGND VGND VPWR VPWR sky130_fd_sc_hd__decap_3
XANTENNA__4546__S0 _1160_ VGND VGND VPWR VPWR sky130_fd_sc_hd__diode_2
XTAP_TAPCELL_ROW_88_1401 VGND VPWR sky130_fd_sc_hd__tapvpwrvgnd_1
XFILLER_0_99_290 VGND VGND VPWR VPWR sky130_fd_sc_hd__fill_1
X_5961_ _1929_ _2681_ VGND VGND VPWR VPWR _2682_ sky130_fd_sc_hd__xnor2_1
XFILLER_0_87_474 VGND VGND VPWR VPWR sky130_fd_sc_hd__fill_2
X_4912_ _1616_ VGND VGND VPWR VPWR _1677_ sky130_fd_sc_hd__buf_8
X_8680_ clknet_leaf_15_clk _0801_ VGND VGND VPWR VPWR registers\[0\]\[8\] sky130_fd_sc_hd__dfxtp_1
X_7700_ _3777_ VGND VGND VPWR VPWR _0267_ sky130_fd_sc_hd__clkbuf_1
XANTENNA__8390__S _4139_ VGND VGND VPWR VPWR sky130_fd_sc_hd__diode_2
XFILLER_0_114_41 VGND VGND VPWR VPWR sky130_fd_sc_hd__fill_2
XANTENNA__8365__A1 _3458_ VGND VGND VPWR VPWR sky130_fd_sc_hd__diode_2
X_5892_ _2580_ _2616_ _2293_ VGND VGND VPWR VPWR _2617_ sky130_fd_sc_hd__mux2_1
XFILLER_0_90_78 VGND VGND VPWR VPWR sky130_fd_sc_hd__decap_3
XFILLER_0_74_113 VGND VGND VPWR VPWR sky130_fd_sc_hd__fill_1
XFILLER_0_59_187 VGND VGND VPWR VPWR sky130_fd_sc_hd__fill_2
X_7631_ _3740_ VGND VGND VPWR VPWR _0235_ sky130_fd_sc_hd__clkbuf_1
XTAP_TAPCELL_ROW_51_918 VGND VPWR sky130_fd_sc_hd__tapvpwrvgnd_1
XFILLER_0_114_85 VGND VGND VPWR VPWR sky130_fd_sc_hd__fill_2
XFILLER_0_90_89 VGND VGND VPWR VPWR sky130_fd_sc_hd__decap_4
X_4843_ registers\[0\]\[31\] registers\[1\]\[31\] registers\[2\]\[31\] registers\[3\]\[31\]
+ _1427_ _1428_ VGND VGND VPWR VPWR _1612_ sky130_fd_sc_hd__mux4_1
XANTENNA__4423__S _1025_ VGND VGND VPWR VPWR sky130_fd_sc_hd__diode_2
X_7562_ _3106_ registers\[22\]\[18\] _3695_ VGND VGND VPWR VPWR _3704_ sky130_fd_sc_hd__mux2_1
X_4774_ _1545_ _1546_ _1362_ VGND VGND VPWR VPWR _1547_ sky130_fd_sc_hd__mux2_1
X_7493_ _3667_ VGND VGND VPWR VPWR _0170_ sky130_fd_sc_hd__clkbuf_1
XTAP_TAPCELL_ROW_99_1552 VGND VPWR sky130_fd_sc_hd__tapvpwrvgnd_1
XTAP_TAPCELL_ROW_99_1541 VGND VPWR sky130_fd_sc_hd__tapvpwrvgnd_1
XFILLER_0_99_65 VGND VGND VPWR VPWR sky130_fd_sc_hd__fill_2
XFILLER_0_99_43 VGND VGND VPWR VPWR sky130_fd_sc_hd__decap_4
XFILLER_0_83_691 VPWR VGND VPWR VGND sky130_ef_sc_hd__decap_12
XFILLER_0_43_522 VGND VGND VPWR VPWR sky130_fd_sc_hd__decap_3
X_9301_ clknet_leaf_81_clk _0398_ VGND VGND VPWR VPWR registers\[28\]\[21\] sky130_fd_sc_hd__dfxtp_1
XFILLER_0_15_235 VGND VGND VPWR VPWR sky130_fd_sc_hd__fill_2
X_6513_ _3125_ registers\[29\]\[27\] _3111_ VGND VGND VPWR VPWR _3126_ sky130_fd_sc_hd__mux2_1
XTAP_TAPCELL_ROW_31_664 VGND VPWR sky130_fd_sc_hd__tapvpwrvgnd_1
X_6444_ net43 VGND VGND VPWR VPWR _3079_ sky130_fd_sc_hd__buf_2
XANTENNA__7876__A0 _3079_ VGND VGND VPWR VPWR sky130_fd_sc_hd__diode_2
XFILLER_0_70_363 VGND VGND VPWR VPWR sky130_fd_sc_hd__fill_1
X_9232_ clknet_leaf_61_clk _0329_ VGND VGND VPWR VPWR registers\[26\]\[16\] sky130_fd_sc_hd__dfxtp_1
Xclkbuf_leaf_9_clk clknet_4_1_0_clk VGND VGND VPWR VPWR clknet_leaf_9_clk sky130_fd_sc_hd__clkbuf_8
XANTENNA__7734__S _3793_ VGND VGND VPWR VPWR sky130_fd_sc_hd__diode_2
XANTENNA_clkbuf_4_3_0_clk_A clknet_0_clk VGND VGND VPWR VPWR sky130_fd_sc_hd__diode_2
XFILLER_0_3_652 VGND VGND VPWR VPWR sky130_fd_sc_hd__fill_2
XANTENNA__7628__A0 _3104_ VGND VGND VPWR VPWR sky130_fd_sc_hd__diode_2
X_9163_ clknet_leaf_59_clk _0260_ VGND VGND VPWR VPWR registers\[24\]\[11\] sky130_fd_sc_hd__dfxtp_1
XFILLER_0_101_638 VGND VGND VPWR VPWR sky130_fd_sc_hd__fill_2
XFILLER_0_101_627 VGND VGND VPWR VPWR sky130_fd_sc_hd__fill_2
XFILLER_0_61_3 VGND VGND VPWR VPWR sky130_fd_sc_hd__decap_3
X_6375_ registers\[3\]\[8\] _2978_ _3030_ VGND VGND VPWR VPWR _3039_ sky130_fd_sc_hd__mux2_1
XANTENNA__4785__S0 _1555_ VGND VGND VPWR VPWR sky130_fd_sc_hd__diode_2
X_9094_ clknet_leaf_34_clk _0191_ VGND VGND VPWR VPWR registers\[22\]\[6\] sky130_fd_sc_hd__dfxtp_1
X_5326_ _2068_ _2069_ _2031_ VGND VGND VPWR VPWR _2070_ sky130_fd_sc_hd__mux2_1
XFILLER_0_2_195 VGND VGND VPWR VPWR sky130_fd_sc_hd__fill_1
X_8114_ _3006_ registers\[30\]\[21\] _3995_ VGND VGND VPWR VPWR _3997_ sky130_fd_sc_hd__mux2_1
XFILLER_0_100_159 VGND VGND VPWR VPWR sky130_fd_sc_hd__decap_3
XANTENNA__4537__S0 _1320_ VGND VGND VPWR VPWR sky130_fd_sc_hd__diode_2
X_8045_ _3960_ VGND VGND VPWR VPWR _0429_ sky130_fd_sc_hd__clkbuf_1
X_5257_ registers\[0\]\[20\] registers\[1\]\[20\] registers\[2\]\[20\] registers\[3\]\[20\]
+ _1968_ _1969_ VGND VGND VPWR VPWR _2005_ sky130_fd_sc_hd__mux4_1
XTAP_TAPCELL_ROW_3_301 VGND VPWR sky130_fd_sc_hd__tapvpwrvgnd_1
XANTENNA__6851__A1 _3003_ VGND VGND VPWR VPWR sky130_fd_sc_hd__diode_2
X_5188_ registers\[0\]\[16\] registers\[1\]\[16\] registers\[2\]\[16\] registers\[3\]\[16\]
+ _1748_ _1749_ VGND VGND VPWR VPWR _1940_ sky130_fd_sc_hd__mux4_1
XFILLER_0_98_728 VGND VGND VPWR VPWR sky130_fd_sc_hd__fill_2
XFILLER_0_97_249 VGND VGND VPWR VPWR sky130_fd_sc_hd__fill_2
XFILLER_0_97_238 VGND VGND VPWR VPWR sky130_fd_sc_hd__decap_4
X_8947_ clknet_leaf_46_clk _0044_ VGND VGND VPWR VPWR registers\[17\]\[19\] sky130_fd_sc_hd__dfxtp_1
XTAP_TAPCELL_ROW_39_764 VGND VPWR sky130_fd_sc_hd__tapvpwrvgnd_1
XANTENNA__7800__A0 _3071_ VGND VGND VPWR VPWR sky130_fd_sc_hd__diode_2
XFILLER_0_3_93 VPWR VGND VPWR VGND sky130_ef_sc_hd__decap_12
XFILLER_0_78_463 VGND VGND VPWR VPWR sky130_fd_sc_hd__fill_2
XANTENNA__6813__S _3288_ VGND VGND VPWR VPWR sky130_fd_sc_hd__diode_2
XANTENNA__8356__A1 _3449_ VGND VGND VPWR VPWR sky130_fd_sc_hd__diode_2
X_8878_ clknet_leaf_53_clk _0999_ VGND VGND VPWR VPWR registers\[15\]\[14\] sky130_fd_sc_hd__dfxtp_1
XFILLER_0_65_113 VGND VGND VPWR VPWR sky130_fd_sc_hd__fill_1
X_7829_ _3100_ registers\[26\]\[15\] _3840_ VGND VGND VPWR VPWR _3846_ sky130_fd_sc_hd__mux2_1
XFILLER_0_81_617 VGND VGND VPWR VPWR sky130_fd_sc_hd__fill_2
XANTENNA__5265__S1 _1969_ VGND VGND VPWR VPWR sky130_fd_sc_hd__diode_2
XFILLER_0_74_691 VGND VGND VPWR VPWR sky130_fd_sc_hd__fill_1
XTAP_TAPCELL_ROW_59_1024 VGND VPWR sky130_fd_sc_hd__tapvpwrvgnd_1
XFILLER_0_14_290 VGND VGND VPWR VPWR sky130_fd_sc_hd__decap_4
XFILLER_0_119_19 VGND VGND VPWR VPWR sky130_fd_sc_hd__decap_8
XANTENNA_input45_A wd3[7] VGND VGND VPWR VPWR sky130_fd_sc_hd__diode_2
XFILLER_0_100_660 VGND VGND VPWR VPWR sky130_fd_sc_hd__fill_2
XANTENNA__8292__A0 _2980_ VGND VGND VPWR VPWR sky130_fd_sc_hd__diode_2
XANTENNA__7819__S _3840_ VGND VGND VPWR VPWR sky130_fd_sc_hd__diode_2
XFILLER_0_69_441 VGND VGND VPWR VPWR sky130_fd_sc_hd__fill_2
XANTENNA__6723__S _3236_ VGND VGND VPWR VPWR sky130_fd_sc_hd__diode_2
XFILLER_0_84_411 VGND VGND VPWR VPWR sky130_fd_sc_hd__fill_2
XTAP_TAPCELL_ROW_83_1342 VGND VPWR sky130_fd_sc_hd__tapvpwrvgnd_1
XANTENNA__4700__S0 _1347_ VGND VGND VPWR VPWR sky130_fd_sc_hd__diode_2
XANTENNA__4724__A1_N _1438_ VGND VGND VPWR VPWR sky130_fd_sc_hd__diode_2
XFILLER_0_84_466 VGND VGND VPWR VPWR sky130_fd_sc_hd__fill_2
XFILLER_0_60_48 VGND VGND VPWR VPWR sky130_fd_sc_hd__fill_2
XFILLER_0_56_179 VGND VGND VPWR VPWR sky130_fd_sc_hd__fill_2
XFILLER_0_44_319 VGND VGND VPWR VPWR sky130_fd_sc_hd__fill_2
XFILLER_0_37_393 VGND VGND VPWR VPWR sky130_fd_sc_hd__decap_3
XANTENNA__7554__S _3695_ VGND VGND VPWR VPWR sky130_fd_sc_hd__diode_2
XFILLER_0_107_281 VGND VGND VPWR VPWR sky130_fd_sc_hd__decap_4
XFILLER_0_40_503 VGND VGND VPWR VPWR sky130_fd_sc_hd__fill_2
XFILLER_0_100_21 VGND VGND VPWR VPWR sky130_fd_sc_hd__fill_2
X_4490_ registers\[4\]\[12\] registers\[5\]\[12\] registers\[6\]\[12\] registers\[7\]\[12\]
+ _1201_ _1204_ VGND VGND VPWR VPWR _1278_ sky130_fd_sc_hd__mux4_1
XFILLER_0_69_57 VGND VGND VPWR VPWR sky130_fd_sc_hd__decap_4
XFILLER_0_40_525 VGND VGND VPWR VPWR sky130_fd_sc_hd__fill_2
XFILLER_0_100_54 VGND VGND VPWR VPWR sky130_fd_sc_hd__decap_3
XANTENNA__5074__S _1689_ VGND VGND VPWR VPWR sky130_fd_sc_hd__diode_2
XTAP_TAPCELL_ROW_94_1482 VGND VPWR sky130_fd_sc_hd__tapvpwrvgnd_1
X_6160_ _2869_ _2587_ _2608_ _2766_ _2420_ VGND VGND VPWR VPWR _2870_ sky130_fd_sc_hd__o221a_1
XFILLER_0_0_633 VGND VGND VPWR VPWR sky130_fd_sc_hd__fill_2
XFILLER_0_0_655 VGND VGND VPWR VPWR sky130_fd_sc_hd__fill_2
X_5111_ registers\[20\]\[12\] registers\[21\]\[12\] registers\[22\]\[12\] registers\[23\]\[12\]
+ _1798_ _1799_ VGND VGND VPWR VPWR _1867_ sky130_fd_sc_hd__mux4_1
XFILLER_0_20_282 VGND VGND VPWR VPWR sky130_fd_sc_hd__fill_1
X_6091_ net95 _2804_ VGND VGND VPWR VPWR _2805_ sky130_fd_sc_hd__xnor2_1
X_5042_ registers\[28\]\[8\] registers\[29\]\[8\] registers\[30\]\[8\] registers\[31\]\[8\]
+ _1798_ _1799_ VGND VGND VPWR VPWR _1802_ sky130_fd_sc_hd__mux4_1
XFILLER_0_79_205 VGND VGND VPWR VPWR sky130_fd_sc_hd__fill_1
X_8801_ clknet_leaf_8_clk _0922_ VGND VGND VPWR VPWR registers\[13\]\[1\] sky130_fd_sc_hd__dfxtp_1
XFILLER_0_95_709 VGND VGND VPWR VPWR sky130_fd_sc_hd__decap_4
X_6993_ _3386_ VGND VGND VPWR VPWR _0975_ sky130_fd_sc_hd__clkbuf_1
XTAP_TAPCELL_ROW_36_723 VGND VPWR sky130_fd_sc_hd__tapvpwrvgnd_1
X_5944_ _2662_ _2665_ VGND VGND VPWR VPWR _2666_ sky130_fd_sc_hd__xnor2_2
XANTENNA__6633__S _3186_ VGND VGND VPWR VPWR sky130_fd_sc_hd__diode_2
XFILLER_0_47_113 VGND VGND VPWR VPWR sky130_fd_sc_hd__decap_3
X_8732_ clknet_leaf_105_clk _0853_ VGND VGND VPWR VPWR registers\[10\]\[28\] sky130_fd_sc_hd__dfxtp_1
XANTENNA__4942__A _1643_ VGND VGND VPWR VPWR sky130_fd_sc_hd__diode_2
X_5875_ _2599_ _2592_ _2593_ VGND VGND VPWR VPWR _2601_ sky130_fd_sc_hd__nor3_1
XFILLER_0_47_135 VGND VGND VPWR VPWR sky130_fd_sc_hd__decap_4
X_8663_ clknet_leaf_69_clk _0784_ VGND VGND VPWR VPWR registers\[7\]\[23\] sky130_fd_sc_hd__dfxtp_1
X_7614_ _3089_ registers\[23\]\[10\] _3731_ VGND VGND VPWR VPWR _3732_ sky130_fd_sc_hd__mux2_1
XFILLER_0_63_617 VGND VGND VPWR VPWR sky130_fd_sc_hd__fill_2
X_8594_ clknet_leaf_66_clk _0715_ VGND VGND VPWR VPWR registers\[3\]\[18\] sky130_fd_sc_hd__dfxtp_1
X_4826_ _1389_ _1595_ VGND VGND VPWR VPWR _1596_ sky130_fd_sc_hd__or2_1
XFILLER_0_47_157 VGND VGND VPWR VPWR sky130_fd_sc_hd__fill_2
XFILLER_0_28_360 VGND VGND VPWR VPWR sky130_fd_sc_hd__fill_1
XFILLER_0_105_207 VGND VGND VPWR VPWR sky130_fd_sc_hd__decap_8
XFILLER_0_90_425 VGND VGND VPWR VPWR sky130_fd_sc_hd__fill_2
X_7545_ _3683_ VGND VGND VPWR VPWR _3695_ sky130_fd_sc_hd__clkbuf_8
XFILLER_0_28_382 VGND VGND VPWR VPWR sky130_fd_sc_hd__decap_3
XFILLER_0_28_393 VPWR VGND VPWR VGND sky130_ef_sc_hd__decap_12
XFILLER_0_50_81 VGND VGND VPWR VPWR sky130_fd_sc_hd__decap_3
XFILLER_0_43_341 VGND VGND VPWR VPWR sky130_fd_sc_hd__fill_2
XFILLER_0_7_298 VGND VGND VPWR VPWR sky130_fd_sc_hd__decap_3
X_4757_ _1124_ _1530_ VGND VGND VPWR VPWR _1531_ sky130_fd_sc_hd__or2_1
X_4688_ _1464_ _1465_ _1362_ VGND VGND VPWR VPWR _1466_ sky130_fd_sc_hd__mux2_1
X_7476_ _3658_ VGND VGND VPWR VPWR _0162_ sky130_fd_sc_hd__clkbuf_1
XFILLER_0_101_402 VGND VGND VPWR VPWR sky130_fd_sc_hd__fill_2
XFILLER_0_70_193 VGND VGND VPWR VPWR sky130_fd_sc_hd__decap_3
X_9215_ clknet_leaf_107_clk _0312_ VGND VGND VPWR VPWR registers\[25\]\[31\] sky130_fd_sc_hd__dfxtp_1
X_6427_ net10 net9 net48 VGND VGND VPWR VPWR _3067_ sky130_fd_sc_hd__and3b_4
X_6358_ _3029_ VGND VGND VPWR VPWR _3030_ sky130_fd_sc_hd__clkbuf_8
X_9146_ clknet_leaf_78_clk _0243_ VGND VGND VPWR VPWR registers\[23\]\[26\] sky130_fd_sc_hd__dfxtp_1
X_5309_ _2052_ _2053_ _1695_ VGND VGND VPWR VPWR _2054_ sky130_fd_sc_hd__mux2_1
XANTENNA__8274__A0 _2958_ VGND VGND VPWR VPWR sky130_fd_sc_hd__diode_2
XANTENNA__8295__S _4092_ VGND VGND VPWR VPWR sky130_fd_sc_hd__diode_2
X_6289_ _2961_ VGND VGND VPWR VPWR _2983_ sky130_fd_sc_hd__clkbuf_8
X_9077_ clknet_leaf_78_clk _0174_ VGND VGND VPWR VPWR registers\[21\]\[21\] sky130_fd_sc_hd__dfxtp_1
X_8028_ _3951_ VGND VGND VPWR VPWR _0421_ sky130_fd_sc_hd__clkbuf_1
XANTENNA__5183__S0 _1742_ VGND VGND VPWR VPWR sky130_fd_sc_hd__diode_2
XANTENNA__6109__A _2048_ VGND VGND VPWR VPWR sky130_fd_sc_hd__diode_2
XFILLER_0_98_525 VGND VGND VPWR VPWR sky130_fd_sc_hd__fill_2
XANTENNA__5013__A _1774_ VGND VGND VPWR VPWR sky130_fd_sc_hd__diode_2
XFILLER_0_86_709 VGND VGND VPWR VPWR sky130_fd_sc_hd__decap_4
XFILLER_0_39_603 VGND VGND VPWR VPWR sky130_fd_sc_hd__fill_2
XANTENNA__7639__S _3742_ VGND VGND VPWR VPWR sky130_fd_sc_hd__diode_2
XFILLER_0_93_230 VPWR VGND VPWR VGND sky130_ef_sc_hd__decap_12
XFILLER_0_38_146 VGND VGND VPWR VPWR sky130_fd_sc_hd__decap_3
XFILLER_0_93_252 VGND VGND VPWR VPWR sky130_fd_sc_hd__decap_6
XANTENNA__5238__S1 _1774_ VGND VGND VPWR VPWR sky130_fd_sc_hd__diode_2
XFILLER_0_54_628 VGND VGND VPWR VPWR sky130_fd_sc_hd__decap_3
XTAP_TAPCELL_ROW_14_439 VGND VPWR sky130_fd_sc_hd__tapvpwrvgnd_1
XFILLER_0_30_29 VGND VGND VPWR VPWR sky130_fd_sc_hd__fill_2
XANTENNA__5683__A _2267_ VGND VGND VPWR VPWR sky130_fd_sc_hd__diode_2
XANTENNA__7374__S _3597_ VGND VGND VPWR VPWR sky130_fd_sc_hd__diode_2
XANTENNA__8501__A1 net18 VGND VGND VPWR VPWR sky130_fd_sc_hd__diode_2
XFILLER_0_62_683 VGND VGND VPWR VPWR sky130_fd_sc_hd__fill_2
XFILLER_0_89_558 VGND VGND VPWR VPWR sky130_fd_sc_hd__fill_2
XANTENNA__7240__A1 _3491_ VGND VGND VPWR VPWR sky130_fd_sc_hd__diode_2
XFILLER_0_29_113 VGND VGND VPWR VPWR sky130_fd_sc_hd__decap_3
XFILLER_0_84_241 VGND VGND VPWR VPWR sky130_fd_sc_hd__decap_8
XFILLER_0_72_414 VGND VGND VPWR VPWR sky130_fd_sc_hd__fill_2
X_5660_ _1438_ _1033_ _1038_ _1048_ _2394_ VGND VGND VPWR VPWR _2395_ sky130_fd_sc_hd__a311o_2
X_4611_ registers\[0\]\[18\] registers\[1\]\[18\] registers\[2\]\[18\] registers\[3\]\[18\]
+ _1390_ _1391_ VGND VGND VPWR VPWR _1393_ sky130_fd_sc_hd__mux4_1
XFILLER_0_38_680 VGND VGND VPWR VPWR sky130_fd_sc_hd__fill_2
XANTENNA__4988__S0 _1748_ VGND VGND VPWR VPWR sky130_fd_sc_hd__diode_2
XTAP_TAPCELL_ROW_96_1511 VGND VPWR sky130_fd_sc_hd__tapvpwrvgnd_1
X_5591_ _2253_ _2314_ VGND VGND VPWR VPWR _2326_ sky130_fd_sc_hd__nand2_1
XFILLER_0_72_469 VGND VGND VPWR VPWR sky130_fd_sc_hd__fill_2
XANTENNA__5593__A net15 VGND VGND VPWR VPWR sky130_fd_sc_hd__diode_2
XFILLER_0_53_650 VGND VGND VPWR VPWR sky130_fd_sc_hd__fill_1
XTAP_TAPCELL_ROW_41_792 VGND VPWR sky130_fd_sc_hd__tapvpwrvgnd_1
XFILLER_0_111_53 VGND VGND VPWR VPWR sky130_fd_sc_hd__decap_3
X_7330_ registers\[1\]\[5\] _3445_ _3575_ VGND VGND VPWR VPWR _3581_ sky130_fd_sc_hd__mux2_1
X_4542_ registers\[20\]\[15\] registers\[21\]\[15\] registers\[22\]\[15\] registers\[23\]\[15\]
+ _1320_ _1321_ VGND VGND VPWR VPWR _1327_ sky130_fd_sc_hd__mux4_1
XANTENNA__4701__S _1362_ VGND VGND VPWR VPWR sky130_fd_sc_hd__diode_2
XFILLER_0_13_514 VGND VGND VPWR VPWR sky130_fd_sc_hd__fill_1
XFILLER_0_25_363 VGND VGND VPWR VPWR sky130_fd_sc_hd__decap_3
X_4473_ registers\[8\]\[11\] registers\[9\]\[11\] registers\[10\]\[11\] registers\[11\]\[11\]
+ _1125_ _1203_ VGND VGND VPWR VPWR _1262_ sky130_fd_sc_hd__mux4_1
X_7261_ _3544_ VGND VGND VPWR VPWR _0061_ sky130_fd_sc_hd__clkbuf_1
XFILLER_0_96_44 VGND VGND VPWR VPWR sky130_fd_sc_hd__fill_2
X_9000_ clknet_leaf_16_clk _0097_ VGND VGND VPWR VPWR registers\[1\]\[8\] sky130_fd_sc_hd__dfxtp_1
X_6212_ _2917_ _2918_ VGND VGND VPWR VPWR _2919_ sky130_fd_sc_hd__and2b_1
XANTENNA__5401__S1 _2109_ VGND VGND VPWR VPWR sky130_fd_sc_hd__diode_2
XPHY_EDGE_ROW_115_Right_115 VGND VGND VPWR VPWR sky130_fd_sc_hd__decap_3
X_7192_ registers\[17\]\[4\] _3443_ _3503_ VGND VGND VPWR VPWR _3508_ sky130_fd_sc_hd__mux2_1
XFILLER_0_96_77 VGND VGND VPWR VPWR sky130_fd_sc_hd__fill_1
X_6143_ _2327_ _2579_ _2583_ VGND VGND VPWR VPWR _2854_ sky130_fd_sc_hd__a21oi_1
XANTENNA__4937__A net5 VGND VGND VPWR VPWR sky130_fd_sc_hd__diode_2
XFILLER_0_0_496 VGND VGND VPWR VPWR sky130_fd_sc_hd__fill_2
XFILLER_0_0_485 VGND VGND VPWR VPWR sky130_fd_sc_hd__fill_2
X_6074_ _2445_ _2695_ VGND VGND VPWR VPWR _2789_ sky130_fd_sc_hd__nand2_1
XANTENNA__5165__S0 _1806_ VGND VGND VPWR VPWR sky130_fd_sc_hd__diode_2
X_5025_ _1784_ _1785_ _1627_ VGND VGND VPWR VPWR _1786_ sky130_fd_sc_hd__mux2_1
XFILLER_0_24_3 VGND VGND VPWR VPWR sky130_fd_sc_hd__fill_2
XTAP_TAPCELL_ROW_49_892 VGND VPWR sky130_fd_sc_hd__tapvpwrvgnd_1
XANTENNA__7459__S _3648_ VGND VGND VPWR VPWR sky130_fd_sc_hd__diode_2
X_6976_ _3377_ VGND VGND VPWR VPWR _0967_ sky130_fd_sc_hd__clkbuf_1
XFILLER_0_95_528 VGND VGND VPWR VPWR sky130_fd_sc_hd__fill_2
XFILLER_0_67_219 VGND VGND VPWR VPWR sky130_fd_sc_hd__fill_2
XFILLER_0_48_411 VGND VGND VPWR VPWR sky130_fd_sc_hd__fill_1
XANTENNA__6363__S _3030_ VGND VGND VPWR VPWR sky130_fd_sc_hd__diode_2
X_8715_ clknet_leaf_52_clk _0836_ VGND VGND VPWR VPWR registers\[10\]\[11\] sky130_fd_sc_hd__dfxtp_1
X_5927_ _2497_ VGND VGND VPWR VPWR _2650_ sky130_fd_sc_hd__inv_2
XFILLER_0_48_488 VGND VGND VPWR VPWR sky130_fd_sc_hd__fill_2
XFILLER_0_48_477 VGND VGND VPWR VPWR sky130_fd_sc_hd__fill_2
XFILLER_0_48_455 VGND VGND VPWR VPWR sky130_fd_sc_hd__fill_2
X_8646_ clknet_leaf_36_clk _0767_ VGND VGND VPWR VPWR registers\[7\]\[6\] sky130_fd_sc_hd__dfxtp_1
XFILLER_0_90_222 VGND VGND VPWR VPWR sky130_fd_sc_hd__fill_2
X_5858_ _2567_ VGND VGND VPWR VPWR _2585_ sky130_fd_sc_hd__inv_2
XFILLER_0_61_80 VGND VGND VPWR VPWR sky130_fd_sc_hd__fill_2
XFILLER_0_8_541 VPWR VGND VPWR VGND sky130_ef_sc_hd__decap_12
XFILLER_0_29_680 VGND VGND VPWR VPWR sky130_fd_sc_hd__fill_2
XANTENNA__7194__S _3503_ VGND VGND VPWR VPWR sky130_fd_sc_hd__diode_2
XANTENNA__5545__A1 _1882_ VGND VGND VPWR VPWR sky130_fd_sc_hd__diode_2
XFILLER_0_90_266 VGND VGND VPWR VPWR sky130_fd_sc_hd__fill_2
X_5789_ _1780_ _2517_ VGND VGND VPWR VPWR _2519_ sky130_fd_sc_hd__nor2_1
X_8577_ clknet_leaf_6_clk _0698_ VGND VGND VPWR VPWR registers\[3\]\[1\] sky130_fd_sc_hd__dfxtp_1
XANTENNA__6599__A _3174_ VGND VGND VPWR VPWR sky130_fd_sc_hd__diode_2
X_4809_ _1381_ _1579_ VGND VGND VPWR VPWR _1580_ sky130_fd_sc_hd__nor2_1
XFILLER_0_16_341 VGND VGND VPWR VPWR sky130_fd_sc_hd__fill_2
XPHY_EDGE_ROW_17_Right_17 VGND VGND VPWR VPWR sky130_fd_sc_hd__decap_3
XFILLER_0_44_694 VGND VGND VPWR VPWR sky130_fd_sc_hd__decap_6
X_7528_ _3686_ VGND VGND VPWR VPWR _0186_ sky130_fd_sc_hd__clkbuf_1
X_7459_ _3071_ registers\[21\]\[1\] _3648_ VGND VGND VPWR VPWR _3650_ sky130_fd_sc_hd__mux2_1
XFILLER_0_114_582 VGND VGND VPWR VPWR sky130_fd_sc_hd__decap_3
XANTENNA__5008__A _1756_ VGND VGND VPWR VPWR sky130_fd_sc_hd__diode_2
XANTENNA__7922__S _3887_ VGND VGND VPWR VPWR sky130_fd_sc_hd__diode_2
XANTENNA__6538__S _3137_ VGND VGND VPWR VPWR sky130_fd_sc_hd__diode_2
X_9129_ clknet_leaf_7_clk _0226_ VGND VGND VPWR VPWR registers\[23\]\[9\] sky130_fd_sc_hd__dfxtp_1
XANTENNA__5442__S _1856_ VGND VGND VPWR VPWR sky130_fd_sc_hd__diode_2
XANTENNA__4847__A _1615_ VGND VGND VPWR VPWR sky130_fd_sc_hd__diode_2
XANTENNA__5156__S0 _1883_ VGND VGND VPWR VPWR sky130_fd_sc_hd__diode_2
XPHY_EDGE_ROW_26_Right_26 VGND VGND VPWR VPWR sky130_fd_sc_hd__decap_3
XTAP_TAPCELL_ROW_19_509 VGND VPWR sky130_fd_sc_hd__tapvpwrvgnd_1
XTAP_TAPCELL_ROW_67_1134 VGND VPWR sky130_fd_sc_hd__tapvpwrvgnd_1
XFILLER_0_98_399 VGND VGND VPWR VPWR sky130_fd_sc_hd__decap_3
XFILLER_0_86_539 VGND VGND VPWR VPWR sky130_fd_sc_hd__decap_3
XANTENNA__4582__A _1148_ VGND VGND VPWR VPWR sky130_fd_sc_hd__diode_2
XANTENNA__6981__A0 _3104_ VGND VGND VPWR VPWR sky130_fd_sc_hd__diode_2
XTAP_TAPCELL_ROW_80_1301 VGND VPWR sky130_fd_sc_hd__tapvpwrvgnd_1
XFILLER_0_39_444 VGND VGND VPWR VPWR sky130_fd_sc_hd__fill_2
XFILLER_0_82_701 VGND VGND VPWR VPWR sky130_fd_sc_hd__fill_2
XANTENNA_clkbuf_4_11_0_clk_A clknet_0_clk VGND VGND VPWR VPWR sky130_fd_sc_hd__diode_2
XFILLER_0_26_138 VGND VGND VPWR VPWR sky130_fd_sc_hd__fill_2
XPHY_EDGE_ROW_35_Right_35 VGND VGND VPWR VPWR sky130_fd_sc_hd__decap_3
XTAP_TAPCELL_ROW_119_1809 VGND VPWR sky130_fd_sc_hd__tapvpwrvgnd_1
XFILLER_0_34_160 VGND VGND VPWR VPWR sky130_fd_sc_hd__fill_2
XFILLER_0_112_519 VGND VGND VPWR VPWR sky130_fd_sc_hd__fill_2
XANTENNA__7289__A1 _3472_ VGND VGND VPWR VPWR sky130_fd_sc_hd__diode_2
XFILLER_0_50_653 VPWR VGND VPWR VGND sky130_ef_sc_hd__decap_12
XFILLER_0_105_582 VGND VGND VPWR VPWR sky130_fd_sc_hd__fill_1
XTAP_TAPCELL_ROW_78_1274 VGND VPWR sky130_fd_sc_hd__tapvpwrvgnd_1
XFILLER_0_10_517 VGND VGND VPWR VPWR sky130_fd_sc_hd__fill_2
XTAP_TAPCELL_ROW_91_1441 VGND VPWR sky130_fd_sc_hd__tapvpwrvgnd_1
XANTENNA__6448__S _3069_ VGND VGND VPWR VPWR sky130_fd_sc_hd__diode_2
XPHY_EDGE_ROW_44_Right_44 VGND VGND VPWR VPWR sky130_fd_sc_hd__decap_3
XANTENNA__4757__A _1124_ VGND VGND VPWR VPWR sky130_fd_sc_hd__diode_2
XANTENNA__5147__S0 _1810_ VGND VGND VPWR VPWR sky130_fd_sc_hd__diode_2
XANTENNA__6249__C1 _2270_ VGND VGND VPWR VPWR sky130_fd_sc_hd__diode_2
XFILLER_0_66_47 VGND VGND VPWR VPWR sky130_fd_sc_hd__fill_1
XFILLER_0_89_300 VGND VGND VPWR VPWR sky130_fd_sc_hd__fill_2
XPHY_EDGE_ROW_19_Left_139 VGND VGND VPWR VPWR sky130_fd_sc_hd__decap_3
XANTENNA__7279__S _3550_ VGND VGND VPWR VPWR sky130_fd_sc_hd__diode_2
X_6830_ registers\[12\]\[10\] _2982_ _3299_ VGND VGND VPWR VPWR _3300_ sky130_fd_sc_hd__mux2_1
XANTENNA__5588__A net81 VGND VGND VPWR VPWR sky130_fd_sc_hd__diode_2
XTAP_TAPCELL_ROW_46_851 VGND VPWR sky130_fd_sc_hd__tapvpwrvgnd_1
X_6761_ _3262_ VGND VGND VPWR VPWR _0867_ sky130_fd_sc_hd__clkbuf_1
XTAP_TAPCELL_ROW_46_862 VGND VPWR sky130_fd_sc_hd__tapvpwrvgnd_1
X_8500_ _4201_ VGND VGND VPWR VPWR _0643_ sky130_fd_sc_hd__clkbuf_1
X_5712_ _1106_ VGND VGND VPWR VPWR _2445_ sky130_fd_sc_hd__clkbuf_4
XFILLER_0_85_561 VPWR VGND VPWR VGND sky130_ef_sc_hd__decap_12
XFILLER_0_57_252 VGND VGND VPWR VPWR sky130_fd_sc_hd__decap_4
XPHY_EDGE_ROW_53_Right_53 VGND VGND VPWR VPWR sky130_fd_sc_hd__decap_3
X_6692_ registers\[10\]\[10\] _2982_ _3225_ VGND VGND VPWR VPWR _3226_ sky130_fd_sc_hd__mux2_1
X_9480_ clknet_leaf_43_clk _0577_ VGND VGND VPWR VPWR registers\[5\]\[8\] sky130_fd_sc_hd__dfxtp_1
XFILLER_0_72_222 VGND VGND VPWR VPWR sky130_fd_sc_hd__fill_2
XFILLER_0_72_211 VGND VGND VPWR VPWR sky130_fd_sc_hd__decap_4
X_8431_ registers\[8\]\[10\] net17 _4164_ VGND VGND VPWR VPWR _4165_ sky130_fd_sc_hd__mux2_1
X_5643_ _2266_ _2375_ _2377_ VGND VGND VPWR VPWR _2378_ sky130_fd_sc_hd__o21ai_1
X_5574_ _1676_ _2214_ VGND VGND VPWR VPWR _2310_ sky130_fd_sc_hd__nor2_1
XFILLER_0_72_266 VGND VGND VPWR VPWR sky130_fd_sc_hd__fill_2
X_8362_ _4116_ VGND VGND VPWR VPWR _4128_ sky130_fd_sc_hd__buf_4
XPHY_EDGE_ROW_28_Left_148 VGND VGND VPWR VPWR sky130_fd_sc_hd__decap_3
XFILLER_0_31_72 VGND VGND VPWR VPWR sky130_fd_sc_hd__decap_4
X_4525_ registers\[4\]\[14\] registers\[5\]\[14\] registers\[6\]\[14\] registers\[7\]\[14\]
+ _1126_ _1128_ VGND VGND VPWR VPWR _1311_ sky130_fd_sc_hd__mux4_1
X_7313_ _3571_ VGND VGND VPWR VPWR _0086_ sky130_fd_sc_hd__clkbuf_1
XANTENNA__7742__S _3793_ VGND VGND VPWR VPWR sky130_fd_sc_hd__diode_2
X_8293_ _4091_ VGND VGND VPWR VPWR _0546_ sky130_fd_sc_hd__clkbuf_1
XFILLER_0_40_141 VGND VGND VPWR VPWR sky130_fd_sc_hd__decap_3
XFILLER_0_111_541 VGND VGND VPWR VPWR sky130_fd_sc_hd__fill_1
X_4456_ registers\[12\]\[10\] registers\[13\]\[10\] registers\[14\]\[10\] registers\[15\]\[10\]
+ _1197_ _1203_ VGND VGND VPWR VPWR _1246_ sky130_fd_sc_hd__mux4_1
XPHY_EDGE_ROW_62_Right_62 VGND VGND VPWR VPWR sky130_fd_sc_hd__decap_3
X_7244_ registers\[17\]\[29\] _3495_ _3525_ VGND VGND VPWR VPWR _3535_ sky130_fd_sc_hd__mux2_1
X_4387_ registers\[0\]\[6\] registers\[1\]\[6\] registers\[2\]\[6\] registers\[3\]\[6\]
+ _1136_ _1137_ VGND VGND VPWR VPWR _1181_ sky130_fd_sc_hd__mux4_1
X_7175_ net39 VGND VGND VPWR VPWR _3497_ sky130_fd_sc_hd__buf_2
X_6126_ _2829_ _2837_ VGND VGND VPWR VPWR _2838_ sky130_fd_sc_hd__nor2_1
XPHY_EDGE_ROW_0_Left_120 VGND VGND VPWR VPWR sky130_fd_sc_hd__decap_3
XFILLER_0_99_108 VGND VGND VPWR VPWR sky130_fd_sc_hd__fill_2
XPHY_EDGE_ROW_37_Left_157 VGND VGND VPWR VPWR sky130_fd_sc_hd__decap_3
X_6057_ _2741_ _2752_ VGND VGND VPWR VPWR _2773_ sky130_fd_sc_hd__or2b_1
XANTENNA__4266__A1 net6 VGND VGND VPWR VPWR sky130_fd_sc_hd__diode_2
XANTENNA__4361__S1 _1128_ VGND VGND VPWR VPWR sky130_fd_sc_hd__diode_2
X_5008_ _1756_ _1769_ VGND VGND VPWR VPWR _1770_ sky130_fd_sc_hd__nand2_1
XANTENNA__5498__A _2213_ VGND VGND VPWR VPWR sky130_fd_sc_hd__diode_2
XANTENNA_clkbuf_leaf_72_clk_A clknet_4_14_0_clk VGND VGND VPWR VPWR sky130_fd_sc_hd__diode_2
XPHY_EDGE_ROW_71_Right_71 VGND VGND VPWR VPWR sky130_fd_sc_hd__decap_3
X_6959_ _3368_ VGND VGND VPWR VPWR _0959_ sky130_fd_sc_hd__clkbuf_1
XANTENNA__5766__A1 _2344_ VGND VGND VPWR VPWR sky130_fd_sc_hd__diode_2
XFILLER_0_64_701 VGND VGND VPWR VPWR sky130_fd_sc_hd__decap_3
XFILLER_0_119_641 VGND VGND VPWR VPWR sky130_fd_sc_hd__decap_3
XANTENNA__6821__S _3288_ VGND VGND VPWR VPWR sky130_fd_sc_hd__diode_2
XTAP_TAPCELL_ROW_62_1064 VGND VPWR sky130_fd_sc_hd__tapvpwrvgnd_1
XPHY_EDGE_ROW_46_Left_166 VGND VGND VPWR VPWR sky130_fd_sc_hd__decap_3
XANTENNA_clkbuf_leaf_87_clk_A clknet_4_8_0_clk VGND VGND VPWR VPWR sky130_fd_sc_hd__diode_2
XTAP_TAPCELL_ROW_24_567 VGND VPWR sky130_fd_sc_hd__tapvpwrvgnd_1
XFILLER_0_36_425 VGND VGND VPWR VPWR sky130_fd_sc_hd__fill_2
XFILLER_0_119_685 VPWR VGND VPWR VGND sky130_ef_sc_hd__decap_12
XFILLER_0_91_564 VGND VGND VPWR VPWR sky130_fd_sc_hd__fill_2
X_8629_ clknet_leaf_81_clk _0750_ VGND VGND VPWR VPWR registers\[29\]\[21\] sky130_fd_sc_hd__dfxtp_1
XFILLER_0_106_335 VGND VGND VPWR VPWR sky130_fd_sc_hd__decap_8
XFILLER_0_32_642 VGND VGND VPWR VPWR sky130_fd_sc_hd__fill_2
XANTENNA_clkbuf_leaf_10_clk_A clknet_4_3_0_clk VGND VGND VPWR VPWR sky130_fd_sc_hd__diode_2
XFILLER_0_114_390 VGND VGND VPWR VPWR sky130_fd_sc_hd__fill_2
XFILLER_0_102_530 VGND VGND VPWR VPWR sky130_fd_sc_hd__fill_2
XPHY_EDGE_ROW_80_Right_80 VGND VGND VPWR VPWR sky130_fd_sc_hd__decap_3
XANTENNA__5961__A _1929_ VGND VGND VPWR VPWR sky130_fd_sc_hd__diode_2
XTAP_TAPCELL_ROW_114_1739 VGND VPWR sky130_fd_sc_hd__tapvpwrvgnd_1
XANTENNA__6268__S _2962_ VGND VGND VPWR VPWR sky130_fd_sc_hd__diode_2
XANTENNA__5129__S0 _1883_ VGND VGND VPWR VPWR sky130_fd_sc_hd__diode_2
XANTENNA_clkbuf_leaf_25_clk_A clknet_4_4_0_clk VGND VGND VPWR VPWR sky130_fd_sc_hd__diode_2
XPHY_EDGE_ROW_55_Left_175 VGND VGND VPWR VPWR sky130_fd_sc_hd__decap_3
XANTENNA__7443__A1 _3489_ VGND VGND VPWR VPWR sky130_fd_sc_hd__diode_2
Xclkbuf_4_3_0_clk clknet_0_clk VGND VGND VPWR VPWR clknet_4_3_0_clk sky130_fd_sc_hd__clkbuf_8
XANTENNA__5454__B1 _2019_ VGND VGND VPWR VPWR sky130_fd_sc_hd__diode_2
XANTENNA__4352__S1 _1113_ VGND VGND VPWR VPWR sky130_fd_sc_hd__diode_2
XFILLER_0_99_642 VGND VGND VPWR VPWR sky130_fd_sc_hd__decap_3
XFILLER_0_98_141 VGND VGND VPWR VPWR sky130_fd_sc_hd__fill_2
XANTENNA__7099__S _3435_ VGND VGND VPWR VPWR sky130_fd_sc_hd__diode_2
XFILLER_0_98_174 VGND VGND VPWR VPWR sky130_fd_sc_hd__fill_2
XFILLER_0_59_539 VGND VGND VPWR VPWR sky130_fd_sc_hd__decap_4
XFILLER_0_59_528 VGND VGND VPWR VPWR sky130_fd_sc_hd__fill_1
XFILLER_0_52_16 VGND VGND VPWR VPWR sky130_fd_sc_hd__fill_2
XANTENNA__7827__S _3840_ VGND VGND VPWR VPWR sky130_fd_sc_hd__diode_2
XFILLER_0_67_561 VGND VGND VPWR VPWR sky130_fd_sc_hd__decap_8
XPHY_EDGE_ROW_64_Left_184 VGND VGND VPWR VPWR sky130_fd_sc_hd__decap_3
XFILLER_0_55_712 VGND VGND VPWR VPWR sky130_fd_sc_hd__decap_3
XTAP_TAPCELL_ROW_43_821 VGND VPWR sky130_fd_sc_hd__tapvpwrvgnd_1
XFILLER_0_109_140 VGND VGND VPWR VPWR sky130_fd_sc_hd__decap_3
XFILLER_0_39_274 VGND VGND VPWR VPWR sky130_fd_sc_hd__decap_4
XANTENNA__6731__S _3236_ VGND VGND VPWR VPWR sky130_fd_sc_hd__diode_2
XFILLER_0_27_458 VGND VGND VPWR VPWR sky130_fd_sc_hd__decap_3
XFILLER_0_82_586 VGND VGND VPWR VPWR sky130_fd_sc_hd__fill_2
XANTENNA__5347__S _1768_ VGND VGND VPWR VPWR sky130_fd_sc_hd__diode_2
XFILLER_0_112_316 VGND VGND VPWR VPWR sky130_fd_sc_hd__decap_3
XANTENNA__5871__A _1851_ VGND VGND VPWR VPWR sky130_fd_sc_hd__diode_2
XANTENNA__7562__S _3695_ VGND VGND VPWR VPWR sky130_fd_sc_hd__diode_2
XFILLER_0_50_450 VGND VGND VPWR VPWR sky130_fd_sc_hd__fill_2
XFILLER_0_22_141 VGND VGND VPWR VPWR sky130_fd_sc_hd__decap_3
XFILLER_0_105_390 VGND VGND VPWR VPWR sky130_fd_sc_hd__fill_2
X_4310_ _1106_ VGND VGND VPWR VPWR _1107_ sky130_fd_sc_hd__inv_2
X_5290_ registers\[28\]\[22\] registers\[29\]\[22\] registers\[30\]\[22\] registers\[31\]\[22\]
+ _1810_ _1811_ VGND VGND VPWR VPWR _2036_ sky130_fd_sc_hd__mux4_1
XFILLER_0_2_569 VGND VGND VPWR VPWR sky130_fd_sc_hd__fill_2
XFILLER_0_2_558 VGND VGND VPWR VPWR sky130_fd_sc_hd__fill_2
XANTENNA__5368__S0 _2097_ VGND VGND VPWR VPWR sky130_fd_sc_hd__diode_2
XPHY_EDGE_ROW_73_Left_193 VGND VGND VPWR VPWR sky130_fd_sc_hd__decap_3
X_4241_ registers\[12\]\[0\] registers\[13\]\[0\] registers\[14\]\[0\] registers\[15\]\[0\]
+ _1039_ _1040_ VGND VGND VPWR VPWR _1041_ sky130_fd_sc_hd__mux4_1
XANTENNA__4591__S1 _1339_ VGND VGND VPWR VPWR sky130_fd_sc_hd__diode_2
XANTENNA__6906__S _3335_ VGND VGND VPWR VPWR sky130_fd_sc_hd__diode_2
XANTENNA__4248__B2 _1025_ VGND VGND VPWR VPWR sky130_fd_sc_hd__diode_2
X_8980_ clknet_leaf_75_clk _0077_ VGND VGND VPWR VPWR registers\[18\]\[20\] sky130_fd_sc_hd__dfxtp_1
XANTENNA__4343__S1 _1137_ VGND VGND VPWR VPWR sky130_fd_sc_hd__diode_2
XFILLER_0_93_78 VGND VGND VPWR VPWR sky130_fd_sc_hd__decap_4
X_7931_ _3899_ VGND VGND VPWR VPWR _0376_ sky130_fd_sc_hd__clkbuf_1
XFILLER_0_26_83 VGND VGND VPWR VPWR sky130_fd_sc_hd__fill_1
X_7862_ _3133_ registers\[26\]\[31\] _3828_ VGND VGND VPWR VPWR _3863_ sky130_fd_sc_hd__mux2_1
XFILLER_0_46_701 VPWR VGND VPWR VGND sky130_ef_sc_hd__decap_12
X_7793_ _3826_ VGND VGND VPWR VPWR _0311_ sky130_fd_sc_hd__clkbuf_1
X_6813_ registers\[12\]\[2\] _2966_ _3288_ VGND VGND VPWR VPWR _3291_ sky130_fd_sc_hd__mux2_1
XFILLER_0_92_317 VGND VGND VPWR VPWR sky130_fd_sc_hd__fill_1
XANTENNA__4950__A _1634_ VGND VGND VPWR VPWR sky130_fd_sc_hd__diode_2
X_6744_ _3253_ VGND VGND VPWR VPWR _0859_ sky130_fd_sc_hd__clkbuf_1
X_9532_ clknet_leaf_105_clk _0629_ VGND VGND VPWR VPWR registers\[8\]\[28\] sky130_fd_sc_hd__dfxtp_1
X_6675_ registers\[10\]\[2\] _2966_ _3214_ VGND VGND VPWR VPWR _3217_ sky130_fd_sc_hd__mux2_1
X_9463_ clknet_leaf_69_clk _0560_ VGND VGND VPWR VPWR registers\[31\]\[23\] sky130_fd_sc_hd__dfxtp_1
XTAP_TAPCELL_ROW_21_526 VGND VPWR sky130_fd_sc_hd__tapvpwrvgnd_1
XTAP_TAPCELL_ROW_21_537 VGND VPWR sky130_fd_sc_hd__tapvpwrvgnd_1
XFILLER_0_115_110 VGND VGND VPWR VPWR sky130_fd_sc_hd__fill_2
XFILLER_0_91_3 VGND VGND VPWR VPWR sky130_fd_sc_hd__decap_4
X_5626_ _2308_ _2357_ _2360_ VGND VGND VPWR VPWR _2361_ sky130_fd_sc_hd__o21ba_1
XFILLER_0_73_575 VGND VGND VPWR VPWR sky130_fd_sc_hd__fill_1
X_8414_ registers\[8\]\[2\] net38 _4153_ VGND VGND VPWR VPWR _4156_ sky130_fd_sc_hd__mux2_1
XFILLER_0_5_330 VGND VGND VPWR VPWR sky130_fd_sc_hd__decap_4
XFILLER_0_116_699 VGND VGND VPWR VPWR sky130_fd_sc_hd__fill_1
XFILLER_0_60_225 VGND VGND VPWR VPWR sky130_fd_sc_hd__decap_3
X_9394_ clknet_leaf_67_clk _0491_ VGND VGND VPWR VPWR registers\[9\]\[18\] sky130_fd_sc_hd__dfxtp_1
XFILLER_0_5_341 VGND VGND VPWR VPWR sky130_fd_sc_hd__fill_1
X_5557_ _1070_ VGND VGND VPWR VPWR _2293_ sky130_fd_sc_hd__clkbuf_4
X_8345_ _4119_ VGND VGND VPWR VPWR _0570_ sky130_fd_sc_hd__clkbuf_1
XFILLER_0_5_385 VGND VGND VPWR VPWR sky130_fd_sc_hd__fill_1
X_5488_ _1979_ _2216_ _2220_ VGND VGND VPWR VPWR _2224_ sky130_fd_sc_hd__o21ai_1
X_4508_ registers\[8\]\[13\] registers\[9\]\[13\] registers\[10\]\[13\] registers\[11\]\[13\]
+ _1160_ _1161_ VGND VGND VPWR VPWR _1295_ sky130_fd_sc_hd__mux4_1
X_8276_ _2964_ registers\[31\]\[1\] _4081_ VGND VGND VPWR VPWR _4083_ sky130_fd_sc_hd__mux2_1
X_4439_ _1228_ _1229_ _1031_ VGND VGND VPWR VPWR _1230_ sky130_fd_sc_hd__mux2_1
X_7227_ _3526_ VGND VGND VPWR VPWR _0045_ sky130_fd_sc_hd__clkbuf_1
X_7158_ registers\[16\]\[24\] _3485_ _3477_ VGND VGND VPWR VPWR _3486_ sky130_fd_sc_hd__mux2_1
X_6109_ _2048_ _2804_ VGND VGND VPWR VPWR _2822_ sky130_fd_sc_hd__nor2_1
X_7089_ net38 VGND VGND VPWR VPWR _3439_ sky130_fd_sc_hd__buf_2
XANTENNA__4334__S1 _1128_ VGND VGND VPWR VPWR sky130_fd_sc_hd__diode_2
XTAP_TAPCELL_ROW_29_637 VGND VPWR sky130_fd_sc_hd__tapvpwrvgnd_1
XFILLER_0_68_325 VGND VGND VPWR VPWR sky130_fd_sc_hd__decap_8
XTAP_TAPCELL_ROW_1_273 VGND VPWR sky130_fd_sc_hd__tapvpwrvgnd_1
XFILLER_0_83_306 VGND VGND VPWR VPWR sky130_fd_sc_hd__fill_2
XFILLER_0_49_561 VGND VGND VPWR VPWR sky130_fd_sc_hd__fill_2
XANTENNA__7647__S _3742_ VGND VGND VPWR VPWR sky130_fd_sc_hd__diode_2
XANTENNA__6551__S _3148_ VGND VGND VPWR VPWR sky130_fd_sc_hd__diode_2
XFILLER_0_83_328 VGND VGND VPWR VPWR sky130_fd_sc_hd__fill_2
XFILLER_0_64_520 VGND VGND VPWR VPWR sky130_fd_sc_hd__decap_3
XFILLER_0_119_460 VGND VGND VPWR VPWR sky130_fd_sc_hd__fill_1
XFILLER_0_64_531 VGND VGND VPWR VPWR sky130_fd_sc_hd__fill_1
XFILLER_0_107_633 VGND VGND VPWR VPWR sky130_fd_sc_hd__fill_1
XANTENNA__5167__S _1714_ VGND VGND VPWR VPWR sky130_fd_sc_hd__diode_2
XFILLER_0_8_190 VGND VGND VPWR VPWR sky130_fd_sc_hd__fill_2
XFILLER_0_106_154 VGND VGND VPWR VPWR sky130_fd_sc_hd__decap_3
XFILLER_0_51_225 VGND VGND VPWR VPWR sky130_fd_sc_hd__decap_3
XFILLER_0_51_269 VGND VGND VPWR VPWR sky130_fd_sc_hd__decap_4
XANTENNA__7382__S _3574_ VGND VGND VPWR VPWR sky130_fd_sc_hd__diode_2
XANTENNA__8478__S _4189_ VGND VGND VPWR VPWR sky130_fd_sc_hd__diode_2
XTAP_TAPCELL_ROW_75_1233 VGND VPWR sky130_fd_sc_hd__tapvpwrvgnd_1
XANTENNA__5691__A net103 VGND VGND VPWR VPWR sky130_fd_sc_hd__diode_2
XFILLER_0_20_634 VGND VGND VPWR VPWR sky130_fd_sc_hd__fill_2
XANTENNA__7664__A1 _3437_ VGND VGND VPWR VPWR sky130_fd_sc_hd__diode_2
XFILLER_0_20_667 VGND VGND VPWR VPWR sky130_fd_sc_hd__fill_2
XTAP_TAPCELL_ROW_9_373 VGND VPWR sky130_fd_sc_hd__tapvpwrvgnd_1
XFILLER_0_20_678 VGND VGND VPWR VPWR sky130_fd_sc_hd__fill_2
XANTENNA__7416__A1 _3462_ VGND VGND VPWR VPWR sky130_fd_sc_hd__diode_2
XFILLER_0_2_29 VGND VGND VPWR VPWR sky130_fd_sc_hd__decap_6
XFILLER_0_87_623 VGND VGND VPWR VPWR sky130_fd_sc_hd__fill_2
XTAP_TAPCELL_ROW_86_1373 VGND VPWR sky130_fd_sc_hd__tapvpwrvgnd_1
XFILLER_0_59_314 VGND VGND VPWR VPWR sky130_fd_sc_hd__fill_1
XFILLER_0_86_133 VGND VGND VPWR VPWR sky130_fd_sc_hd__fill_1
XFILLER_0_74_306 VGND VGND VPWR VPWR sky130_fd_sc_hd__fill_2
XTAP_TAPCELL_ROW_56_990 VGND VPWR sky130_fd_sc_hd__tapvpwrvgnd_1
XFILLER_0_28_701 VGND VGND VPWR VPWR sky130_fd_sc_hd__fill_1
XANTENNA__6461__S _3090_ VGND VGND VPWR VPWR sky130_fd_sc_hd__diode_2
XANTENNA__4938__C1 _1702_ VGND VGND VPWR VPWR sky130_fd_sc_hd__diode_2
X_4790_ registers\[12\]\[28\] registers\[13\]\[28\] registers\[14\]\[28\] registers\[15\]\[28\]
+ _1550_ _1551_ VGND VGND VPWR VPWR _1562_ sky130_fd_sc_hd__mux4_1
XFILLER_0_55_542 VGND VGND VPWR VPWR sky130_fd_sc_hd__fill_2
XFILLER_0_7_628 VGND VGND VPWR VPWR sky130_fd_sc_hd__fill_2
XFILLER_0_70_501 VGND VGND VPWR VPWR sky130_fd_sc_hd__fill_2
XFILLER_0_12_52 VGND VGND VPWR VPWR sky130_fd_sc_hd__fill_2
XFILLER_0_12_63 VGND VGND VPWR VPWR sky130_fd_sc_hd__fill_2
XFILLER_0_15_406 VGND VGND VPWR VPWR sky130_fd_sc_hd__fill_1
XANTENNA__6155__A1 net138 VGND VGND VPWR VPWR sky130_fd_sc_hd__diode_2
X_6460_ _3068_ VGND VGND VPWR VPWR _3090_ sky130_fd_sc_hd__clkbuf_8
XFILLER_0_12_85 VGND VGND VPWR VPWR sky130_fd_sc_hd__fill_2
XFILLER_0_112_113 VGND VGND VPWR VPWR sky130_fd_sc_hd__fill_2
X_6391_ _3047_ VGND VGND VPWR VPWR _0712_ sky130_fd_sc_hd__clkbuf_1
XANTENNA__8388__S _4139_ VGND VGND VPWR VPWR sky130_fd_sc_hd__diode_2
X_5411_ _2019_ _2150_ _1960_ VGND VGND VPWR VPWR _2151_ sky130_fd_sc_hd__o21ai_1
XPHY_EDGE_ROW_81_Left_201 VGND VGND VPWR VPWR sky130_fd_sc_hd__decap_3
Xoutput114 net114 VGND VGND VPWR VPWR rd2[10] sky130_fd_sc_hd__buf_1
Xoutput125 net125 VGND VGND VPWR VPWR rd2[20] sky130_fd_sc_hd__buf_1
Xoutput103 net103 VGND VGND VPWR VPWR rd1[2] sky130_fd_sc_hd__buf_1
X_5342_ registers\[20\]\[25\] registers\[21\]\[25\] registers\[22\]\[25\] registers\[23\]\[25\]
+ _2027_ _2028_ VGND VGND VPWR VPWR _2085_ sky130_fd_sc_hd__mux4_1
X_8130_ _3022_ registers\[30\]\[29\] _3995_ VGND VGND VPWR VPWR _4005_ sky130_fd_sc_hd__mux2_1
XFILLER_0_23_483 VGND VGND VPWR VPWR sky130_fd_sc_hd__fill_2
Xoutput136 net136 VGND VGND VPWR VPWR rd2[30] sky130_fd_sc_hd__buf_1
X_8061_ _3968_ VGND VGND VPWR VPWR _0437_ sky130_fd_sc_hd__clkbuf_1
XFILLER_0_10_133 VGND VGND VPWR VPWR sky130_fd_sc_hd__decap_4
XFILLER_0_11_667 VGND VGND VPWR VPWR sky130_fd_sc_hd__fill_2
X_5273_ _1763_ VGND VGND VPWR VPWR _2020_ sky130_fd_sc_hd__buf_4
X_7012_ net10 net9 net48 VGND VGND VPWR VPWR _3396_ sky130_fd_sc_hd__and3_2
X_4224_ net7 VGND VGND VPWR VPWR _1024_ sky130_fd_sc_hd__inv_2
XANTENNA__7407__A1 _3453_ VGND VGND VPWR VPWR sky130_fd_sc_hd__diode_2
XFILLER_0_97_409 VGND VGND VPWR VPWR sky130_fd_sc_hd__fill_1
XPHY_EDGE_ROW_90_Left_210 VGND VGND VPWR VPWR sky130_fd_sc_hd__decap_3
XFILLER_0_78_612 VGND VGND VPWR VPWR sky130_fd_sc_hd__fill_2
X_8963_ clknet_leaf_22_clk _0060_ VGND VGND VPWR VPWR registers\[18\]\[3\] sky130_fd_sc_hd__dfxtp_1
XFILLER_0_78_645 VGND VGND VPWR VPWR sky130_fd_sc_hd__fill_2
XFILLER_0_78_634 VGND VGND VPWR VPWR sky130_fd_sc_hd__decap_3
X_8894_ clknet_leaf_13_clk _1015_ VGND VGND VPWR VPWR registers\[15\]\[30\] sky130_fd_sc_hd__dfxtp_1
X_7914_ _3117_ registers\[27\]\[23\] _3887_ VGND VGND VPWR VPWR _3891_ sky130_fd_sc_hd__mux2_1
XFILLER_0_93_615 VGND VGND VPWR VPWR sky130_fd_sc_hd__fill_1
XFILLER_0_78_689 VGND VGND VPWR VPWR sky130_fd_sc_hd__fill_1
XFILLER_0_77_155 VGND VGND VPWR VPWR sky130_fd_sc_hd__decap_8
XFILLER_0_53_70 VGND VGND VPWR VPWR sky130_fd_sc_hd__fill_2
X_7845_ _3854_ VGND VGND VPWR VPWR _0335_ sky130_fd_sc_hd__clkbuf_1
XANTENNA__6371__S _3030_ VGND VGND VPWR VPWR sky130_fd_sc_hd__diode_2
XANTENNA__7467__S _3648_ VGND VGND VPWR VPWR sky130_fd_sc_hd__diode_2
XANTENNA__6394__A1 _2997_ VGND VGND VPWR VPWR sky130_fd_sc_hd__diode_2
X_4988_ registers\[28\]\[6\] registers\[29\]\[6\] registers\[30\]\[6\] registers\[31\]\[6\]
+ _1748_ _1749_ VGND VGND VPWR VPWR _1750_ sky130_fd_sc_hd__mux4_1
X_9515_ clknet_leaf_51_clk _0612_ VGND VGND VPWR VPWR registers\[8\]\[11\] sky130_fd_sc_hd__dfxtp_1
X_7776_ _3115_ registers\[25\]\[22\] _3815_ VGND VGND VPWR VPWR _3818_ sky130_fd_sc_hd__mux2_1
XTAP_TAPCELL_ROW_34_695 VGND VPWR sky130_fd_sc_hd__tapvpwrvgnd_1
X_6727_ registers\[10\]\[27\] _3018_ _3236_ VGND VGND VPWR VPWR _3244_ sky130_fd_sc_hd__mux2_1
X_9446_ clknet_leaf_34_clk _0543_ VGND VGND VPWR VPWR registers\[31\]\[6\] sky130_fd_sc_hd__dfxtp_1
XANTENNA__6146__A1 _1500_ VGND VGND VPWR VPWR sky130_fd_sc_hd__diode_2
X_6658_ registers\[0\]\[28\] _3020_ _3197_ VGND VGND VPWR VPWR _3206_ sky130_fd_sc_hd__mux2_1
XFILLER_0_33_236 VGND VGND VPWR VPWR sky130_fd_sc_hd__decap_3
XFILLER_0_116_485 VGND VGND VPWR VPWR sky130_fd_sc_hd__fill_2
XFILLER_0_103_113 VGND VGND VPWR VPWR sky130_fd_sc_hd__decap_3
X_5609_ _2295_ VGND VGND VPWR VPWR _2344_ sky130_fd_sc_hd__clkbuf_4
X_9377_ clknet_leaf_5_clk _0474_ VGND VGND VPWR VPWR registers\[9\]\[1\] sky130_fd_sc_hd__dfxtp_1
X_6589_ _3168_ VGND VGND VPWR VPWR _0789_ sky130_fd_sc_hd__clkbuf_1
X_8328_ _3016_ registers\[31\]\[26\] _4103_ VGND VGND VPWR VPWR _4110_ sky130_fd_sc_hd__mux2_1
XANTENNA__6400__A _3029_ VGND VGND VPWR VPWR sky130_fd_sc_hd__diode_2
XANTENNA__5016__A _1702_ VGND VGND VPWR VPWR sky130_fd_sc_hd__diode_2
X_8259_ _4073_ VGND VGND VPWR VPWR _0530_ sky130_fd_sc_hd__clkbuf_1
XANTENNA__7930__S _3864_ VGND VGND VPWR VPWR sky130_fd_sc_hd__diode_2
XTAP_TAPCELL_ROW_6_343 VGND VPWR sky130_fd_sc_hd__tapvpwrvgnd_1
XTAP_TAPCELL_ROW_6_332 VGND VPWR sky130_fd_sc_hd__tapvpwrvgnd_1
XANTENNA__6546__S _3137_ VGND VGND VPWR VPWR sky130_fd_sc_hd__diode_2
XTAP_TAPCELL_ROW_70_1174 VGND VPWR sky130_fd_sc_hd__tapvpwrvgnd_1
XTAP_TAPCELL_ROW_70_1163 VGND VPWR sky130_fd_sc_hd__tapvpwrvgnd_1
XANTENNA__4371__A1_N _1109_ VGND VGND VPWR VPWR sky130_fd_sc_hd__diode_2
XANTENNA__4632__A1 _1389_ VGND VGND VPWR VPWR sky130_fd_sc_hd__diode_2
XANTENNA__5686__A _2276_ VGND VGND VPWR VPWR sky130_fd_sc_hd__diode_2
XANTENNA__4590__A _1109_ VGND VGND VPWR VPWR sky130_fd_sc_hd__diode_2
XFILLER_0_107_430 VGND VGND VPWR VPWR sky130_fd_sc_hd__fill_2
XFILLER_0_37_586 VGND VGND VPWR VPWR sky130_fd_sc_hd__fill_2
Xinput16 wd3[0] VGND VGND VPWR VPWR net16 sky130_fd_sc_hd__buf_2
Xinput27 wd3[1] VGND VGND VPWR VPWR net27 sky130_fd_sc_hd__buf_2
Xinput38 wd3[2] VGND VGND VPWR VPWR net38 sky130_fd_sc_hd__buf_2
XFILLER_0_107_496 VGND VGND VPWR VPWR sky130_fd_sc_hd__fill_2
XFILLER_0_24_247 VGND VGND VPWR VPWR sky130_fd_sc_hd__decap_3
XFILLER_0_24_269 VGND VGND VPWR VPWR sky130_fd_sc_hd__decap_3
XANTENNA__6310__A net24 VGND VGND VPWR VPWR sky130_fd_sc_hd__diode_2
XANTENNA__4243__S0 _1026_ VGND VGND VPWR VPWR sky130_fd_sc_hd__diode_2
XFILLER_0_40_729 VGND VGND VPWR VPWR sky130_fd_sc_hd__fill_1
XFILLER_0_103_680 VPWR VGND VPWR VGND sky130_ef_sc_hd__decap_12
XANTENNA__7840__S _3851_ VGND VGND VPWR VPWR sky130_fd_sc_hd__diode_2
XANTENNA__4546__S1 _1161_ VGND VGND VPWR VPWR sky130_fd_sc_hd__diode_2
XFILLER_0_20_486 VGND VGND VPWR VPWR sky130_fd_sc_hd__fill_1
XFILLER_0_74_14 VGND VGND VPWR VPWR sky130_fd_sc_hd__fill_1
XTAP_TAPCELL_ROW_88_1402 VGND VPWR sky130_fd_sc_hd__tapvpwrvgnd_1
XANTENNA__7141__A net26 VGND VGND VPWR VPWR sky130_fd_sc_hd__diode_2
XANTENNA__8062__A1 _3495_ VGND VGND VPWR VPWR sky130_fd_sc_hd__diode_2
X_5960_ net119 _2680_ VGND VGND VPWR VPWR _2681_ sky130_fd_sc_hd__xnor2_1
XFILLER_0_59_122 VGND VGND VPWR VPWR sky130_fd_sc_hd__fill_1
X_5891_ _2337_ _2341_ VGND VGND VPWR VPWR _2616_ sky130_fd_sc_hd__and2_1
XFILLER_0_59_144 VGND VGND VPWR VPWR sky130_fd_sc_hd__fill_2
X_4911_ _1676_ VGND VGND VPWR VPWR net103 sky130_fd_sc_hd__inv_2
XANTENNA__7287__S _3550_ VGND VGND VPWR VPWR sky130_fd_sc_hd__diode_2
X_7630_ _3106_ registers\[23\]\[18\] _3731_ VGND VGND VPWR VPWR _3740_ sky130_fd_sc_hd__mux2_1
XTAP_TAPCELL_ROW_51_919 VGND VPWR sky130_fd_sc_hd__tapvpwrvgnd_1
XFILLER_0_47_328 VGND VGND VPWR VPWR sky130_fd_sc_hd__fill_2
XFILLER_0_74_136 VGND VGND VPWR VPWR sky130_fd_sc_hd__fill_1
XFILLER_0_74_125 VGND VGND VPWR VPWR sky130_fd_sc_hd__fill_2
XFILLER_0_7_414 VGND VGND VPWR VPWR sky130_fd_sc_hd__decap_4
XFILLER_0_23_51 VGND VGND VPWR VPWR sky130_fd_sc_hd__decap_3
X_4842_ registers\[4\]\[31\] registers\[5\]\[31\] registers\[6\]\[31\] registers\[7\]\[31\]
+ _1427_ _1428_ VGND VGND VPWR VPWR _1611_ sky130_fd_sc_hd__mux4_1
XFILLER_0_117_238 VGND VGND VPWR VPWR sky130_fd_sc_hd__decap_6
X_7561_ _3703_ VGND VGND VPWR VPWR _0202_ sky130_fd_sc_hd__clkbuf_1
XFILLER_0_99_22 VGND VGND VPWR VPWR sky130_fd_sc_hd__decap_3
XFILLER_0_62_309 VGND VGND VPWR VPWR sky130_fd_sc_hd__decap_4
XFILLER_0_43_501 VGND VGND VPWR VPWR sky130_fd_sc_hd__decap_3
XFILLER_0_7_425 VGND VGND VPWR VPWR sky130_fd_sc_hd__decap_4
X_4773_ registers\[12\]\[27\] registers\[13\]\[27\] registers\[14\]\[27\] registers\[15\]\[27\]
+ _1404_ _1405_ VGND VGND VPWR VPWR _1546_ sky130_fd_sc_hd__mux4_1
X_7492_ _3104_ registers\[21\]\[17\] _3659_ VGND VGND VPWR VPWR _3667_ sky130_fd_sc_hd__mux2_1
XTAP_TAPCELL_ROW_99_1542 VGND VPWR sky130_fd_sc_hd__tapvpwrvgnd_1
XFILLER_0_55_383 VGND VGND VPWR VPWR sky130_fd_sc_hd__fill_2
X_9300_ clknet_leaf_74_clk _0397_ VGND VGND VPWR VPWR registers\[28\]\[20\] sky130_fd_sc_hd__dfxtp_1
X_6512_ net35 VGND VGND VPWR VPWR _3125_ sky130_fd_sc_hd__clkbuf_2
XTAP_TAPCELL_ROW_31_665 VGND VPWR sky130_fd_sc_hd__tapvpwrvgnd_1
X_6443_ _3078_ VGND VGND VPWR VPWR _0733_ sky130_fd_sc_hd__clkbuf_1
X_9231_ clknet_leaf_66_clk _0328_ VGND VGND VPWR VPWR registers\[26\]\[15\] sky130_fd_sc_hd__dfxtp_1
XFILLER_0_31_718 VGND VGND VPWR VPWR sky130_fd_sc_hd__decap_8
XFILLER_0_113_444 VGND VGND VPWR VPWR sky130_fd_sc_hd__fill_2
XFILLER_0_99_99 VGND VGND VPWR VPWR sky130_fd_sc_hd__decap_4
XFILLER_0_31_729 VGND VGND VPWR VPWR sky130_fd_sc_hd__fill_1
X_9162_ clknet_leaf_38_clk _0259_ VGND VGND VPWR VPWR registers\[24\]\[10\] sky130_fd_sc_hd__dfxtp_1
XFILLER_0_101_617 VGND VGND VPWR VPWR sky130_fd_sc_hd__decap_4
X_6374_ _3038_ VGND VGND VPWR VPWR _0704_ sky130_fd_sc_hd__clkbuf_1
XFILLER_0_2_141 VGND VGND VPWR VPWR sky130_fd_sc_hd__decap_3
XANTENNA__4785__S1 _1556_ VGND VGND VPWR VPWR sky130_fd_sc_hd__diode_2
XFILLER_0_23_291 VGND VGND VPWR VPWR sky130_fd_sc_hd__fill_2
X_9093_ clknet_leaf_27_clk _0190_ VGND VGND VPWR VPWR registers\[22\]\[5\] sky130_fd_sc_hd__dfxtp_1
X_5325_ registers\[24\]\[24\] registers\[25\]\[24\] registers\[26\]\[24\] registers\[27\]\[24\]
+ _2020_ _2021_ VGND VGND VPWR VPWR _2069_ sky130_fd_sc_hd__mux4_1
X_8113_ _3996_ VGND VGND VPWR VPWR _0461_ sky130_fd_sc_hd__clkbuf_1
XANTENNA__4537__S1 _1321_ VGND VGND VPWR VPWR sky130_fd_sc_hd__diode_2
XFILLER_0_54_3 VGND VGND VPWR VPWR sky130_fd_sc_hd__fill_2
XFILLER_0_11_497 VGND VGND VPWR VPWR sky130_fd_sc_hd__fill_2
X_8044_ registers\[2\]\[20\] _3476_ _3959_ VGND VGND VPWR VPWR _3960_ sky130_fd_sc_hd__mux2_1
X_5256_ _1768_ _2003_ VGND VGND VPWR VPWR _2004_ sky130_fd_sc_hd__or2_1
XFILLER_0_48_81 VGND VGND VPWR VPWR sky130_fd_sc_hd__decap_3
XTAP_TAPCELL_ROW_3_302 VGND VPWR sky130_fd_sc_hd__tapvpwrvgnd_1
X_5187_ registers\[4\]\[16\] registers\[5\]\[16\] registers\[6\]\[16\] registers\[7\]\[16\]
+ _1748_ _1749_ VGND VGND VPWR VPWR _1939_ sky130_fd_sc_hd__mux4_1
XANTENNA__5270__S _1768_ VGND VGND VPWR VPWR sky130_fd_sc_hd__diode_2
XFILLER_0_97_206 VGND VGND VPWR VPWR sky130_fd_sc_hd__fill_2
XTAP_TAPCELL_ROW_108_1660 VGND VPWR sky130_fd_sc_hd__tapvpwrvgnd_1
X_8946_ clknet_leaf_72_clk _0043_ VGND VGND VPWR VPWR registers\[17\]\[18\] sky130_fd_sc_hd__dfxtp_1
XTAP_TAPCELL_ROW_39_765 VGND VPWR sky130_fd_sc_hd__tapvpwrvgnd_1
X_8877_ clknet_leaf_51_clk _0998_ VGND VGND VPWR VPWR registers\[15\]\[13\] sky130_fd_sc_hd__dfxtp_1
XFILLER_0_93_423 VGND VGND VPWR VPWR sky130_fd_sc_hd__fill_2
XFILLER_0_78_486 VGND VGND VPWR VPWR sky130_fd_sc_hd__fill_2
X_7828_ _3845_ VGND VGND VPWR VPWR _0327_ sky130_fd_sc_hd__clkbuf_1
XANTENNA__7564__A0 _3108_ VGND VGND VPWR VPWR sky130_fd_sc_hd__diode_2
X_7759_ _3098_ registers\[25\]\[14\] _3804_ VGND VGND VPWR VPWR _3809_ sky130_fd_sc_hd__mux2_1
XFILLER_0_108_249 VGND VGND VPWR VPWR sky130_fd_sc_hd__decap_3
XFILLER_0_65_169 VGND VGND VPWR VPWR sky130_fd_sc_hd__fill_1
XFILLER_0_19_553 VGND VGND VPWR VPWR sky130_fd_sc_hd__decap_3
XANTENNA__4473__S0 _1125_ VGND VGND VPWR VPWR sky130_fd_sc_hd__diode_2
XFILLER_0_74_681 VGND VGND VPWR VPWR sky130_fd_sc_hd__fill_2
XFILLER_0_6_480 VGND VGND VPWR VPWR sky130_fd_sc_hd__fill_2
X_9429_ clknet_leaf_91_clk _0526_ VGND VGND VPWR VPWR registers\[6\]\[21\] sky130_fd_sc_hd__dfxtp_1
XFILLER_0_34_545 VGND VGND VPWR VPWR sky130_fd_sc_hd__fill_2
XFILLER_0_104_433 VGND VGND VPWR VPWR sky130_fd_sc_hd__fill_2
XFILLER_0_61_397 VGND VGND VPWR VPWR sky130_fd_sc_hd__fill_2
XTAP_TAPCELL_ROW_59_1025 VGND VPWR sky130_fd_sc_hd__tapvpwrvgnd_1
XFILLER_0_22_729 VGND VGND VPWR VPWR sky130_fd_sc_hd__fill_1
XFILLER_0_104_477 VGND VGND VPWR VPWR sky130_fd_sc_hd__fill_1
XFILLER_0_28_29 VGND VGND VPWR VPWR sky130_fd_sc_hd__fill_1
XANTENNA_input38_A wd3[2] VGND VGND VPWR VPWR sky130_fd_sc_hd__diode_2
XFILLER_0_88_206 VGND VGND VPWR VPWR sky130_fd_sc_hd__fill_2
XANTENNA__8044__A1 _3476_ VGND VGND VPWR VPWR sky130_fd_sc_hd__diode_2
XFILLER_0_69_453 VGND VGND VPWR VPWR sky130_fd_sc_hd__decap_3
XTAP_TAPCELL_ROW_83_1343 VGND VPWR sky130_fd_sc_hd__tapvpwrvgnd_1
XTAP_TAPCELL_ROW_83_1332 VGND VPWR sky130_fd_sc_hd__tapvpwrvgnd_1
XFILLER_0_57_626 VGND VGND VPWR VPWR sky130_fd_sc_hd__fill_2
XFILLER_0_57_615 VGND VGND VPWR VPWR sky130_fd_sc_hd__fill_1
XANTENNA__4700__S1 _1348_ VGND VGND VPWR VPWR sky130_fd_sc_hd__diode_2
XFILLER_0_84_445 VGND VGND VPWR VPWR sky130_fd_sc_hd__fill_2
XFILLER_0_60_27 VGND VGND VPWR VPWR sky130_fd_sc_hd__fill_1
XFILLER_0_56_136 VGND VGND VPWR VPWR sky130_fd_sc_hd__fill_2
XFILLER_0_56_125 VGND VGND VPWR VPWR sky130_fd_sc_hd__decap_8
XFILLER_0_72_607 VGND VGND VPWR VPWR sky130_fd_sc_hd__decap_3
XFILLER_0_71_106 VGND VGND VPWR VPWR sky130_fd_sc_hd__fill_2
XFILLER_0_44_309 VGND VGND VPWR VPWR sky130_fd_sc_hd__fill_2
XFILLER_0_115_709 VPWR VGND VPWR VGND sky130_ef_sc_hd__decap_12
XANTENNA__7835__S _3840_ VGND VGND VPWR VPWR sky130_fd_sc_hd__diode_2
XANTENNA__5318__C1 _1702_ VGND VGND VPWR VPWR sky130_fd_sc_hd__diode_2
XFILLER_0_4_417 VGND VGND VPWR VPWR sky130_fd_sc_hd__decap_3
XFILLER_0_25_556 VGND VGND VPWR VPWR sky130_fd_sc_hd__fill_2
XFILLER_0_80_673 VGND VGND VPWR VPWR sky130_fd_sc_hd__fill_2
XFILLER_0_0_612 VGND VGND VPWR VPWR sky130_fd_sc_hd__fill_2
XANTENNA__6530__A1 _2958_ VGND VGND VPWR VPWR sky130_fd_sc_hd__diode_2
XFILLER_0_110_447 VGND VGND VPWR VPWR sky130_fd_sc_hd__decap_4
XFILLER_0_110_425 VGND VGND VPWR VPWR sky130_fd_sc_hd__fill_1
XTAP_TAPCELL_ROW_94_1483 VGND VPWR sky130_fd_sc_hd__tapvpwrvgnd_1
XANTENNA__4893__A1_N _1616_ VGND VGND VPWR VPWR sky130_fd_sc_hd__diode_2
XFILLER_0_0_645 VGND VGND VPWR VPWR sky130_fd_sc_hd__fill_1
XFILLER_0_85_24 VGND VGND VPWR VPWR sky130_fd_sc_hd__fill_1
X_5110_ _1866_ VGND VGND VPWR VPWR net83 sky130_fd_sc_hd__inv_2
X_6090_ net127 _2803_ VGND VGND VPWR VPWR _2804_ sky130_fd_sc_hd__xnor2_1
XFILLER_0_0_667 VGND VGND VPWR VPWR sky130_fd_sc_hd__decap_3
XFILLER_0_20_272 VGND VGND VPWR VPWR sky130_fd_sc_hd__fill_1
XFILLER_0_85_57 VGND VGND VPWR VPWR sky130_fd_sc_hd__fill_2
X_5041_ _1797_ _1800_ _1767_ VGND VGND VPWR VPWR _1801_ sky130_fd_sc_hd__mux2_1
XFILLER_0_109_64 VGND VGND VPWR VPWR sky130_fd_sc_hd__fill_2
XFILLER_0_109_42 VPWR VGND VPWR VGND sky130_ef_sc_hd__decap_12
XANTENNA__8035__A1 _3468_ VGND VGND VPWR VPWR sky130_fd_sc_hd__diode_2
XANTENNA__6914__S _3335_ VGND VGND VPWR VPWR sky130_fd_sc_hd__diode_2
X_8800_ clknet_leaf_2_clk _0921_ VGND VGND VPWR VPWR registers\[13\]\[0\] sky130_fd_sc_hd__dfxtp_1
X_6992_ _3115_ registers\[14\]\[22\] _3383_ VGND VGND VPWR VPWR _3386_ sky130_fd_sc_hd__mux2_1
X_8731_ clknet_leaf_100_clk _0852_ VGND VGND VPWR VPWR registers\[10\]\[27\] sky130_fd_sc_hd__dfxtp_1
XTAP_TAPCELL_ROW_36_724 VGND VPWR sky130_fd_sc_hd__tapvpwrvgnd_1
X_5943_ _2626_ _2631_ _2647_ _2664_ VGND VGND VPWR VPWR _2665_ sky130_fd_sc_hd__a31o_1
X_5874_ _2592_ _2593_ _2599_ VGND VGND VPWR VPWR _2600_ sky130_fd_sc_hd__o21a_1
X_8662_ clknet_leaf_93_clk _0783_ VGND VGND VPWR VPWR registers\[7\]\[22\] sky130_fd_sc_hd__dfxtp_1
X_8593_ clknet_leaf_49_clk _0714_ VGND VGND VPWR VPWR registers\[3\]\[17\] sky130_fd_sc_hd__dfxtp_1
X_7613_ _3719_ VGND VGND VPWR VPWR _3731_ sky130_fd_sc_hd__clkbuf_8
X_4825_ _1593_ _1594_ _1362_ VGND VGND VPWR VPWR _1595_ sky130_fd_sc_hd__mux2_1
XFILLER_0_47_169 VGND VGND VPWR VPWR sky130_fd_sc_hd__decap_3
XTAP_TAPCELL_ROW_16_470 VGND VPWR sky130_fd_sc_hd__tapvpwrvgnd_1
XFILLER_0_35_309 VGND VGND VPWR VPWR sky130_fd_sc_hd__fill_2
XANTENNA__4455__S0 _1131_ VGND VGND VPWR VPWR sky130_fd_sc_hd__diode_2
XFILLER_0_90_437 VGND VGND VPWR VPWR sky130_fd_sc_hd__fill_2
X_7544_ _3694_ VGND VGND VPWR VPWR _0194_ sky130_fd_sc_hd__clkbuf_1
XFILLER_0_43_353 VGND VGND VPWR VPWR sky130_fd_sc_hd__decap_4
XFILLER_0_43_331 VGND VGND VPWR VPWR sky130_fd_sc_hd__decap_3
XFILLER_0_7_277 VGND VGND VPWR VPWR sky130_fd_sc_hd__decap_3
XFILLER_0_16_567 VPWR VGND VPWR VGND sky130_ef_sc_hd__decap_12
X_4756_ _1528_ _1529_ _1140_ VGND VGND VPWR VPWR _1530_ sky130_fd_sc_hd__mux2_1
XFILLER_0_71_673 VGND VGND VPWR VPWR sky130_fd_sc_hd__fill_2
XFILLER_0_70_172 VGND VGND VPWR VPWR sky130_fd_sc_hd__fill_2
XFILLER_0_70_150 VGND VGND VPWR VPWR sky130_fd_sc_hd__fill_1
X_4687_ registers\[12\]\[22\] registers\[13\]\[22\] registers\[14\]\[22\] registers\[15\]\[22\]
+ _1338_ _1339_ VGND VGND VPWR VPWR _1465_ sky130_fd_sc_hd__mux4_1
X_7475_ _3087_ registers\[21\]\[9\] _3648_ VGND VGND VPWR VPWR _3658_ sky130_fd_sc_hd__mux2_1
XFILLER_0_43_364 VGND VGND VPWR VPWR sky130_fd_sc_hd__fill_2
XFILLER_0_16_589 VGND VGND VPWR VPWR sky130_fd_sc_hd__fill_2
XFILLER_0_113_263 VGND VGND VPWR VPWR sky130_fd_sc_hd__fill_1
XFILLER_0_113_241 VGND VGND VPWR VPWR sky130_fd_sc_hd__fill_1
X_6426_ net13 net12 net11 VGND VGND VPWR VPWR _3066_ sky130_fd_sc_hd__and3_2
XFILLER_0_3_472 VGND VGND VPWR VPWR sky130_fd_sc_hd__fill_2
X_9214_ clknet_leaf_98_clk _0311_ VGND VGND VPWR VPWR registers\[25\]\[30\] sky130_fd_sc_hd__dfxtp_1
XFILLER_0_113_285 VGND VGND VPWR VPWR sky130_fd_sc_hd__fill_1
XFILLER_0_101_436 VGND VGND VPWR VPWR sky130_fd_sc_hd__fill_2
XANTENNA__4532__B1 _1142_ VGND VGND VPWR VPWR sky130_fd_sc_hd__diode_2
X_6357_ _2960_ _3028_ VGND VGND VPWR VPWR _3029_ sky130_fd_sc_hd__nor2_2
X_9145_ clknet_leaf_80_clk _0242_ VGND VGND VPWR VPWR registers\[23\]\[25\] sky130_fd_sc_hd__dfxtp_1
XANTENNA__7480__S _3659_ VGND VGND VPWR VPWR sky130_fd_sc_hd__diode_2
X_5308_ registers\[24\]\[23\] registers\[25\]\[23\] registers\[26\]\[23\] registers\[27\]\[23\]
+ _1883_ _1774_ VGND VGND VPWR VPWR _2053_ sky130_fd_sc_hd__mux4_1
X_6288_ net17 VGND VGND VPWR VPWR _2982_ sky130_fd_sc_hd__buf_2
X_9076_ clknet_leaf_74_clk _0173_ VGND VGND VPWR VPWR registers\[21\]\[20\] sky130_fd_sc_hd__dfxtp_1
X_8027_ registers\[2\]\[12\] _3460_ _3948_ VGND VGND VPWR VPWR _3951_ sky130_fd_sc_hd__mux2_1
XANTENNA__5183__S1 _1743_ VGND VGND VPWR VPWR sky130_fd_sc_hd__diode_2
X_5239_ _1767_ _1987_ VGND VGND VPWR VPWR _1988_ sky130_fd_sc_hd__or2_1
XFILLER_0_98_504 VGND VGND VPWR VPWR sky130_fd_sc_hd__fill_2
XANTENNA__6588__A1 _3020_ VGND VGND VPWR VPWR sky130_fd_sc_hd__diode_2
XFILLER_0_39_626 VGND VGND VPWR VPWR sky130_fd_sc_hd__decap_4
XFILLER_0_39_615 VGND VGND VPWR VPWR sky130_fd_sc_hd__fill_1
X_8929_ clknet_leaf_107_clk _0026_ VGND VGND VPWR VPWR registers\[17\]\[1\] sky130_fd_sc_hd__dfxtp_1
XFILLER_0_39_637 VGND VGND VPWR VPWR sky130_fd_sc_hd__fill_2
XFILLER_0_38_136 VGND VGND VPWR VPWR sky130_fd_sc_hd__fill_2
XFILLER_0_109_525 VGND VGND VPWR VPWR sky130_fd_sc_hd__fill_2
XFILLER_0_93_242 VGND VGND VPWR VPWR sky130_fd_sc_hd__decap_4
XFILLER_0_26_309 VGND VGND VPWR VPWR sky130_fd_sc_hd__fill_1
XANTENNA__4446__S0 _1196_ VGND VGND VPWR VPWR sky130_fd_sc_hd__diode_2
XFILLER_0_47_681 VGND VGND VPWR VPWR sky130_fd_sc_hd__fill_1
XANTENNA__7655__S _3719_ VGND VGND VPWR VPWR sky130_fd_sc_hd__diode_2
XANTENNA__4771__B1 _1124_ VGND VGND VPWR VPWR sky130_fd_sc_hd__diode_2
XFILLER_0_22_504 VGND VGND VPWR VPWR sky130_fd_sc_hd__fill_2
XFILLER_0_22_526 VGND VGND VPWR VPWR sky130_fd_sc_hd__decap_3
XANTENNA__8486__S _4189_ VGND VGND VPWR VPWR sky130_fd_sc_hd__diode_2
XFILLER_0_39_28 VGND VGND VPWR VPWR sky130_fd_sc_hd__decap_4
XFILLER_0_30_581 VGND VGND VPWR VPWR sky130_fd_sc_hd__decap_4
XANTENNA__4519__S _1132_ VGND VGND VPWR VPWR sky130_fd_sc_hd__diode_2
XANTENNA_clkload3_A clknet_4_4_0_clk VGND VGND VPWR VPWR sky130_fd_sc_hd__diode_2
XFILLER_0_69_250 VGND VGND VPWR VPWR sky130_fd_sc_hd__fill_2
XFILLER_0_84_253 VGND VGND VPWR VPWR sky130_fd_sc_hd__fill_2
XFILLER_0_57_456 VGND VGND VPWR VPWR sky130_fd_sc_hd__fill_2
XFILLER_0_29_169 VGND VGND VPWR VPWR sky130_fd_sc_hd__decap_6
X_4610_ registers\[4\]\[18\] registers\[5\]\[18\] registers\[6\]\[18\] registers\[7\]\[18\]
+ _1390_ _1391_ VGND VGND VPWR VPWR _1392_ sky130_fd_sc_hd__mux4_1
XANTENNA__4437__S0 _1053_ VGND VGND VPWR VPWR sky130_fd_sc_hd__diode_2
XFILLER_0_44_128 VGND VGND VPWR VPWR sky130_fd_sc_hd__fill_2
XFILLER_0_44_117 VGND VGND VPWR VPWR sky130_fd_sc_hd__fill_2
XFILLER_0_5_704 VGND VGND VPWR VPWR sky130_fd_sc_hd__fill_2
XFILLER_0_115_528 VGND VGND VPWR VPWR sky130_fd_sc_hd__fill_1
XFILLER_0_112_3 VGND VGND VPWR VPWR sky130_fd_sc_hd__fill_2
XANTENNA__4988__S1 _1749_ VGND VGND VPWR VPWR sky130_fd_sc_hd__diode_2
XTAP_TAPCELL_ROW_96_1501 VGND VPWR sky130_fd_sc_hd__tapvpwrvgnd_1
X_5590_ _2219_ _2324_ VGND VGND VPWR VPWR _2325_ sky130_fd_sc_hd__or2_1
XTAP_TAPCELL_ROW_41_793 VGND VPWR sky130_fd_sc_hd__tapvpwrvgnd_1
XTAP_TAPCELL_ROW_96_1512 VGND VPWR sky130_fd_sc_hd__tapvpwrvgnd_1
X_4541_ registers\[16\]\[15\] registers\[17\]\[15\] registers\[18\]\[15\] registers\[19\]\[15\]
+ _1320_ _1321_ VGND VGND VPWR VPWR _1326_ sky130_fd_sc_hd__mux4_1
XFILLER_0_53_673 VGND VGND VPWR VPWR sky130_fd_sc_hd__fill_2
XFILLER_0_40_312 VGND VGND VPWR VPWR sky130_fd_sc_hd__fill_2
XFILLER_0_4_236 VGND VGND VPWR VPWR sky130_fd_sc_hd__decap_4
XFILLER_0_20_52 VGND VGND VPWR VPWR sky130_fd_sc_hd__decap_3
X_4472_ _1257_ _1260_ _1122_ VGND VGND VPWR VPWR _1261_ sky130_fd_sc_hd__mux2_1
X_7260_ registers\[18\]\[4\] _3443_ _3539_ VGND VGND VPWR VPWR _3544_ sky130_fd_sc_hd__mux2_1
XFILLER_0_80_481 VGND VGND VPWR VPWR sky130_fd_sc_hd__fill_2
XFILLER_0_13_537 VGND VGND VPWR VPWR sky130_fd_sc_hd__fill_2
XFILLER_0_13_548 VGND VGND VPWR VPWR sky130_fd_sc_hd__fill_2
XFILLER_0_20_85 VGND VGND VPWR VPWR sky130_fd_sc_hd__fill_2
XANTENNA__4514__B1 _1142_ VGND VGND VPWR VPWR sky130_fd_sc_hd__diode_2
X_7191_ _3507_ VGND VGND VPWR VPWR _0028_ sky130_fd_sc_hd__clkbuf_1
X_6211_ _2168_ _2916_ VGND VGND VPWR VPWR _2918_ sky130_fd_sc_hd__or2_1
XANTENNA__8396__S _4139_ VGND VGND VPWR VPWR sky130_fd_sc_hd__diode_2
XFILLER_0_96_56 VGND VGND VPWR VPWR sky130_fd_sc_hd__fill_2
X_6142_ _2391_ VGND VGND VPWR VPWR _2853_ sky130_fd_sc_hd__inv_2
XANTENNA__8256__A1 _3485_ VGND VGND VPWR VPWR sky130_fd_sc_hd__diode_2
XFILLER_0_0_475 VGND VGND VPWR VPWR sky130_fd_sc_hd__fill_1
X_6073_ _2725_ _2787_ _2460_ VGND VGND VPWR VPWR _2788_ sky130_fd_sc_hd__mux2_1
XANTENNA__5165__S1 _1759_ VGND VGND VPWR VPWR sky130_fd_sc_hd__diode_2
X_5024_ registers\[24\]\[7\] registers\[25\]\[7\] registers\[26\]\[7\] registers\[27\]\[7\]
+ _1628_ _1629_ VGND VGND VPWR VPWR _1785_ sky130_fd_sc_hd__mux4_1
XANTENNA__6644__S _3197_ VGND VGND VPWR VPWR sky130_fd_sc_hd__diode_2
XTAP_TAPCELL_ROW_49_893 VGND VPWR sky130_fd_sc_hd__tapvpwrvgnd_1
XTAP_TAPCELL_ROW_105_1630 VGND VPWR sky130_fd_sc_hd__tapvpwrvgnd_1
X_6975_ _3098_ registers\[14\]\[14\] _3372_ VGND VGND VPWR VPWR _3377_ sky130_fd_sc_hd__mux2_1
XFILLER_0_95_518 VGND VGND VPWR VPWR sky130_fd_sc_hd__fill_1
X_8714_ clknet_leaf_41_clk _0835_ VGND VGND VPWR VPWR registers\[10\]\[10\] sky130_fd_sc_hd__dfxtp_1
XFILLER_0_88_581 VGND VGND VPWR VPWR sky130_fd_sc_hd__fill_1
X_5926_ _2647_ _2648_ VGND VGND VPWR VPWR _2649_ sky130_fd_sc_hd__xnor2_1
XANTENNA__7519__A0 _3131_ VGND VGND VPWR VPWR sky130_fd_sc_hd__diode_2
XFILLER_0_118_322 VGND VGND VPWR VPWR sky130_fd_sc_hd__fill_1
X_8645_ clknet_leaf_32_clk _0766_ VGND VGND VPWR VPWR registers\[7\]\[5\] sky130_fd_sc_hd__dfxtp_1
XFILLER_0_91_713 VGND VGND VPWR VPWR sky130_fd_sc_hd__decap_4
XFILLER_0_48_467 VGND VGND VPWR VPWR sky130_fd_sc_hd__fill_2
XFILLER_0_91_724 VGND VGND VPWR VPWR sky130_fd_sc_hd__fill_2
X_5857_ _2495_ _2579_ _2583_ VGND VGND VPWR VPWR _2584_ sky130_fd_sc_hd__a21o_1
XANTENNA__4428__S0 _1196_ VGND VGND VPWR VPWR sky130_fd_sc_hd__diode_2
XANTENNA__5784__A _1145_ VGND VGND VPWR VPWR sky130_fd_sc_hd__diode_2
XFILLER_0_63_415 VGND VGND VPWR VPWR sky130_fd_sc_hd__fill_2
XANTENNA__7475__S _3648_ VGND VGND VPWR VPWR sky130_fd_sc_hd__diode_2
XFILLER_0_90_234 VGND VGND VPWR VPWR sky130_fd_sc_hd__fill_2
X_5788_ _1780_ _2517_ VGND VGND VPWR VPWR _2518_ sky130_fd_sc_hd__and2_1
X_8576_ clknet_leaf_5_clk _0697_ VGND VGND VPWR VPWR registers\[3\]\[0\] sky130_fd_sc_hd__dfxtp_1
X_4808_ _1577_ _1578_ _1513_ VGND VGND VPWR VPWR _1579_ sky130_fd_sc_hd__mux2_1
XFILLER_0_35_139 VGND VGND VPWR VPWR sky130_fd_sc_hd__fill_2
XFILLER_0_44_684 VGND VGND VPWR VPWR sky130_fd_sc_hd__decap_3
X_4739_ registers\[0\]\[25\] registers\[1\]\[25\] registers\[2\]\[25\] registers\[3\]\[25\]
+ _1404_ _1405_ VGND VGND VPWR VPWR _1514_ sky130_fd_sc_hd__mux4_1
X_7527_ _3071_ registers\[22\]\[1\] _3684_ VGND VGND VPWR VPWR _3686_ sky130_fd_sc_hd__mux2_1
XFILLER_0_102_712 VPWR VGND VPWR VGND sky130_ef_sc_hd__decap_12
X_7458_ _3649_ VGND VGND VPWR VPWR _0153_ sky130_fd_sc_hd__clkbuf_1
XFILLER_0_16_386 VGND VGND VPWR VPWR sky130_fd_sc_hd__fill_2
XFILLER_0_31_312 VGND VGND VPWR VPWR sky130_fd_sc_hd__decap_3
XTAP_TAPCELL_ROW_116_1770 VGND VPWR sky130_fd_sc_hd__tapvpwrvgnd_1
X_6409_ registers\[3\]\[24\] _3012_ _3052_ VGND VGND VPWR VPWR _3057_ sky130_fd_sc_hd__mux2_1
XANTENNA__6819__S _3288_ VGND VGND VPWR VPWR sky130_fd_sc_hd__diode_2
XFILLER_0_101_233 VGND VGND VPWR VPWR sky130_fd_sc_hd__fill_2
X_7389_ registers\[20\]\[0\] _3433_ _3612_ VGND VGND VPWR VPWR _3613_ sky130_fd_sc_hd__mux2_1
X_9128_ clknet_leaf_7_clk _0225_ VGND VGND VPWR VPWR registers\[23\]\[8\] sky130_fd_sc_hd__dfxtp_1
XANTENNA__5156__S1 _1774_ VGND VGND VPWR VPWR sky130_fd_sc_hd__diode_2
X_9059_ clknet_leaf_22_clk _0156_ VGND VGND VPWR VPWR registers\[21\]\[3\] sky130_fd_sc_hd__dfxtp_1
XFILLER_0_98_323 VGND VGND VPWR VPWR sky130_fd_sc_hd__decap_4
XTAP_TAPCELL_ROW_67_1124 VGND VPWR sky130_fd_sc_hd__tapvpwrvgnd_1
XANTENNA__4863__A net3 VGND VGND VPWR VPWR sky130_fd_sc_hd__diode_2
XFILLER_0_86_529 VGND VGND VPWR VPWR sky130_fd_sc_hd__decap_3
XTAP_TAPCELL_ROW_67_1135 VGND VPWR sky130_fd_sc_hd__tapvpwrvgnd_1
XANTENNA__6430__A0 _3065_ VGND VGND VPWR VPWR sky130_fd_sc_hd__diode_2
XFILLER_0_79_592 VPWR VGND VPWR VGND sky130_ef_sc_hd__decap_12
XTAP_TAPCELL_ROW_80_1302 VGND VPWR sky130_fd_sc_hd__tapvpwrvgnd_1
XANTENNA__4667__S0 _1427_ VGND VGND VPWR VPWR sky130_fd_sc_hd__diode_2
XFILLER_0_109_311 VGND VGND VPWR VPWR sky130_fd_sc_hd__fill_2
XFILLER_0_94_551 VGND VGND VPWR VPWR sky130_fd_sc_hd__fill_2
XFILLER_0_66_231 VGND VGND VPWR VPWR sky130_fd_sc_hd__decap_4
XFILLER_0_54_437 VGND VGND VPWR VPWR sky130_fd_sc_hd__fill_2
XFILLER_0_109_366 VGND VGND VPWR VPWR sky130_fd_sc_hd__fill_2
XFILLER_0_19_180 VGND VGND VPWR VPWR sky130_fd_sc_hd__fill_2
XFILLER_0_35_651 VGND VGND VPWR VPWR sky130_fd_sc_hd__decap_3
XANTENNA__5941__C1 _1882_ VGND VGND VPWR VPWR sky130_fd_sc_hd__diode_2
XFILLER_0_50_610 VGND VGND VPWR VPWR sky130_fd_sc_hd__fill_2
XFILLER_0_41_109 VGND VGND VPWR VPWR sky130_fd_sc_hd__fill_1
XFILLER_0_105_572 VGND VGND VPWR VPWR sky130_fd_sc_hd__decap_4
XFILLER_0_105_561 VGND VGND VPWR VPWR sky130_fd_sc_hd__decap_4
XFILLER_0_22_312 VGND VGND VPWR VPWR sky130_fd_sc_hd__decap_4
XFILLER_0_22_334 VGND VGND VPWR VPWR sky130_fd_sc_hd__fill_2
XFILLER_0_34_172 VGND VGND VPWR VPWR sky130_fd_sc_hd__fill_2
XTAP_TAPCELL_ROW_78_1275 VGND VPWR sky130_fd_sc_hd__tapvpwrvgnd_1
XFILLER_0_50_665 VGND VGND VPWR VPWR sky130_fd_sc_hd__fill_2
XFILLER_0_22_378 VGND VGND VPWR VPWR sky130_fd_sc_hd__fill_1
XANTENNA__6729__S _3236_ VGND VGND VPWR VPWR sky130_fd_sc_hd__diode_2
XTAP_TAPCELL_ROW_91_1442 VGND VPWR sky130_fd_sc_hd__tapvpwrvgnd_1
XANTENNA__5147__S1 _1811_ VGND VGND VPWR VPWR sky130_fd_sc_hd__diode_2
XANTENNA__6464__S _3090_ VGND VGND VPWR VPWR sky130_fd_sc_hd__diode_2
XANTENNA__8410__A1 net16 VGND VGND VPWR VPWR sky130_fd_sc_hd__diode_2
XTAP_TAPCELL_ROW_46_852 VGND VPWR sky130_fd_sc_hd__tapvpwrvgnd_1
X_6760_ registers\[11\]\[10\] _2982_ _3261_ VGND VGND VPWR VPWR _3262_ sky130_fd_sc_hd__mux2_1
XTAP_TAPCELL_ROW_46_863 VGND VPWR sky130_fd_sc_hd__tapvpwrvgnd_1
X_5711_ _2442_ _2443_ _2403_ VGND VGND VPWR VPWR _2444_ sky130_fd_sc_hd__mux2_1
XFILLER_0_85_551 VGND VGND VPWR VPWR sky130_fd_sc_hd__fill_2
XFILLER_0_45_404 VGND VGND VPWR VPWR sky130_fd_sc_hd__fill_2
XFILLER_0_15_85 VGND VGND VPWR VPWR sky130_fd_sc_hd__decap_4
XFILLER_0_72_201 VGND VGND VPWR VPWR sky130_fd_sc_hd__decap_4
X_6691_ _3213_ VGND VGND VPWR VPWR _3225_ sky130_fd_sc_hd__clkbuf_8
XTAP_TAPCELL_ROW_100_1560 VGND VPWR sky130_fd_sc_hd__tapvpwrvgnd_1
XFILLER_0_93_7 VGND VGND VPWR VPWR sky130_fd_sc_hd__fill_2
X_5642_ _1070_ _2376_ VGND VGND VPWR VPWR _2377_ sky130_fd_sc_hd__or2_1
X_8430_ _4152_ VGND VGND VPWR VPWR _4164_ sky130_fd_sc_hd__clkbuf_8
X_5573_ _2301_ _2306_ _2308_ VGND VGND VPWR VPWR _2309_ sky130_fd_sc_hd__mux2_1
XANTENNA__5932__C1 net15 VGND VGND VPWR VPWR sky130_fd_sc_hd__diode_2
X_8361_ _4127_ VGND VGND VPWR VPWR _0578_ sky130_fd_sc_hd__clkbuf_1
XFILLER_0_5_534 VGND VGND VPWR VPWR sky130_fd_sc_hd__decap_3
XFILLER_0_32_109 VGND VGND VPWR VPWR sky130_fd_sc_hd__fill_2
X_4524_ _1135_ _1309_ VGND VGND VPWR VPWR _1310_ sky130_fd_sc_hd__nand2_1
XFILLER_0_41_621 VGND VGND VPWR VPWR sky130_fd_sc_hd__fill_2
XFILLER_0_5_589 VGND VGND VPWR VPWR sky130_fd_sc_hd__fill_1
X_7312_ registers\[18\]\[29\] _3495_ _3561_ VGND VGND VPWR VPWR _3571_ sky130_fd_sc_hd__mux2_1
X_8292_ _2980_ registers\[31\]\[9\] _4081_ VGND VGND VPWR VPWR _4091_ sky130_fd_sc_hd__mux2_1
XANTENNA__6488__A0 _3108_ VGND VGND VPWR VPWR sky130_fd_sc_hd__diode_2
XFILLER_0_41_665 VGND VGND VPWR VPWR sky130_fd_sc_hd__decap_6
XFILLER_0_40_153 VGND VGND VPWR VPWR sky130_fd_sc_hd__decap_3
X_4455_ _1241_ _1242_ _1243_ _1244_ _1131_ _1025_ VGND VGND VPWR VPWR _1245_ sky130_fd_sc_hd__mux4_1
XANTENNA__6639__S _3186_ VGND VGND VPWR VPWR sky130_fd_sc_hd__diode_2
X_7243_ _3534_ VGND VGND VPWR VPWR _0053_ sky130_fd_sc_hd__clkbuf_1
XFILLER_0_13_389 VGND VGND VPWR VPWR sky130_fd_sc_hd__decap_3
X_4386_ registers\[4\]\[6\] registers\[5\]\[6\] registers\[6\]\[6\] registers\[7\]\[6\]
+ _1136_ _1137_ VGND VGND VPWR VPWR _1180_ sky130_fd_sc_hd__mux4_1
XANTENNA__8229__A1 _3458_ VGND VGND VPWR VPWR sky130_fd_sc_hd__diode_2
XFILLER_0_40_197 VGND VGND VPWR VPWR sky130_fd_sc_hd__fill_1
X_7174_ _3496_ VGND VGND VPWR VPWR _0022_ sky130_fd_sc_hd__clkbuf_1
X_6125_ _2834_ _2836_ VGND VGND VPWR VPWR _2837_ sky130_fd_sc_hd__and2_1
XANTENNA__7988__A0 _3016_ VGND VGND VPWR VPWR sky130_fd_sc_hd__diode_2
X_6056_ _2011_ _2771_ VGND VGND VPWR VPWR _2772_ sky130_fd_sc_hd__xnor2_2
X_5007_ _1761_ _1766_ _1768_ VGND VGND VPWR VPWR _1769_ sky130_fd_sc_hd__mux2_1
XANTENNA__4683__A _1421_ VGND VGND VPWR VPWR sky130_fd_sc_hd__diode_2
XFILLER_0_68_529 VGND VGND VPWR VPWR sky130_fd_sc_hd__decap_3
XANTENNA__4649__S0 _1427_ VGND VGND VPWR VPWR sky130_fd_sc_hd__diode_2
X_6958_ _3081_ registers\[14\]\[6\] _3361_ VGND VGND VPWR VPWR _3368_ sky130_fd_sc_hd__mux2_1
XFILLER_0_48_253 VGND VGND VPWR VPWR sky130_fd_sc_hd__decap_4
XFILLER_0_118_141 VPWR VGND VPWR VGND sky130_ef_sc_hd__decap_12
X_6889_ _3081_ registers\[13\]\[6\] _3324_ VGND VGND VPWR VPWR _3331_ sky130_fd_sc_hd__mux2_1
X_5909_ _2281_ _2288_ VGND VGND VPWR VPWR _2633_ sky130_fd_sc_hd__nand2_1
XANTENNA__5718__S _1072_ VGND VGND VPWR VPWR sky130_fd_sc_hd__diode_2
XTAP_TAPCELL_ROW_24_568 VGND VPWR sky130_fd_sc_hd__tapvpwrvgnd_1
XFILLER_0_119_697 VGND VGND VPWR VPWR sky130_fd_sc_hd__decap_3
XFILLER_0_118_174 VGND VGND VPWR VPWR sky130_fd_sc_hd__fill_2
XPHY_EDGE_ROW_101_Left_221 VGND VGND VPWR VPWR sky130_fd_sc_hd__decap_3
XFILLER_0_91_532 VGND VGND VPWR VPWR sky130_fd_sc_hd__fill_2
XFILLER_0_63_234 VGND VGND VPWR VPWR sky130_fd_sc_hd__fill_2
XTAP_TAPCELL_ROW_62_1065 VGND VPWR sky130_fd_sc_hd__tapvpwrvgnd_1
XANTENNA__4622__S _1124_ VGND VGND VPWR VPWR sky130_fd_sc_hd__diode_2
X_8628_ clknet_leaf_74_clk _0749_ VGND VGND VPWR VPWR registers\[29\]\[20\] sky130_fd_sc_hd__dfxtp_1
X_8559_ clknet_leaf_46_clk _0680_ VGND VGND VPWR VPWR registers\[19\]\[15\] sky130_fd_sc_hd__dfxtp_1
XFILLER_0_51_429 VGND VGND VPWR VPWR sky130_fd_sc_hd__fill_2
XFILLER_0_17_673 VGND VGND VPWR VPWR sky130_fd_sc_hd__decap_6
XANTENNA__5019__A _1780_ VGND VGND VPWR VPWR sky130_fd_sc_hd__diode_2
XFILLER_0_44_481 VGND VGND VPWR VPWR sky130_fd_sc_hd__decap_4
XANTENNA__8468__A1 net36 VGND VGND VPWR VPWR sky130_fd_sc_hd__diode_2
XFILLER_0_31_153 VGND VGND VPWR VPWR sky130_fd_sc_hd__fill_2
XFILLER_0_6_3 VGND VGND VPWR VPWR sky130_fd_sc_hd__fill_2
XFILLER_0_31_197 VGND VGND VPWR VPWR sky130_fd_sc_hd__fill_2
XPHY_EDGE_ROW_110_Left_230 VGND VGND VPWR VPWR sky130_fd_sc_hd__decap_3
XANTENNA__5129__S1 _1774_ VGND VGND VPWR VPWR sky130_fd_sc_hd__diode_2
XANTENNA_input20_A wd3[13] VGND VGND VPWR VPWR sky130_fd_sc_hd__diode_2
XANTENNA__5454__A1 _2081_ VGND VGND VPWR VPWR sky130_fd_sc_hd__diode_2
XFILLER_0_36_29 VGND VGND VPWR VPWR sky130_fd_sc_hd__fill_2
XFILLER_0_98_153 VGND VGND VPWR VPWR sky130_fd_sc_hd__decap_3
XFILLER_0_86_348 VGND VGND VPWR VPWR sky130_fd_sc_hd__fill_2
XFILLER_0_67_540 VGND VGND VPWR VPWR sky130_fd_sc_hd__fill_2
XTAP_TAPCELL_ROW_43_822 VGND VPWR sky130_fd_sc_hd__tapvpwrvgnd_1
XFILLER_0_27_426 VGND VGND VPWR VPWR sky130_fd_sc_hd__fill_1
XANTENNA__6706__A1 _2997_ VGND VGND VPWR VPWR sky130_fd_sc_hd__diode_2
XANTENNA__6313__A net25 VGND VGND VPWR VPWR sky130_fd_sc_hd__diode_2
XANTENNA__7409__A _3611_ VGND VGND VPWR VPWR sky130_fd_sc_hd__diode_2
XANTENNA__8004__S _3937_ VGND VGND VPWR VPWR sky130_fd_sc_hd__diode_2
XFILLER_0_82_565 VGND VGND VPWR VPWR sky130_fd_sc_hd__decap_4
XANTENNA__5065__S0 _1820_ VGND VGND VPWR VPWR sky130_fd_sc_hd__diode_2
XANTENNA__5390__B1 _2026_ VGND VGND VPWR VPWR sky130_fd_sc_hd__diode_2
XANTENNA__5368__S1 _2109_ VGND VGND VPWR VPWR sky130_fd_sc_hd__diode_2
X_4240_ a2[1] VGND VGND VPWR VPWR _1040_ sky130_fd_sc_hd__clkbuf_4
XANTENNA__7144__A net28 VGND VGND VPWR VPWR sky130_fd_sc_hd__diode_2
X_7930_ _3133_ registers\[27\]\[31\] _3864_ VGND VGND VPWR VPWR _3899_ sky130_fd_sc_hd__mux2_1
XFILLER_0_89_164 VGND VGND VPWR VPWR sky130_fd_sc_hd__fill_2
XFILLER_0_77_315 VGND VGND VPWR VPWR sky130_fd_sc_hd__decap_3
X_7861_ _3862_ VGND VGND VPWR VPWR _0343_ sky130_fd_sc_hd__clkbuf_1
XANTENNA__7198__A1 _3449_ VGND VGND VPWR VPWR sky130_fd_sc_hd__diode_2
X_6812_ _3290_ VGND VGND VPWR VPWR _0890_ sky130_fd_sc_hd__clkbuf_1
XFILLER_0_58_562 VGND VGND VPWR VPWR sky130_fd_sc_hd__fill_2
X_7792_ _3131_ registers\[25\]\[30\] _3792_ VGND VGND VPWR VPWR _3826_ sky130_fd_sc_hd__mux2_1
XFILLER_0_58_584 VGND VGND VPWR VPWR sky130_fd_sc_hd__fill_1
XFILLER_0_46_713 VGND VGND VPWR VPWR sky130_fd_sc_hd__fill_1
X_6743_ registers\[11\]\[2\] _2966_ _3250_ VGND VGND VPWR VPWR _3253_ sky130_fd_sc_hd__mux2_1
XFILLER_0_18_404 VGND VGND VPWR VPWR sky130_fd_sc_hd__fill_2
X_9531_ clknet_leaf_101_clk _0628_ VGND VGND VPWR VPWR registers\[8\]\[27\] sky130_fd_sc_hd__dfxtp_1
XFILLER_0_116_601 VGND VGND VPWR VPWR sky130_fd_sc_hd__fill_2
XFILLER_0_73_554 VGND VGND VPWR VPWR sky130_fd_sc_hd__fill_2
XANTENNA__7319__A _3574_ VGND VGND VPWR VPWR sky130_fd_sc_hd__diode_2
X_6674_ _3216_ VGND VGND VPWR VPWR _0826_ sky130_fd_sc_hd__clkbuf_1
X_9462_ clknet_leaf_94_clk _0559_ VGND VGND VPWR VPWR registers\[31\]\[22\] sky130_fd_sc_hd__dfxtp_1
XFILLER_0_9_169 VGND VGND VPWR VPWR sky130_fd_sc_hd__decap_3
XFILLER_0_18_437 VGND VGND VPWR VPWR sky130_fd_sc_hd__fill_2
XTAP_TAPCELL_ROW_21_527 VGND VPWR sky130_fd_sc_hd__tapvpwrvgnd_1
XFILLER_0_116_645 VPWR VGND VPWR VGND sky130_ef_sc_hd__decap_12
XFILLER_0_115_122 VGND VGND VPWR VPWR sky130_fd_sc_hd__fill_2
X_5625_ _2353_ _2326_ _2358_ _2359_ VGND VGND VPWR VPWR _2360_ sky130_fd_sc_hd__a31o_1
XANTENNA__5056__S0 _1757_ VGND VGND VPWR VPWR sky130_fd_sc_hd__diode_2
XFILLER_0_61_705 VGND VGND VPWR VPWR sky130_fd_sc_hd__decap_4
X_8413_ _4155_ VGND VGND VPWR VPWR _0602_ sky130_fd_sc_hd__clkbuf_1
XTAP_TAPCELL_ROW_21_538 VGND VPWR sky130_fd_sc_hd__tapvpwrvgnd_1
XFILLER_0_33_418 VGND VGND VPWR VPWR sky130_fd_sc_hd__fill_1
XANTENNA__7753__S _3804_ VGND VGND VPWR VPWR sky130_fd_sc_hd__diode_2
XFILLER_0_115_133 VGND VGND VPWR VPWR sky130_fd_sc_hd__fill_2
X_9393_ clknet_leaf_62_clk _0490_ VGND VGND VPWR VPWR registers\[9\]\[17\] sky130_fd_sc_hd__dfxtp_1
XANTENNA__7370__A1 _3485_ VGND VGND VPWR VPWR sky130_fd_sc_hd__diode_2
XANTENNA__4803__S0 _1555_ VGND VGND VPWR VPWR sky130_fd_sc_hd__diode_2
XFILLER_0_115_188 VGND VGND VPWR VPWR sky130_fd_sc_hd__fill_2
XFILLER_0_115_177 VGND VGND VPWR VPWR sky130_fd_sc_hd__fill_1
XFILLER_0_103_328 VGND VGND VPWR VPWR sky130_fd_sc_hd__decap_4
X_5556_ _2290_ _2291_ _1051_ VGND VGND VPWR VPWR _2292_ sky130_fd_sc_hd__mux2_1
X_8344_ registers\[5\]\[1\] _3437_ _4117_ VGND VGND VPWR VPWR _4119_ sky130_fd_sc_hd__mux2_1
XANTENNA__6369__S _3030_ VGND VGND VPWR VPWR sky130_fd_sc_hd__diode_2
X_5487_ _1995_ _2216_ _2217_ VGND VGND VPWR VPWR _2223_ sky130_fd_sc_hd__o21ai_1
X_4507_ registers\[12\]\[13\] registers\[13\]\[13\] registers\[14\]\[13\] registers\[15\]\[13\]
+ _1160_ _1161_ VGND VGND VPWR VPWR _1294_ sky130_fd_sc_hd__mux4_1
XFILLER_0_41_495 VGND VGND VPWR VPWR sky130_fd_sc_hd__fill_2
XFILLER_0_41_462 VGND VGND VPWR VPWR sky130_fd_sc_hd__fill_2
X_8275_ _4082_ VGND VGND VPWR VPWR _0537_ sky130_fd_sc_hd__clkbuf_1
XFILLER_0_14_698 VGND VGND VPWR VPWR sky130_fd_sc_hd__fill_2
XFILLER_0_111_372 VGND VGND VPWR VPWR sky130_fd_sc_hd__fill_1
X_4438_ registers\[24\]\[9\] registers\[25\]\[9\] registers\[26\]\[9\] registers\[27\]\[9\]
+ _1053_ _1054_ VGND VGND VPWR VPWR _1229_ sky130_fd_sc_hd__mux4_1
X_7226_ registers\[17\]\[20\] _3476_ _3525_ VGND VGND VPWR VPWR _3526_ sky130_fd_sc_hd__mux2_1
X_4369_ _1162_ _1163_ _1140_ VGND VGND VPWR VPWR _1164_ sky130_fd_sc_hd__mux2_1
XFILLER_0_6_94 VGND VGND VPWR VPWR sky130_fd_sc_hd__fill_2
X_7157_ net32 VGND VGND VPWR VPWR _3485_ sky130_fd_sc_hd__buf_2
X_6108_ _2819_ _2820_ VGND VGND VPWR VPWR _2821_ sky130_fd_sc_hd__nor2_1
X_7088_ _3438_ VGND VGND VPWR VPWR _1018_ sky130_fd_sc_hd__clkbuf_1
X_6039_ _2675_ VGND VGND VPWR VPWR _2756_ sky130_fd_sc_hd__inv_2
XTAP_TAPCELL_ROW_29_638 VGND VPWR sky130_fd_sc_hd__tapvpwrvgnd_1
XTAP_TAPCELL_ROW_1_274 VGND VPWR sky130_fd_sc_hd__tapvpwrvgnd_1
XANTENNA__7928__S _3864_ VGND VGND VPWR VPWR sky130_fd_sc_hd__diode_2
XANTENNA__6832__S _3299_ VGND VGND VPWR VPWR sky130_fd_sc_hd__diode_2
XFILLER_0_49_595 VGND VGND VPWR VPWR sky130_fd_sc_hd__fill_2
XANTENNA__5295__S0 _1806_ VGND VGND VPWR VPWR sky130_fd_sc_hd__diode_2
XFILLER_0_119_472 VGND VGND VPWR VPWR sky130_fd_sc_hd__fill_1
XFILLER_0_119_494 VGND VGND VPWR VPWR sky130_fd_sc_hd__decap_8
XFILLER_0_107_623 VGND VGND VPWR VPWR sky130_fd_sc_hd__fill_2
XANTENNA__5047__S0 _1806_ VGND VGND VPWR VPWR sky130_fd_sc_hd__diode_2
XFILLER_0_64_576 VGND VGND VPWR VPWR sky130_fd_sc_hd__fill_2
XFILLER_0_24_407 VGND VGND VPWR VPWR sky130_fd_sc_hd__decap_4
XFILLER_0_17_492 VGND VGND VPWR VPWR sky130_fd_sc_hd__fill_2
XTAP_TAPCELL_ROW_75_1234 VGND VPWR sky130_fd_sc_hd__tapvpwrvgnd_1
XANTENNA__5124__B1 _1655_ VGND VGND VPWR VPWR sky130_fd_sc_hd__diode_2
XFILLER_0_47_28 VGND VGND VPWR VPWR sky130_fd_sc_hd__fill_2
XTAP_TAPCELL_ROW_9_374 VGND VPWR sky130_fd_sc_hd__tapvpwrvgnd_1
XANTENNA__8494__S _4189_ VGND VGND VPWR VPWR sky130_fd_sc_hd__diode_2
XANTENNA__4527__S _1140_ VGND VGND VPWR VPWR sky130_fd_sc_hd__diode_2
XFILLER_0_99_473 VGND VGND VPWR VPWR sky130_fd_sc_hd__fill_2
XTAP_TAPCELL_ROW_86_1374 VGND VPWR sky130_fd_sc_hd__tapvpwrvgnd_1
XFILLER_0_86_156 VGND VGND VPWR VPWR sky130_fd_sc_hd__fill_2
XTAP_TAPCELL_ROW_56_991 VGND VPWR sky130_fd_sc_hd__tapvpwrvgnd_1
XFILLER_0_103_11 VPWR VGND VPWR VGND sky130_ef_sc_hd__decap_12
XFILLER_0_6_106 VGND VGND VPWR VPWR sky130_fd_sc_hd__fill_2
Xclkbuf_leaf_106_clk clknet_4_2_0_clk VGND VGND VPWR VPWR clknet_leaf_106_clk sky130_fd_sc_hd__clkbuf_8
XFILLER_0_27_212 VGND VGND VPWR VPWR sky130_fd_sc_hd__fill_2
XFILLER_0_103_66 VGND VGND VPWR VPWR sky130_fd_sc_hd__decap_4
XFILLER_0_82_362 VGND VGND VPWR VPWR sky130_fd_sc_hd__fill_2
XFILLER_0_55_576 VGND VGND VPWR VPWR sky130_fd_sc_hd__fill_2
XFILLER_0_103_88 VGND VGND VPWR VPWR sky130_fd_sc_hd__fill_2
XFILLER_0_82_384 VGND VGND VPWR VPWR sky130_fd_sc_hd__fill_2
XFILLER_0_82_373 VGND VGND VPWR VPWR sky130_fd_sc_hd__fill_1
XANTENNA__7573__S _3706_ VGND VGND VPWR VPWR sky130_fd_sc_hd__diode_2
X_6390_ registers\[3\]\[15\] _2993_ _3041_ VGND VGND VPWR VPWR _3047_ sky130_fd_sc_hd__mux2_1
X_5410_ _2148_ _2149_ _2081_ VGND VGND VPWR VPWR _2150_ sky130_fd_sc_hd__mux2_1
XFILLER_0_2_301 VGND VGND VPWR VPWR sky130_fd_sc_hd__decap_4
XFILLER_0_112_136 VGND VGND VPWR VPWR sky130_fd_sc_hd__fill_2
XANTENNA__8301__A0 _2989_ VGND VGND VPWR VPWR sky130_fd_sc_hd__diode_2
XFILLER_0_88_68 VGND VGND VPWR VPWR sky130_fd_sc_hd__fill_2
XANTENNA__6189__S _2353_ VGND VGND VPWR VPWR sky130_fd_sc_hd__diode_2
Xoutput115 net115 VGND VGND VPWR VPWR rd2[11] sky130_fd_sc_hd__buf_1
XANTENNA_clkbuf_leaf_71_clk_A clknet_4_11_0_clk VGND VGND VPWR VPWR sky130_fd_sc_hd__diode_2
XFILLER_0_2_356 VGND VGND VPWR VPWR sky130_fd_sc_hd__fill_2
Xoutput104 net104 VGND VGND VPWR VPWR rd1[30] sky130_fd_sc_hd__buf_1
X_5341_ _2084_ VGND VGND VPWR VPWR net97 sky130_fd_sc_hd__inv_2
XFILLER_0_100_309 VGND VGND VPWR VPWR sky130_fd_sc_hd__fill_2
Xoutput126 net126 VGND VGND VPWR VPWR rd2[21] sky130_fd_sc_hd__buf_1
Xoutput137 net137 VGND VGND VPWR VPWR rd2[31] sky130_fd_sc_hd__buf_1
X_8060_ registers\[2\]\[28\] _3493_ _3959_ VGND VGND VPWR VPWR _3968_ sky130_fd_sc_hd__mux2_1
X_5272_ _1754_ VGND VGND VPWR VPWR _2019_ sky130_fd_sc_hd__buf_4
X_7011_ _3395_ VGND VGND VPWR VPWR _0984_ sky130_fd_sc_hd__clkbuf_1
XANTENNA_clkbuf_leaf_86_clk_A clknet_4_8_0_clk VGND VGND VPWR VPWR sky130_fd_sc_hd__diode_2
X_8962_ clknet_leaf_1_clk _0059_ VGND VGND VPWR VPWR registers\[18\]\[2\] sky130_fd_sc_hd__dfxtp_1
XFILLER_0_37_61 VGND VGND VPWR VPWR sky130_fd_sc_hd__fill_2
XANTENNA__5122__A _1752_ VGND VGND VPWR VPWR sky130_fd_sc_hd__diode_2
X_7913_ _3890_ VGND VGND VPWR VPWR _0367_ sky130_fd_sc_hd__clkbuf_1
XFILLER_0_78_624 VGND VGND VPWR VPWR sky130_fd_sc_hd__fill_2
XANTENNA__7748__S _3793_ VGND VGND VPWR VPWR sky130_fd_sc_hd__diode_2
X_8893_ clknet_leaf_105_clk _1014_ VGND VGND VPWR VPWR registers\[15\]\[29\] sky130_fd_sc_hd__dfxtp_1
XANTENNA__6652__S _3197_ VGND VGND VPWR VPWR sky130_fd_sc_hd__diode_2
X_7844_ _3115_ registers\[26\]\[22\] _3851_ VGND VGND VPWR VPWR _3854_ sky130_fd_sc_hd__mux2_1
X_7775_ _3817_ VGND VGND VPWR VPWR _0302_ sky130_fd_sc_hd__clkbuf_1
X_9514_ clknet_leaf_41_clk _0611_ VGND VGND VPWR VPWR registers\[8\]\[10\] sky130_fd_sc_hd__dfxtp_1
XFILLER_0_92_137 VGND VGND VPWR VPWR sky130_fd_sc_hd__decap_3
X_4987_ _1706_ VGND VGND VPWR VPWR _1749_ sky130_fd_sc_hd__buf_4
XANTENNA_clkbuf_leaf_24_clk_A clknet_4_4_0_clk VGND VGND VPWR VPWR sky130_fd_sc_hd__diode_2
X_6726_ _3243_ VGND VGND VPWR VPWR _0851_ sky130_fd_sc_hd__clkbuf_1
XFILLER_0_61_502 VGND VGND VPWR VPWR sky130_fd_sc_hd__fill_2
XTAP_TAPCELL_ROW_34_696 VGND VPWR sky130_fd_sc_hd__tapvpwrvgnd_1
XFILLER_0_116_453 VGND VGND VPWR VPWR sky130_fd_sc_hd__fill_2
XFILLER_0_116_442 VGND VGND VPWR VPWR sky130_fd_sc_hd__decap_4
XANTENNA__7343__A1 _3458_ VGND VGND VPWR VPWR sky130_fd_sc_hd__diode_2
X_9445_ clknet_leaf_26_clk _0542_ VGND VGND VPWR VPWR registers\[31\]\[5\] sky130_fd_sc_hd__dfxtp_1
XFILLER_0_73_384 VGND VGND VPWR VPWR sky130_fd_sc_hd__fill_2
X_6657_ _3205_ VGND VGND VPWR VPWR _0820_ sky130_fd_sc_hd__clkbuf_1
X_5608_ _2339_ _2342_ _2266_ VGND VGND VPWR VPWR _2343_ sky130_fd_sc_hd__mux2_1
X_9376_ clknet_leaf_5_clk _0473_ VGND VGND VPWR VPWR registers\[9\]\[0\] sky130_fd_sc_hd__dfxtp_1
X_6588_ registers\[7\]\[28\] _3020_ _3159_ VGND VGND VPWR VPWR _3168_ sky130_fd_sc_hd__mux2_1
XFILLER_0_5_150 VGND VGND VPWR VPWR sky130_fd_sc_hd__fill_2
XANTENNA__4900__S _1621_ VGND VGND VPWR VPWR sky130_fd_sc_hd__diode_2
Xclkbuf_4_2_0_clk clknet_0_clk VGND VGND VPWR VPWR clknet_4_2_0_clk sky130_fd_sc_hd__clkbuf_8
XANTENNA_clkbuf_leaf_39_clk_A clknet_4_7_0_clk VGND VGND VPWR VPWR sky130_fd_sc_hd__diode_2
X_5539_ _2274_ VGND VGND VPWR VPWR _2275_ sky130_fd_sc_hd__inv_2
X_8327_ _4109_ VGND VGND VPWR VPWR _0562_ sky130_fd_sc_hd__clkbuf_1
XFILLER_0_41_281 VGND VGND VPWR VPWR sky130_fd_sc_hd__fill_2
XFILLER_0_41_270 VGND VGND VPWR VPWR sky130_fd_sc_hd__fill_2
XFILLER_0_14_495 VGND VGND VPWR VPWR sky130_fd_sc_hd__fill_2
XFILLER_0_112_692 VGND VGND VPWR VPWR sky130_fd_sc_hd__decap_8
XANTENNA__5201__S0 _1773_ VGND VGND VPWR VPWR sky130_fd_sc_hd__diode_2
X_8258_ registers\[6\]\[25\] _3487_ _4067_ VGND VGND VPWR VPWR _4073_ sky130_fd_sc_hd__mux2_1
X_7209_ registers\[17\]\[12\] _3460_ _3514_ VGND VGND VPWR VPWR _3517_ sky130_fd_sc_hd__mux2_1
XANTENNA__6827__S _3288_ VGND VGND VPWR VPWR sky130_fd_sc_hd__diode_2
XTAP_TAPCELL_ROW_6_333 VGND VPWR sky130_fd_sc_hd__tapvpwrvgnd_1
X_8189_ _4036_ VGND VGND VPWR VPWR _0497_ sky130_fd_sc_hd__clkbuf_1
XTAP_TAPCELL_ROW_70_1164 VGND VPWR sky130_fd_sc_hd__tapvpwrvgnd_1
XTAP_TAPCELL_ROW_70_1175 VGND VPWR sky130_fd_sc_hd__tapvpwrvgnd_1
XFILLER_0_96_421 VGND VGND VPWR VPWR sky130_fd_sc_hd__fill_2
XFILLER_0_96_432 VGND VGND VPWR VPWR sky130_fd_sc_hd__fill_2
XFILLER_0_69_657 VGND VGND VPWR VPWR sky130_fd_sc_hd__fill_2
XFILLER_0_96_498 VGND VGND VPWR VPWR sky130_fd_sc_hd__fill_2
XFILLER_0_84_616 VGND VGND VPWR VPWR sky130_fd_sc_hd__decap_3
XANTENNA__7031__A0 _3085_ VGND VGND VPWR VPWR sky130_fd_sc_hd__diode_2
XTAP_TAPCELL_ROW_53_950 VGND VPWR sky130_fd_sc_hd__tapvpwrvgnd_1
XANTENNA__5268__S0 _1968_ VGND VGND VPWR VPWR sky130_fd_sc_hd__diode_2
XFILLER_0_107_453 VGND VGND VPWR VPWR sky130_fd_sc_hd__fill_2
Xinput17 wd3[10] VGND VGND VPWR VPWR net17 sky130_fd_sc_hd__clkbuf_2
XANTENNA__7334__A1 _3449_ VGND VGND VPWR VPWR sky130_fd_sc_hd__diode_2
Xinput28 wd3[20] VGND VGND VPWR VPWR net28 sky130_fd_sc_hd__clkbuf_4
XANTENNA__7393__S _3612_ VGND VGND VPWR VPWR sky130_fd_sc_hd__diode_2
Xinput39 wd3[30] VGND VGND VPWR VPWR net39 sky130_fd_sc_hd__clkbuf_2
XANTENNA__5896__B2 _2560_ VGND VGND VPWR VPWR sky130_fd_sc_hd__diode_2
XANTENNA__4243__S1 _1027_ VGND VGND VPWR VPWR sky130_fd_sc_hd__diode_2
XANTENNA__5440__S0 _1758_ VGND VGND VPWR VPWR sky130_fd_sc_hd__diode_2
XFILLER_0_58_38 VGND VGND VPWR VPWR sky130_fd_sc_hd__decap_3
XFILLER_0_20_421 VGND VGND VPWR VPWR sky130_fd_sc_hd__decap_4
XTAP_TAPCELL_ROW_88_1403 VGND VPWR sky130_fd_sc_hd__tapvpwrvgnd_1
XFILLER_0_99_281 VGND VGND VPWR VPWR sky130_fd_sc_hd__decap_3
XFILLER_0_75_605 VGND VGND VPWR VPWR sky130_fd_sc_hd__decap_4
X_5890_ _2613_ _2614_ VGND VGND VPWR VPWR _2615_ sky130_fd_sc_hd__nand2_1
X_4910_ _1616_ _1667_ _1675_ VGND VGND VPWR VPWR _1676_ sky130_fd_sc_hd__o21ai_4
XFILLER_0_90_69 VGND VGND VPWR VPWR sky130_fd_sc_hd__fill_2
XFILLER_0_87_487 VGND VGND VPWR VPWR sky130_fd_sc_hd__fill_2
XFILLER_0_59_156 VGND VGND VPWR VPWR sky130_fd_sc_hd__fill_2
XFILLER_0_23_30 VGND VGND VPWR VPWR sky130_fd_sc_hd__fill_2
XANTENNA__5259__S0 _1758_ VGND VGND VPWR VPWR sky130_fd_sc_hd__diode_2
X_4841_ _1389_ _1609_ VGND VGND VPWR VPWR _1610_ sky130_fd_sc_hd__or2_1
XFILLER_0_28_521 VGND VGND VPWR VPWR sky130_fd_sc_hd__fill_2
XFILLER_0_117_217 VGND VGND VPWR VPWR sky130_fd_sc_hd__decap_6
X_7560_ _3104_ registers\[22\]\[17\] _3695_ VGND VGND VPWR VPWR _3703_ sky130_fd_sc_hd__mux2_1
XFILLER_0_99_12 VGND VGND VPWR VPWR sky130_fd_sc_hd__fill_1
XFILLER_0_83_671 VGND VGND VPWR VPWR sky130_fd_sc_hd__fill_1
XFILLER_0_83_660 VGND VGND VPWR VPWR sky130_fd_sc_hd__decap_3
XFILLER_0_55_362 VGND VGND VPWR VPWR sky130_fd_sc_hd__fill_2
X_4772_ registers\[8\]\[27\] registers\[9\]\[27\] registers\[10\]\[27\] registers\[11\]\[27\]
+ _1404_ _1405_ VGND VGND VPWR VPWR _1545_ sky130_fd_sc_hd__mux4_1
XTAP_TAPCELL_ROW_99_1543 VGND VPWR sky130_fd_sc_hd__tapvpwrvgnd_1
X_7491_ _3666_ VGND VGND VPWR VPWR _0169_ sky130_fd_sc_hd__clkbuf_1
X_6511_ _3124_ VGND VGND VPWR VPWR _0755_ sky130_fd_sc_hd__clkbuf_1
XFILLER_0_28_587 VGND VGND VPWR VPWR sky130_fd_sc_hd__fill_1
XTAP_TAPCELL_ROW_31_666 VGND VPWR sky130_fd_sc_hd__tapvpwrvgnd_1
X_9230_ clknet_leaf_38_clk _0327_ VGND VGND VPWR VPWR registers\[26\]\[14\] sky130_fd_sc_hd__dfxtp_1
XFILLER_0_113_423 VGND VGND VPWR VPWR sky130_fd_sc_hd__fill_1
XFILLER_0_99_78 VGND VGND VPWR VPWR sky130_fd_sc_hd__decap_3
X_6442_ _3077_ registers\[29\]\[4\] _3069_ VGND VGND VPWR VPWR _3078_ sky130_fd_sc_hd__mux2_1
X_9161_ clknet_leaf_10_clk _0258_ VGND VGND VPWR VPWR registers\[24\]\[9\] sky130_fd_sc_hd__dfxtp_1
XANTENNA__5431__S0 _1996_ VGND VGND VPWR VPWR sky130_fd_sc_hd__diode_2
X_6373_ registers\[3\]\[7\] _2976_ _3030_ VGND VGND VPWR VPWR _3038_ sky130_fd_sc_hd__mux2_1
XFILLER_0_2_164 VGND VGND VPWR VPWR sky130_fd_sc_hd__decap_3
XFILLER_0_11_421 VGND VGND VPWR VPWR sky130_fd_sc_hd__decap_4
XFILLER_0_11_432 VGND VGND VPWR VPWR sky130_fd_sc_hd__fill_1
X_8112_ _3003_ registers\[30\]\[20\] _3995_ VGND VGND VPWR VPWR _3996_ sky130_fd_sc_hd__mux2_1
X_9092_ clknet_leaf_28_clk _0189_ VGND VGND VPWR VPWR registers\[22\]\[4\] sky130_fd_sc_hd__dfxtp_1
X_5324_ registers\[28\]\[24\] registers\[29\]\[24\] registers\[30\]\[24\] registers\[31\]\[24\]
+ _2020_ _2021_ VGND VGND VPWR VPWR _2068_ sky130_fd_sc_hd__mux4_1
XFILLER_0_11_443 VGND VGND VPWR VPWR sky130_fd_sc_hd__fill_2
XFILLER_0_11_465 VGND VGND VPWR VPWR sky130_fd_sc_hd__fill_2
XANTENNA__4956__A _1629_ VGND VGND VPWR VPWR sky130_fd_sc_hd__diode_2
X_5255_ registers\[4\]\[20\] registers\[5\]\[20\] registers\[6\]\[20\] registers\[7\]\[20\]
+ _1968_ _1969_ VGND VGND VPWR VPWR _2003_ sky130_fd_sc_hd__mux4_1
X_8043_ _3936_ VGND VGND VPWR VPWR _3959_ sky130_fd_sc_hd__clkbuf_8
XFILLER_0_47_3 VGND VGND VPWR VPWR sky130_fd_sc_hd__fill_2
X_5186_ _1746_ _1937_ _1687_ VGND VGND VPWR VPWR _1938_ sky130_fd_sc_hd__o21a_1
XTAP_TAPCELL_ROW_3_303 VGND VPWR sky130_fd_sc_hd__tapvpwrvgnd_1
XFILLER_0_3_40 VGND VGND VPWR VPWR sky130_fd_sc_hd__fill_2
X_8945_ clknet_leaf_55_clk _0042_ VGND VGND VPWR VPWR registers\[17\]\[17\] sky130_fd_sc_hd__dfxtp_1
XFILLER_0_78_421 VGND VGND VPWR VPWR sky130_fd_sc_hd__fill_2
XFILLER_0_64_81 VGND VGND VPWR VPWR sky130_fd_sc_hd__decap_3
XTAP_TAPCELL_ROW_39_766 VGND VPWR sky130_fd_sc_hd__tapvpwrvgnd_1
XANTENNA__7478__S _3659_ VGND VGND VPWR VPWR sky130_fd_sc_hd__diode_2
XTAP_TAPCELL_ROW_108_1661 VGND VPWR sky130_fd_sc_hd__tapvpwrvgnd_1
XANTENNA__6382__S _3041_ VGND VGND VPWR VPWR sky130_fd_sc_hd__diode_2
XFILLER_0_78_443 VGND VGND VPWR VPWR sky130_fd_sc_hd__fill_1
XANTENNA__5787__A _1184_ VGND VGND VPWR VPWR sky130_fd_sc_hd__diode_2
X_8876_ clknet_leaf_15_clk _0997_ VGND VGND VPWR VPWR registers\[15\]\[12\] sky130_fd_sc_hd__dfxtp_1
X_7827_ _3098_ registers\[26\]\[14\] _3840_ VGND VGND VPWR VPWR _3845_ sky130_fd_sc_hd__mux2_1
XFILLER_0_65_104 VGND VGND VPWR VPWR sky130_fd_sc_hd__fill_2
XFILLER_0_109_729 VGND VGND VPWR VPWR sky130_fd_sc_hd__fill_2
X_7758_ _3808_ VGND VGND VPWR VPWR _0294_ sky130_fd_sc_hd__clkbuf_1
XANTENNA__4473__S1 _1203_ VGND VGND VPWR VPWR sky130_fd_sc_hd__diode_2
X_7689_ registers\[24\]\[13\] _3462_ _3768_ VGND VGND VPWR VPWR _3772_ sky130_fd_sc_hd__mux2_1
X_6709_ _3234_ VGND VGND VPWR VPWR _0843_ sky130_fd_sc_hd__clkbuf_1
XFILLER_0_46_384 VGND VGND VPWR VPWR sky130_fd_sc_hd__decap_3
XFILLER_0_34_524 VGND VGND VPWR VPWR sky130_fd_sc_hd__fill_2
XFILLER_0_61_332 VGND VGND VPWR VPWR sky130_fd_sc_hd__fill_2
X_9428_ clknet_leaf_92_clk _0525_ VGND VGND VPWR VPWR registers\[6\]\[20\] sky130_fd_sc_hd__dfxtp_1
XFILLER_0_34_557 VGND VGND VPWR VPWR sky130_fd_sc_hd__fill_2
XFILLER_0_116_283 VGND VGND VPWR VPWR sky130_fd_sc_hd__fill_2
XTAP_TAPCELL_ROW_59_1026 VGND VPWR sky130_fd_sc_hd__tapvpwrvgnd_1
XANTENNA__5422__S0 _2119_ VGND VGND VPWR VPWR sky130_fd_sc_hd__diode_2
XFILLER_0_22_719 VGND VGND VPWR VPWR sky130_fd_sc_hd__decap_4
X_9359_ clknet_leaf_46_clk _0456_ VGND VGND VPWR VPWR registers\[30\]\[15\] sky130_fd_sc_hd__dfxtp_1
XANTENNA__6557__S _3148_ VGND VGND VPWR VPWR sky130_fd_sc_hd__diode_2
XANTENNA__4866__A net4 VGND VGND VPWR VPWR sky130_fd_sc_hd__diode_2
XFILLER_0_28_19 VGND VGND VPWR VPWR sky130_fd_sc_hd__fill_2
XANTENNA__4805__S _1381_ VGND VGND VPWR VPWR sky130_fd_sc_hd__diode_2
XTAP_TAPCELL_ROW_83_1344 VGND VPWR sky130_fd_sc_hd__tapvpwrvgnd_1
XTAP_TAPCELL_ROW_83_1333 VGND VPWR sky130_fd_sc_hd__tapvpwrvgnd_1
XFILLER_0_37_340 VGND VGND VPWR VPWR sky130_fd_sc_hd__decap_3
XFILLER_0_65_671 VGND VGND VPWR VPWR sky130_fd_sc_hd__fill_1
XFILLER_0_25_535 VGND VGND VPWR VPWR sky130_fd_sc_hd__fill_1
XANTENNA__8012__S _3937_ VGND VGND VPWR VPWR sky130_fd_sc_hd__diode_2
XFILLER_0_64_192 VGND VGND VPWR VPWR sky130_fd_sc_hd__fill_2
XFILLER_0_52_365 VGND VGND VPWR VPWR sky130_fd_sc_hd__fill_2
XFILLER_0_12_218 VGND VGND VPWR VPWR sky130_fd_sc_hd__fill_2
XFILLER_0_110_415 VGND VGND VPWR VPWR sky130_fd_sc_hd__fill_1
XFILLER_0_69_48 VGND VGND VPWR VPWR sky130_fd_sc_hd__decap_8
XFILLER_0_40_549 VGND VGND VPWR VPWR sky130_fd_sc_hd__fill_2
XFILLER_0_100_89 VGND VGND VPWR VPWR sky130_fd_sc_hd__decap_3
XTAP_TAPCELL_ROW_94_1484 VGND VPWR sky130_fd_sc_hd__tapvpwrvgnd_1
XANTENNA__6467__S _3090_ VGND VGND VPWR VPWR sky130_fd_sc_hd__diode_2
XFILLER_0_20_262 VGND VGND VPWR VPWR sky130_fd_sc_hd__decap_4
XFILLER_0_109_21 VGND VGND VPWR VPWR sky130_fd_sc_hd__fill_1
X_5040_ registers\[16\]\[8\] registers\[17\]\[8\] registers\[18\]\[8\] registers\[19\]\[8\]
+ _1798_ _1799_ VGND VGND VPWR VPWR _1800_ sky130_fd_sc_hd__mux4_1
XFILLER_0_85_69 VGND VGND VPWR VPWR sky130_fd_sc_hd__decap_4
XFILLER_0_18_85 VGND VGND VPWR VPWR sky130_fd_sc_hd__fill_2
X_6991_ _3385_ VGND VGND VPWR VPWR _0974_ sky130_fd_sc_hd__clkbuf_1
X_5942_ net85 _2646_ _2663_ VGND VGND VPWR VPWR _2664_ sky130_fd_sc_hd__a21bo_1
XANTENNA__7298__S _3561_ VGND VGND VPWR VPWR sky130_fd_sc_hd__diode_2
XANTENNA__4715__S _1159_ VGND VGND VPWR VPWR sky130_fd_sc_hd__diode_2
X_8730_ clknet_leaf_90_clk _0851_ VGND VGND VPWR VPWR registers\[10\]\[26\] sky130_fd_sc_hd__dfxtp_1
XTAP_TAPCELL_ROW_36_725 VGND VPWR sky130_fd_sc_hd__tapvpwrvgnd_1
XFILLER_0_47_104 VGND VGND VPWR VPWR sky130_fd_sc_hd__fill_1
XFILLER_0_34_73 VGND VGND VPWR VPWR sky130_fd_sc_hd__decap_3
X_5873_ _2597_ _2598_ VGND VGND VPWR VPWR _2599_ sky130_fd_sc_hd__nor2_1
XFILLER_0_48_638 VGND VGND VPWR VPWR sky130_fd_sc_hd__decap_6
X_8661_ clknet_leaf_85_clk _0782_ VGND VGND VPWR VPWR registers\[7\]\[21\] sky130_fd_sc_hd__dfxtp_1
XFILLER_0_118_526 VGND VGND VPWR VPWR sky130_fd_sc_hd__decap_3
X_8592_ clknet_leaf_65_clk _0713_ VGND VGND VPWR VPWR registers\[3\]\[16\] sky130_fd_sc_hd__dfxtp_1
X_7612_ _3730_ VGND VGND VPWR VPWR _0226_ sky130_fd_sc_hd__clkbuf_1
X_4824_ registers\[12\]\[30\] registers\[13\]\[30\] registers\[14\]\[30\] registers\[15\]\[30\]
+ _1404_ _1405_ VGND VGND VPWR VPWR _1594_ sky130_fd_sc_hd__mux4_1
XTAP_TAPCELL_ROW_16_471 VGND VPWR sky130_fd_sc_hd__tapvpwrvgnd_1
XFILLER_0_28_351 VGND VGND VPWR VPWR sky130_fd_sc_hd__decap_3
XANTENNA__4455__S1 _1025_ VGND VGND VPWR VPWR sky130_fd_sc_hd__diode_2
X_7543_ _3087_ registers\[22\]\[9\] _3684_ VGND VGND VPWR VPWR _3694_ sky130_fd_sc_hd__mux2_1
XFILLER_0_7_245 VGND VGND VPWR VPWR sky130_fd_sc_hd__fill_2
XFILLER_0_16_502 VGND VGND VPWR VPWR sky130_fd_sc_hd__fill_2
X_4755_ registers\[0\]\[26\] registers\[1\]\[26\] registers\[2\]\[26\] registers\[3\]\[26\]
+ _1323_ _1324_ VGND VGND VPWR VPWR _1529_ sky130_fd_sc_hd__mux4_1
XFILLER_0_71_696 VGND VGND VPWR VPWR sky130_fd_sc_hd__decap_8
X_7474_ _3657_ VGND VGND VPWR VPWR _0161_ sky130_fd_sc_hd__clkbuf_1
X_4686_ registers\[8\]\[22\] registers\[9\]\[22\] registers\[10\]\[22\] registers\[11\]\[22\]
+ _1418_ _1419_ VGND VGND VPWR VPWR _1464_ sky130_fd_sc_hd__mux4_1
XFILLER_0_43_387 VGND VGND VPWR VPWR sky130_fd_sc_hd__fill_2
XANTENNA__5404__S0 _2072_ VGND VGND VPWR VPWR sky130_fd_sc_hd__diode_2
X_9213_ clknet_leaf_88_clk _0310_ VGND VGND VPWR VPWR registers\[25\]\[29\] sky130_fd_sc_hd__dfxtp_1
XFILLER_0_16_579 VGND VGND VPWR VPWR sky130_fd_sc_hd__fill_1
XANTENNA__7761__S _3804_ VGND VGND VPWR VPWR sky130_fd_sc_hd__diode_2
X_6425_ net16 VGND VGND VPWR VPWR _3065_ sky130_fd_sc_hd__buf_2
XFILLER_0_101_415 VGND VGND VPWR VPWR sky130_fd_sc_hd__fill_2
XANTENNA__4532__A1 _1153_ VGND VGND VPWR VPWR sky130_fd_sc_hd__diode_2
X_6356_ net13 net12 net11 VGND VGND VPWR VPWR _3028_ sky130_fd_sc_hd__or3_2
X_9144_ clknet_leaf_86_clk _0241_ VGND VGND VPWR VPWR registers\[23\]\[24\] sky130_fd_sc_hd__dfxtp_1
X_9075_ clknet_leaf_45_clk _0172_ VGND VGND VPWR VPWR registers\[21\]\[19\] sky130_fd_sc_hd__dfxtp_1
XANTENNA__6377__S _3030_ VGND VGND VPWR VPWR sky130_fd_sc_hd__diode_2
XFILLER_0_59_81 VGND VGND VPWR VPWR sky130_fd_sc_hd__decap_4
X_5307_ registers\[28\]\[23\] registers\[29\]\[23\] registers\[30\]\[23\] registers\[31\]\[23\]
+ _1883_ _1774_ VGND VGND VPWR VPWR _2052_ sky130_fd_sc_hd__mux4_1
X_8026_ _3950_ VGND VGND VPWR VPWR _0420_ sky130_fd_sc_hd__clkbuf_1
X_6287_ _2981_ VGND VGND VPWR VPWR _0674_ sky130_fd_sc_hd__clkbuf_1
X_5238_ registers\[4\]\[19\] registers\[5\]\[19\] registers\[6\]\[19\] registers\[7\]\[19\]
+ _1883_ _1774_ VGND VGND VPWR VPWR _1987_ sky130_fd_sc_hd__mux4_1
X_5169_ _1746_ _1921_ VGND VGND VPWR VPWR _1922_ sky130_fd_sc_hd__or2_1
Xclkbuf_leaf_95_clk clknet_4_9_0_clk VGND VGND VPWR VPWR clknet_leaf_95_clk sky130_fd_sc_hd__clkbuf_8
XFILLER_0_98_549 VGND VGND VPWR VPWR sky130_fd_sc_hd__decap_3
XANTENNA__5245__C1 _1702_ VGND VGND VPWR VPWR sky130_fd_sc_hd__diode_2
XFILLER_0_94_722 VGND VGND VPWR VPWR sky130_fd_sc_hd__fill_2
XFILLER_0_78_251 VGND VGND VPWR VPWR sky130_fd_sc_hd__fill_1
X_8928_ clknet_leaf_0_clk _0025_ VGND VGND VPWR VPWR registers\[17\]\[0\] sky130_fd_sc_hd__dfxtp_1
XFILLER_0_39_649 VGND VGND VPWR VPWR sky130_fd_sc_hd__fill_2
XANTENNA__7936__S _3901_ VGND VGND VPWR VPWR sky130_fd_sc_hd__diode_2
X_8859_ clknet_leaf_101_clk _0980_ VGND VGND VPWR VPWR registers\[14\]\[27\] sky130_fd_sc_hd__dfxtp_1
XANTENNA__6840__S _3299_ VGND VGND VPWR VPWR sky130_fd_sc_hd__diode_2
XFILLER_0_93_276 VGND VGND VPWR VPWR sky130_fd_sc_hd__fill_2
XANTENNA__4446__S1 _1202_ VGND VGND VPWR VPWR sky130_fd_sc_hd__diode_2
XANTENNA__6141__A _2560_ VGND VGND VPWR VPWR sky130_fd_sc_hd__diode_2
XFILLER_0_62_674 VGND VGND VPWR VPWR sky130_fd_sc_hd__fill_2
XANTENNA__4771__A1 _1513_ VGND VGND VPWR VPWR sky130_fd_sc_hd__diode_2
XFILLER_0_22_516 VGND VGND VPWR VPWR sky130_fd_sc_hd__fill_2
XFILLER_0_34_365 VGND VGND VPWR VPWR sky130_fd_sc_hd__decap_3
XFILLER_0_104_253 VGND VGND VPWR VPWR sky130_fd_sc_hd__decap_3
XANTENNA__7473__A0 _3085_ VGND VGND VPWR VPWR sky130_fd_sc_hd__diode_2
XFILLER_0_100_481 VGND VGND VPWR VPWR sky130_fd_sc_hd__fill_2
XFILLER_0_55_17 VGND VGND VPWR VPWR sky130_fd_sc_hd__decap_3
XANTENNA__4382__S0 _1126_ VGND VGND VPWR VPWR sky130_fd_sc_hd__diode_2
Xclkbuf_leaf_86_clk clknet_4_8_0_clk VGND VGND VPWR VPWR clknet_leaf_86_clk sky130_fd_sc_hd__clkbuf_8
XFILLER_0_69_262 VGND VGND VPWR VPWR sky130_fd_sc_hd__fill_2
XANTENNA__6316__A net26 VGND VGND VPWR VPWR sky130_fd_sc_hd__diode_2
XFILLER_0_97_593 VGND VGND VPWR VPWR sky130_fd_sc_hd__decap_4
XFILLER_0_97_582 VGND VGND VPWR VPWR sky130_fd_sc_hd__fill_1
XFILLER_0_57_446 VGND VGND VPWR VPWR sky130_fd_sc_hd__fill_2
XFILLER_0_57_413 VGND VGND VPWR VPWR sky130_fd_sc_hd__decap_3
XFILLER_0_45_608 VGND VGND VPWR VPWR sky130_fd_sc_hd__decap_3
XANTENNA__7846__S _3851_ VGND VGND VPWR VPWR sky130_fd_sc_hd__diode_2
XANTENNA__4437__S1 _1054_ VGND VGND VPWR VPWR sky130_fd_sc_hd__diode_2
XTAP_TAPCELL_ROW_13_430 VGND VPWR sky130_fd_sc_hd__tapvpwrvgnd_1
XTAP_TAPCELL_ROW_96_1502 VGND VPWR sky130_fd_sc_hd__tapvpwrvgnd_1
XTAP_TAPCELL_ROW_41_794 VGND VPWR sky130_fd_sc_hd__tapvpwrvgnd_1
XANTENNA__5366__S _2019_ VGND VGND VPWR VPWR sky130_fd_sc_hd__diode_2
XFILLER_0_111_33 VGND VGND VPWR VPWR sky130_fd_sc_hd__decap_4
XFILLER_0_108_581 VGND VGND VPWR VPWR sky130_fd_sc_hd__fill_2
XFILLER_0_105_3 VGND VGND VPWR VPWR sky130_fd_sc_hd__fill_2
XTAP_TAPCELL_ROW_96_1513 VGND VPWR sky130_fd_sc_hd__tapvpwrvgnd_1
X_4540_ registers\[28\]\[15\] registers\[29\]\[15\] registers\[30\]\[15\] registers\[31\]\[15\]
+ _1323_ _1324_ VGND VGND VPWR VPWR _1325_ sky130_fd_sc_hd__mux4_1
XFILLER_0_53_685 VGND VGND VPWR VPWR sky130_fd_sc_hd__decap_3
Xclkbuf_leaf_10_clk clknet_4_3_0_clk VGND VGND VPWR VPWR clknet_leaf_10_clk sky130_fd_sc_hd__clkbuf_8
XFILLER_0_20_20 VGND VGND VPWR VPWR sky130_fd_sc_hd__fill_2
X_4471_ _1258_ _1259_ _1116_ VGND VGND VPWR VPWR _1260_ sky130_fd_sc_hd__mux2_1
XFILLER_0_20_64 VGND VGND VPWR VPWR sky130_fd_sc_hd__fill_2
XANTENNA__7581__S _3706_ VGND VGND VPWR VPWR sky130_fd_sc_hd__diode_2
XFILLER_0_111_724 VGND VGND VPWR VPWR sky130_fd_sc_hd__fill_2
XANTENNA__4514__A1 _1135_ VGND VGND VPWR VPWR sky130_fd_sc_hd__diode_2
X_7190_ registers\[17\]\[3\] _3441_ _3503_ VGND VGND VPWR VPWR _3507_ sky130_fd_sc_hd__mux2_1
X_6210_ _2168_ _2916_ VGND VGND VPWR VPWR _2917_ sky130_fd_sc_hd__and2_1
XFILLER_0_40_346 VGND VGND VPWR VPWR sky130_fd_sc_hd__fill_2
XFILLER_0_0_421 VGND VGND VPWR VPWR sky130_fd_sc_hd__fill_2
X_6141_ _2560_ _2848_ _2851_ VGND VGND VPWR VPWR _2852_ sky130_fd_sc_hd__or3_1
XFILLER_0_0_432 VGND VGND VPWR VPWR sky130_fd_sc_hd__fill_2
X_6072_ _2757_ _2786_ _2353_ VGND VGND VPWR VPWR _2787_ sky130_fd_sc_hd__mux2_1
XFILLER_0_29_84 VGND VGND VPWR VPWR sky130_fd_sc_hd__fill_2
X_5023_ registers\[28\]\[7\] registers\[29\]\[7\] registers\[30\]\[7\] registers\[31\]\[7\]
+ _1628_ _1629_ VGND VGND VPWR VPWR _1784_ sky130_fd_sc_hd__mux4_1
XANTENNA__6925__S _3346_ VGND VGND VPWR VPWR sky130_fd_sc_hd__diode_2
Xclkbuf_leaf_77_clk clknet_4_10_0_clk VGND VGND VPWR VPWR clknet_leaf_77_clk sky130_fd_sc_hd__clkbuf_8
XTAP_TAPCELL_ROW_49_894 VGND VPWR sky130_fd_sc_hd__tapvpwrvgnd_1
XTAP_TAPCELL_ROW_105_1620 VGND VPWR sky130_fd_sc_hd__tapvpwrvgnd_1
X_6974_ _3376_ VGND VGND VPWR VPWR _0966_ sky130_fd_sc_hd__clkbuf_1
XFILLER_0_76_722 VGND VGND VPWR VPWR sky130_fd_sc_hd__fill_2
X_8713_ clknet_leaf_19_clk _0834_ VGND VGND VPWR VPWR registers\[10\]\[9\] sky130_fd_sc_hd__dfxtp_1
X_5925_ _2626_ _2631_ _2624_ VGND VGND VPWR VPWR _2648_ sky130_fd_sc_hd__a21oi_1
XFILLER_0_0_41 VPWR VGND VPWR VGND sky130_ef_sc_hd__decap_12
X_8644_ clknet_leaf_30_clk _0765_ VGND VGND VPWR VPWR registers\[7\]\[4\] sky130_fd_sc_hd__dfxtp_1
X_5856_ _2445_ _2582_ VGND VGND VPWR VPWR _2583_ sky130_fd_sc_hd__and2_1
XFILLER_0_63_405 VGND VGND VPWR VPWR sky130_fd_sc_hd__fill_1
XFILLER_0_8_510 VGND VGND VPWR VPWR sky130_fd_sc_hd__fill_2
XANTENNA__6660__S _3197_ VGND VGND VPWR VPWR sky130_fd_sc_hd__diode_2
XFILLER_0_0_85 VPWR VGND VPWR VGND sky130_ef_sc_hd__decap_12
XFILLER_0_90_213 VGND VGND VPWR VPWR sky130_fd_sc_hd__decap_6
XANTENNA__4428__S1 _1202_ VGND VGND VPWR VPWR sky130_fd_sc_hd__diode_2
XANTENNA__5784__B _1166_ VGND VGND VPWR VPWR sky130_fd_sc_hd__diode_2
XFILLER_0_61_93 VGND VGND VPWR VPWR sky130_fd_sc_hd__decap_4
XPHY_EDGE_ROW_3_Right_3 VGND VGND VPWR VPWR sky130_fd_sc_hd__decap_3
X_4807_ registers\[0\]\[29\] registers\[1\]\[29\] registers\[2\]\[29\] registers\[3\]\[29\]
+ _1550_ _1551_ VGND VGND VPWR VPWR _1578_ sky130_fd_sc_hd__mux4_1
XANTENNA__8192__A1 _3489_ VGND VGND VPWR VPWR sky130_fd_sc_hd__diode_2
XFILLER_0_106_529 VGND VGND VPWR VPWR sky130_fd_sc_hd__decap_3
XFILLER_0_90_246 VGND VGND VPWR VPWR sky130_fd_sc_hd__fill_2
X_5787_ _1184_ _2516_ VGND VGND VPWR VPWR _2517_ sky130_fd_sc_hd__xnor2_1
XFILLER_0_44_652 VGND VGND VPWR VPWR sky130_fd_sc_hd__fill_1
XFILLER_0_8_587 VGND VGND VPWR VPWR sky130_fd_sc_hd__fill_1
XFILLER_0_28_181 VGND VGND VPWR VPWR sky130_fd_sc_hd__fill_1
XFILLER_0_28_192 VGND VGND VPWR VPWR sky130_fd_sc_hd__fill_2
X_8575_ clknet_leaf_100_clk _0696_ VGND VGND VPWR VPWR registers\[19\]\[31\] sky130_fd_sc_hd__dfxtp_1
XFILLER_0_43_151 VGND VGND VPWR VPWR sky130_fd_sc_hd__fill_1
XFILLER_0_9_61 VGND VGND VPWR VPWR sky130_fd_sc_hd__fill_2
X_7526_ _3685_ VGND VGND VPWR VPWR _0185_ sky130_fd_sc_hd__clkbuf_1
X_4738_ _1344_ VGND VGND VPWR VPWR _1513_ sky130_fd_sc_hd__buf_4
XFILLER_0_16_365 VGND VGND VPWR VPWR sky130_fd_sc_hd__decap_3
XFILLER_0_71_482 VGND VGND VPWR VPWR sky130_fd_sc_hd__fill_2
XFILLER_0_9_83 VGND VGND VPWR VPWR sky130_fd_sc_hd__fill_1
X_7457_ _3065_ registers\[21\]\[0\] _3648_ VGND VGND VPWR VPWR _3649_ sky130_fd_sc_hd__mux2_1
X_4669_ _1446_ _1447_ _1386_ VGND VGND VPWR VPWR _1448_ sky130_fd_sc_hd__mux2_1
XFILLER_0_102_724 VGND VGND VPWR VPWR sky130_fd_sc_hd__decap_4
XFILLER_0_3_281 VGND VGND VPWR VPWR sky130_fd_sc_hd__decap_3
XFILLER_0_31_357 VGND VGND VPWR VPWR sky130_fd_sc_hd__fill_2
X_6408_ _3056_ VGND VGND VPWR VPWR _0720_ sky130_fd_sc_hd__clkbuf_1
XTAP_TAPCELL_ROW_116_1771 VGND VPWR sky130_fd_sc_hd__tapvpwrvgnd_1
X_9127_ clknet_leaf_24_clk _0224_ VGND VGND VPWR VPWR registers\[23\]\[7\] sky130_fd_sc_hd__dfxtp_1
X_7388_ _3611_ VGND VGND VPWR VPWR _3612_ sky130_fd_sc_hd__clkbuf_8
XFILLER_0_12_571 VGND VGND VPWR VPWR sky130_fd_sc_hd__decap_8
X_6339_ registers\[19\]\[26\] _3016_ _3004_ VGND VGND VPWR VPWR _3017_ sky130_fd_sc_hd__mux2_1
X_9058_ clknet_leaf_1_clk _0155_ VGND VGND VPWR VPWR registers\[21\]\[2\] sky130_fd_sc_hd__dfxtp_1
X_8009_ _3941_ VGND VGND VPWR VPWR _0412_ sky130_fd_sc_hd__clkbuf_1
XFILLER_0_98_302 VGND VGND VPWR VPWR sky130_fd_sc_hd__fill_2
Xclkbuf_leaf_68_clk clknet_4_11_0_clk VGND VGND VPWR VPWR clknet_leaf_68_clk sky130_fd_sc_hd__clkbuf_8
XFILLER_0_98_346 VGND VGND VPWR VPWR sky130_fd_sc_hd__decap_8
XTAP_TAPCELL_ROW_67_1125 VGND VPWR sky130_fd_sc_hd__tapvpwrvgnd_1
XFILLER_0_86_508 VGND VGND VPWR VPWR sky130_fd_sc_hd__fill_2
XFILLER_0_79_571 VGND VGND VPWR VPWR sky130_fd_sc_hd__decap_3
XTAP_TAPCELL_ROW_67_1136 VGND VPWR sky130_fd_sc_hd__tapvpwrvgnd_1
XFILLER_0_67_711 VGND VGND VPWR VPWR sky130_fd_sc_hd__fill_1
XFILLER_0_39_435 VGND VGND VPWR VPWR sky130_fd_sc_hd__fill_2
XANTENNA__4667__S1 _1428_ VGND VGND VPWR VPWR sky130_fd_sc_hd__diode_2
XANTENNA__5975__A net139 VGND VGND VPWR VPWR sky130_fd_sc_hd__diode_2
XFILLER_0_94_541 VGND VGND VPWR VPWR sky130_fd_sc_hd__fill_2
XTAP_TAPCELL_ROW_80_1303 VGND VPWR sky130_fd_sc_hd__tapvpwrvgnd_1
XANTENNA__7666__S _3757_ VGND VGND VPWR VPWR sky130_fd_sc_hd__diode_2
XFILLER_0_94_585 VGND VGND VPWR VPWR sky130_fd_sc_hd__decap_3
XFILLER_0_34_151 VGND VGND VPWR VPWR sky130_fd_sc_hd__fill_2
XFILLER_0_35_685 VGND VGND VPWR VPWR sky130_fd_sc_hd__fill_2
XFILLER_0_50_633 VGND VGND VPWR VPWR sky130_fd_sc_hd__fill_2
XFILLER_0_50_622 VGND VGND VPWR VPWR sky130_fd_sc_hd__fill_2
XANTENNA__5914__S _2490_ VGND VGND VPWR VPWR sky130_fd_sc_hd__diode_2
XTAP_TAPCELL_ROW_78_1276 VGND VPWR sky130_fd_sc_hd__tapvpwrvgnd_1
XFILLER_0_22_357 VGND VGND VPWR VPWR sky130_fd_sc_hd__fill_1
XTAP_TAPCELL_ROW_91_1443 VGND VPWR sky130_fd_sc_hd__tapvpwrvgnd_1
XANTENNA__6249__A1 _2353_ VGND VGND VPWR VPWR sky130_fd_sc_hd__diode_2
XANTENNA__4355__S0 _1111_ VGND VGND VPWR VPWR sky130_fd_sc_hd__diode_2
XANTENNA__6745__S _3250_ VGND VGND VPWR VPWR sky130_fd_sc_hd__diode_2
Xclkbuf_leaf_59_clk clknet_4_15_0_clk VGND VGND VPWR VPWR clknet_leaf_59_clk sky130_fd_sc_hd__clkbuf_8
XANTENNA__7430__A _3611_ VGND VGND VPWR VPWR sky130_fd_sc_hd__diode_2
XFILLER_0_106_11 VGND VGND VPWR VPWR sky130_fd_sc_hd__fill_1
XFILLER_0_89_324 VPWR VGND VPWR VGND sky130_ef_sc_hd__decap_12
XFILLER_0_58_711 VGND VGND VPWR VPWR sky130_fd_sc_hd__fill_1
XFILLER_0_119_109 VGND VGND VPWR VPWR sky130_fd_sc_hd__decap_3
XTAP_TAPCELL_ROW_46_853 VGND VPWR sky130_fd_sc_hd__tapvpwrvgnd_1
X_5710_ _2370_ _2375_ _2266_ VGND VGND VPWR VPWR _2443_ sky130_fd_sc_hd__mux2_1
XFILLER_0_18_608 VGND VGND VPWR VPWR sky130_fd_sc_hd__fill_1
XFILLER_0_85_585 VPWR VGND VPWR VGND sky130_ef_sc_hd__decap_12
X_6690_ _3224_ VGND VGND VPWR VPWR _0834_ sky130_fd_sc_hd__clkbuf_1
XFILLER_0_73_725 VGND VGND VPWR VPWR sky130_fd_sc_hd__decap_3
XFILLER_0_57_276 VGND VGND VPWR VPWR sky130_fd_sc_hd__fill_2
XFILLER_0_45_427 VGND VGND VPWR VPWR sky130_fd_sc_hd__decap_3
XTAP_TAPCELL_ROW_100_1561 VGND VPWR sky130_fd_sc_hd__tapvpwrvgnd_1
X_5641_ _2232_ _2242_ _1051_ VGND VGND VPWR VPWR _2376_ sky130_fd_sc_hd__mux2_1
XFILLER_0_45_449 VGND VGND VPWR VPWR sky130_fd_sc_hd__decap_3
XFILLER_0_31_41 VGND VGND VPWR VPWR sky130_fd_sc_hd__fill_2
X_5572_ _2307_ VGND VGND VPWR VPWR _2308_ sky130_fd_sc_hd__buf_2
X_8360_ registers\[5\]\[9\] _3453_ _4117_ VGND VGND VPWR VPWR _4127_ sky130_fd_sc_hd__mux2_1
XFILLER_0_60_419 VGND VGND VPWR VPWR sky130_fd_sc_hd__fill_1
XFILLER_0_26_674 VGND VGND VPWR VPWR sky130_fd_sc_hd__fill_2
X_4523_ _1307_ _1308_ _1148_ VGND VGND VPWR VPWR _1309_ sky130_fd_sc_hd__mux2_1
XFILLER_0_86_7 VGND VGND VPWR VPWR sky130_fd_sc_hd__decap_8
X_8291_ _4090_ VGND VGND VPWR VPWR _0545_ sky130_fd_sc_hd__clkbuf_1
XFILLER_0_53_493 VGND VGND VPWR VPWR sky130_fd_sc_hd__fill_2
X_7311_ _3570_ VGND VGND VPWR VPWR _0085_ sky130_fd_sc_hd__clkbuf_1
XFILLER_0_25_162 VGND VGND VPWR VPWR sky130_fd_sc_hd__decap_4
XFILLER_0_41_677 VGND VGND VPWR VPWR sky130_fd_sc_hd__decap_8
X_7242_ registers\[17\]\[28\] _3493_ _3525_ VGND VGND VPWR VPWR _3534_ sky130_fd_sc_hd__mux2_1
X_4454_ registers\[20\]\[10\] registers\[21\]\[10\] registers\[22\]\[10\] registers\[23\]\[10\]
+ _1110_ _1112_ VGND VGND VPWR VPWR _1244_ sky130_fd_sc_hd__mux4_1
XFILLER_0_111_554 VGND VGND VPWR VPWR sky130_fd_sc_hd__fill_2
XFILLER_0_40_165 VGND VGND VPWR VPWR sky130_fd_sc_hd__decap_3
XFILLER_0_111_565 VGND VGND VPWR VPWR sky130_fd_sc_hd__fill_1
X_4385_ _1124_ _1178_ VGND VGND VPWR VPWR _1179_ sky130_fd_sc_hd__nand2_1
XANTENNA__4594__S0 _1338_ VGND VGND VPWR VPWR sky130_fd_sc_hd__diode_2
XFILLER_0_0_273 VGND VGND VPWR VPWR sky130_fd_sc_hd__fill_2
X_7173_ registers\[16\]\[29\] _3495_ _3477_ VGND VGND VPWR VPWR _3496_ sky130_fd_sc_hd__mux2_1
X_6124_ _2776_ _2832_ _2835_ VGND VGND VPWR VPWR _2836_ sky130_fd_sc_hd__o21ba_1
X_6055_ _1440_ _2750_ VGND VGND VPWR VPWR _2771_ sky130_fd_sc_hd__xnor2_2
X_5006_ _1767_ VGND VGND VPWR VPWR _1768_ sky130_fd_sc_hd__clkbuf_8
XANTENNA__7340__A _3574_ VGND VGND VPWR VPWR sky130_fd_sc_hd__diode_2
XANTENNA__6660__A1 _3022_ VGND VGND VPWR VPWR sky130_fd_sc_hd__diode_2
X_6957_ _3367_ VGND VGND VPWR VPWR _0958_ sky130_fd_sc_hd__clkbuf_1
XFILLER_0_49_711 VGND VGND VPWR VPWR sky130_fd_sc_hd__fill_2
XANTENNA__4649__S1 _1428_ VGND VGND VPWR VPWR sky130_fd_sc_hd__diode_2
XANTENNA__7486__S _3659_ VGND VGND VPWR VPWR sky130_fd_sc_hd__diode_2
XANTENNA__6390__S _3041_ VGND VGND VPWR VPWR sky130_fd_sc_hd__diode_2
X_6888_ _3330_ VGND VGND VPWR VPWR _0926_ sky130_fd_sc_hd__clkbuf_1
XANTENNA__8165__A1 _3462_ VGND VGND VPWR VPWR sky130_fd_sc_hd__diode_2
XFILLER_0_64_725 VGND VGND VPWR VPWR sky130_fd_sc_hd__fill_2
X_5908_ _2626_ _2631_ VGND VGND VPWR VPWR _2632_ sky130_fd_sc_hd__xnor2_1
XTAP_TAPCELL_ROW_24_569 VGND VPWR sky130_fd_sc_hd__tapvpwrvgnd_1
X_5839_ _1108_ _2200_ VGND VGND VPWR VPWR _2567_ sky130_fd_sc_hd__or2_2
XFILLER_0_91_544 VGND VGND VPWR VPWR sky130_fd_sc_hd__fill_1
XTAP_TAPCELL_ROW_62_1066 VGND VPWR sky130_fd_sc_hd__tapvpwrvgnd_1
X_8627_ clknet_leaf_96_clk _0748_ VGND VGND VPWR VPWR registers\[29\]\[19\] sky130_fd_sc_hd__dfxtp_1
XFILLER_0_8_373 VGND VGND VPWR VPWR sky130_fd_sc_hd__fill_2
XFILLER_0_118_197 VGND VGND VPWR VPWR sky130_fd_sc_hd__decap_4
X_8558_ clknet_leaf_38_clk _0679_ VGND VGND VPWR VPWR registers\[19\]\[14\] sky130_fd_sc_hd__dfxtp_1
XFILLER_0_44_460 VPWR VGND VPWR VGND sky130_ef_sc_hd__decap_12
X_7509_ _3121_ registers\[21\]\[25\] _3670_ VGND VGND VPWR VPWR _3676_ sky130_fd_sc_hd__mux2_1
XFILLER_0_16_162 VGND VGND VPWR VPWR sky130_fd_sc_hd__fill_2
XFILLER_0_16_184 VGND VGND VPWR VPWR sky130_fd_sc_hd__fill_2
X_8489_ _4195_ VGND VGND VPWR VPWR _0638_ sky130_fd_sc_hd__clkbuf_1
XFILLER_0_16_195 VGND VGND VPWR VPWR sky130_fd_sc_hd__fill_1
XANTENNA__5687__C1 _2420_ VGND VGND VPWR VPWR sky130_fd_sc_hd__diode_2
XFILLER_0_31_165 VGND VGND VPWR VPWR sky130_fd_sc_hd__decap_3
XANTENNA__4585__S0 _1201_ VGND VGND VPWR VPWR sky130_fd_sc_hd__diode_2
XANTENNA__6565__S _3148_ VGND VGND VPWR VPWR sky130_fd_sc_hd__diode_2
XANTENNA__4874__A _1641_ VGND VGND VPWR VPWR sky130_fd_sc_hd__diode_2
XFILLER_0_99_666 VGND VGND VPWR VPWR sky130_fd_sc_hd__fill_2
XANTENNA_input13_A a3[4] VGND VGND VPWR VPWR sky130_fd_sc_hd__diode_2
XANTENNA__4414__B1 _1142_ VGND VGND VPWR VPWR sky130_fd_sc_hd__diode_2
XTAP_TAPCELL_ROW_43_823 VGND VPWR sky130_fd_sc_hd__tapvpwrvgnd_1
XTAP_TAPCELL_ROW_43_812 VGND VPWR sky130_fd_sc_hd__tapvpwrvgnd_1
XANTENNA__8156__A1 _3453_ VGND VGND VPWR VPWR sky130_fd_sc_hd__diode_2
XFILLER_0_27_405 VGND VGND VPWR VPWR sky130_fd_sc_hd__fill_2
XFILLER_0_109_164 VGND VGND VPWR VPWR sky130_fd_sc_hd__fill_2
XFILLER_0_82_533 VGND VGND VPWR VPWR sky130_fd_sc_hd__fill_2
XFILLER_0_70_706 VGND VGND VPWR VPWR sky130_fd_sc_hd__fill_2
XANTENNA__5065__S1 _1821_ VGND VGND VPWR VPWR sky130_fd_sc_hd__diode_2
XFILLER_0_42_408 VPWR VGND VPWR VGND sky130_ef_sc_hd__decap_12
XFILLER_0_82_599 VGND VGND VPWR VPWR sky130_fd_sc_hd__fill_2
XANTENNA__5390__A1 _2076_ VGND VGND VPWR VPWR sky130_fd_sc_hd__diode_2
XFILLER_0_23_633 VGND VGND VPWR VPWR sky130_fd_sc_hd__fill_2
XFILLER_0_2_527 VGND VGND VPWR VPWR sky130_fd_sc_hd__fill_2
XFILLER_0_22_132 VGND VGND VPWR VPWR sky130_fd_sc_hd__decap_8
XANTENNA__8020__S _3937_ VGND VGND VPWR VPWR sky130_fd_sc_hd__diode_2
XANTENNA_output81_A net81 VGND VGND VPWR VPWR sky130_fd_sc_hd__diode_2
XFILLER_0_22_165 VGND VGND VPWR VPWR sky130_fd_sc_hd__decap_3
XFILLER_0_23_688 VGND VGND VPWR VPWR sky130_fd_sc_hd__fill_2
XANTENNA__4576__S0 _1160_ VGND VGND VPWR VPWR sky130_fd_sc_hd__diode_2
XFILLER_0_10_338 VGND VGND VPWR VPWR sky130_fd_sc_hd__decap_3
XANTENNA__7160__A net33 VGND VGND VPWR VPWR sky130_fd_sc_hd__diode_2
XANTENNA__4784__A _1348_ VGND VGND VPWR VPWR sky130_fd_sc_hd__diode_2
XANTENNA__6642__A1 _3003_ VGND VGND VPWR VPWR sky130_fd_sc_hd__diode_2
X_7860_ _3131_ registers\[26\]\[30\] _3828_ VGND VGND VPWR VPWR _3862_ sky130_fd_sc_hd__mux2_1
X_6811_ registers\[12\]\[1\] _2964_ _3288_ VGND VGND VPWR VPWR _3290_ sky130_fd_sc_hd__mux2_1
X_7791_ _3825_ VGND VGND VPWR VPWR _0310_ sky130_fd_sc_hd__clkbuf_1
XANTENNA__4500__S0 _1167_ VGND VGND VPWR VPWR sky130_fd_sc_hd__diode_2
X_6742_ _3252_ VGND VGND VPWR VPWR _0858_ sky130_fd_sc_hd__clkbuf_1
X_9530_ clknet_leaf_91_clk _0627_ VGND VGND VPWR VPWR registers\[8\]\[26\] sky130_fd_sc_hd__dfxtp_1
XFILLER_0_85_393 VGND VGND VPWR VPWR sky130_fd_sc_hd__fill_1
X_6673_ registers\[10\]\[1\] _2964_ _3214_ VGND VGND VPWR VPWR _3216_ sky130_fd_sc_hd__mux2_1
X_9461_ clknet_leaf_82_clk _0558_ VGND VGND VPWR VPWR registers\[31\]\[21\] sky130_fd_sc_hd__dfxtp_1
XTAP_TAPCELL_ROW_21_528 VGND VPWR sky130_fd_sc_hd__tapvpwrvgnd_1
XANTENNA__5056__S1 _1814_ VGND VGND VPWR VPWR sky130_fd_sc_hd__diode_2
X_5624_ _2295_ _1106_ VGND VGND VPWR VPWR _2359_ sky130_fd_sc_hd__nand2_2
X_9392_ clknet_leaf_62_clk _0489_ VGND VGND VPWR VPWR registers\[9\]\[16\] sky130_fd_sc_hd__dfxtp_1
XFILLER_0_73_588 VGND VGND VPWR VPWR sky130_fd_sc_hd__decap_3
X_8412_ registers\[8\]\[1\] net27 _4153_ VGND VGND VPWR VPWR _4155_ sky130_fd_sc_hd__mux2_1
XFILLER_0_116_657 VPWR VGND VPWR VGND sky130_ef_sc_hd__decap_12
XFILLER_0_115_156 VGND VGND VPWR VPWR sky130_fd_sc_hd__fill_2
XFILLER_0_115_145 VGND VGND VPWR VPWR sky130_fd_sc_hd__fill_2
XANTENNA__4803__S1 _1556_ VGND VGND VPWR VPWR sky130_fd_sc_hd__diode_2
XFILLER_0_26_482 VGND VGND VPWR VPWR sky130_fd_sc_hd__fill_2
X_8343_ _4118_ VGND VGND VPWR VPWR _0569_ sky130_fd_sc_hd__clkbuf_1
X_5555_ _1835_ _2214_ VGND VGND VPWR VPWR _2291_ sky130_fd_sc_hd__or2_1
XFILLER_0_41_430 VGND VGND VPWR VPWR sky130_fd_sc_hd__fill_2
XFILLER_0_13_132 VPWR VGND VPWR VGND sky130_ef_sc_hd__decap_12
X_4506_ _1289_ _1292_ _1122_ VGND VGND VPWR VPWR _1293_ sky130_fd_sc_hd__mux2_1
X_5486_ _2218_ _2221_ VGND VGND VPWR VPWR _2222_ sky130_fd_sc_hd__nand2_1
XFILLER_0_41_485 VGND VGND VPWR VPWR sky130_fd_sc_hd__fill_1
X_8274_ _2958_ registers\[31\]\[0\] _4081_ VGND VGND VPWR VPWR _4082_ sky130_fd_sc_hd__mux2_1
XTAP_TAPCELL_ROW_113_1730 VGND VPWR sky130_fd_sc_hd__tapvpwrvgnd_1
XFILLER_0_111_362 VGND VGND VPWR VPWR sky130_fd_sc_hd__decap_4
X_4437_ registers\[28\]\[9\] registers\[29\]\[9\] registers\[30\]\[9\] registers\[31\]\[9\]
+ _1053_ _1054_ VGND VGND VPWR VPWR _1228_ sky130_fd_sc_hd__mux4_1
XFILLER_0_13_198 VGND VGND VPWR VPWR sky130_fd_sc_hd__fill_2
X_7225_ _3502_ VGND VGND VPWR VPWR _3525_ sky130_fd_sc_hd__clkbuf_8
X_7156_ _3484_ VGND VGND VPWR VPWR _0016_ sky130_fd_sc_hd__clkbuf_1
XFILLER_0_6_62 VGND VGND VPWR VPWR sky130_fd_sc_hd__decap_4
X_4368_ registers\[0\]\[5\] registers\[1\]\[5\] registers\[2\]\[5\] registers\[3\]\[5\]
+ _1160_ _1161_ VGND VGND VPWR VPWR _1163_ sky130_fd_sc_hd__mux4_1
X_6107_ net96 _2816_ _2818_ VGND VGND VPWR VPWR _2820_ sky130_fd_sc_hd__and3_1
XANTENNA__4892__B1 net5 VGND VGND VPWR VPWR sky130_fd_sc_hd__diode_2
XANTENNA_input5_A a1[4] VGND VGND VPWR VPWR sky130_fd_sc_hd__diode_2
XANTENNA__4319__S0 _1111_ VGND VGND VPWR VPWR sky130_fd_sc_hd__diode_2
X_4299_ _1094_ _1095_ _1030_ VGND VGND VPWR VPWR _1096_ sky130_fd_sc_hd__mux2_1
X_7087_ registers\[16\]\[1\] _3437_ _3435_ VGND VGND VPWR VPWR _3438_ sky130_fd_sc_hd__mux2_1
X_6038_ _2538_ _2722_ VGND VGND VPWR VPWR _2755_ sky130_fd_sc_hd__nand2_1
XTAP_TAPCELL_ROW_29_639 VGND VPWR sky130_fd_sc_hd__tapvpwrvgnd_1
XFILLER_0_96_625 VGND VGND VPWR VPWR sky130_fd_sc_hd__decap_8
XFILLER_0_68_338 VGND VGND VPWR VPWR sky130_fd_sc_hd__fill_2
XTAP_TAPCELL_ROW_1_275 VGND VPWR sky130_fd_sc_hd__tapvpwrvgnd_1
XANTENNA__8386__A1 _3479_ VGND VGND VPWR VPWR sky130_fd_sc_hd__diode_2
XANTENNA__5729__S _2460_ VGND VGND VPWR VPWR sky130_fd_sc_hd__diode_2
XFILLER_0_95_146 VGND VGND VPWR VPWR sky130_fd_sc_hd__fill_1
X_7989_ _3930_ VGND VGND VPWR VPWR _0403_ sky130_fd_sc_hd__clkbuf_1
XANTENNA__8105__S _3984_ VGND VGND VPWR VPWR sky130_fd_sc_hd__diode_2
XANTENNA__5295__S1 _1759_ VGND VGND VPWR VPWR sky130_fd_sc_hd__diode_2
XANTENNA__8138__A1 _3433_ VGND VGND VPWR VPWR sky130_fd_sc_hd__diode_2
XFILLER_0_9_671 VGND VGND VPWR VPWR sky130_fd_sc_hd__fill_1
XFILLER_0_119_484 VGND VGND VPWR VPWR sky130_fd_sc_hd__decap_6
XANTENNA__7944__S _3901_ VGND VGND VPWR VPWR sky130_fd_sc_hd__diode_2
XFILLER_0_91_363 VGND VGND VPWR VPWR sky130_fd_sc_hd__decap_3
XANTENNA__5047__S1 _1759_ VGND VGND VPWR VPWR sky130_fd_sc_hd__diode_2
XFILLER_0_24_419 VGND VGND VPWR VPWR sky130_fd_sc_hd__fill_1
XFILLER_0_36_268 VGND VGND VPWR VPWR sky130_fd_sc_hd__decap_3
XFILLER_0_107_657 VGND VGND VPWR VPWR sky130_fd_sc_hd__decap_3
XFILLER_0_17_460 VGND VGND VPWR VPWR sky130_fd_sc_hd__fill_1
XFILLER_0_17_482 VGND VGND VPWR VPWR sky130_fd_sc_hd__fill_2
XFILLER_0_106_167 VGND VGND VPWR VPWR sky130_fd_sc_hd__decap_3
XTAP_TAPCELL_ROW_75_1235 VGND VPWR sky130_fd_sc_hd__tapvpwrvgnd_1
XFILLER_0_32_485 VGND VGND VPWR VPWR sky130_fd_sc_hd__fill_2
XANTENNA__5124__A1 _1809_ VGND VGND VPWR VPWR sky130_fd_sc_hd__diode_2
XANTENNA__4558__S0 _1320_ VGND VGND VPWR VPWR sky130_fd_sc_hd__diode_2
XTAP_TAPCELL_ROW_9_375 VGND VPWR sky130_fd_sc_hd__tapvpwrvgnd_1
XANTENNA__8074__A0 _2966_ VGND VGND VPWR VPWR sky130_fd_sc_hd__diode_2
XANTENNA__4808__S _1513_ VGND VGND VPWR VPWR sky130_fd_sc_hd__diode_2
XANTENNA__7821__A0 _3092_ VGND VGND VPWR VPWR sky130_fd_sc_hd__diode_2
XFILLER_0_99_485 VGND VGND VPWR VPWR sky130_fd_sc_hd__fill_2
XFILLER_0_87_636 VGND VGND VPWR VPWR sky130_fd_sc_hd__fill_2
XANTENNA__8377__A1 _3470_ VGND VGND VPWR VPWR sky130_fd_sc_hd__diode_2
XANTENNA__4730__S0 _1415_ VGND VGND VPWR VPWR sky130_fd_sc_hd__diode_2
XFILLER_0_87_658 VGND VGND VPWR VPWR sky130_fd_sc_hd__fill_2
XTAP_TAPCELL_ROW_86_1375 VGND VPWR sky130_fd_sc_hd__tapvpwrvgnd_1
XTAP_TAPCELL_ROW_56_992 VGND VPWR sky130_fd_sc_hd__tapvpwrvgnd_1
XTAP_TAPCELL_ROW_56_981 VGND VPWR sky130_fd_sc_hd__tapvpwrvgnd_1
XFILLER_0_86_179 VGND VGND VPWR VPWR sky130_fd_sc_hd__decap_4
XFILLER_0_86_168 VGND VGND VPWR VPWR sky130_fd_sc_hd__fill_1
XANTENNA__4938__B2 _1701_ VGND VGND VPWR VPWR sky130_fd_sc_hd__diode_2
XFILLER_0_12_21 VGND VGND VPWR VPWR sky130_fd_sc_hd__decap_4
XANTENNA__7854__S _3851_ VGND VGND VPWR VPWR sky130_fd_sc_hd__diode_2
XFILLER_0_55_599 VGND VGND VPWR VPWR sky130_fd_sc_hd__fill_1
XFILLER_0_12_76 VGND VGND VPWR VPWR sky130_fd_sc_hd__fill_2
XFILLER_0_88_25 VGND VGND VPWR VPWR sky130_fd_sc_hd__decap_3
XFILLER_0_42_238 VGND VGND VPWR VPWR sky130_fd_sc_hd__fill_1
XANTENNA__4779__A _1405_ VGND VGND VPWR VPWR sky130_fd_sc_hd__diode_2
XANTENNA__5374__S _2076_ VGND VGND VPWR VPWR sky130_fd_sc_hd__diode_2
Xoutput116 net116 VGND VGND VPWR VPWR rd2[12] sky130_fd_sc_hd__buf_1
XFILLER_0_2_346 VGND VGND VPWR VPWR sky130_fd_sc_hd__fill_1
X_5340_ _1977_ _2071_ _2078_ _2083_ VGND VGND VPWR VPWR _2084_ sky130_fd_sc_hd__o2bb2a_4
XFILLER_0_11_614 VGND VGND VPWR VPWR sky130_fd_sc_hd__fill_2
Xoutput105 net105 VGND VGND VPWR VPWR rd1[31] sky130_fd_sc_hd__buf_1
Xoutput138 net138 VGND VGND VPWR VPWR rd2[3] sky130_fd_sc_hd__buf_1
XANTENNA__4549__S0 _1198_ VGND VGND VPWR VPWR sky130_fd_sc_hd__diode_2
XFILLER_0_63_9 VGND VGND VPWR VPWR sky130_fd_sc_hd__fill_1
Xoutput127 net127 VGND VGND VPWR VPWR rd2[22] sky130_fd_sc_hd__buf_1
XFILLER_0_50_293 VGND VGND VPWR VPWR sky130_fd_sc_hd__fill_2
X_5271_ _2014_ _2017_ _1756_ VGND VGND VPWR VPWR _2018_ sky130_fd_sc_hd__mux2_1
XANTENNA__6863__A1 _3016_ VGND VGND VPWR VPWR sky130_fd_sc_hd__diode_2
X_7010_ _3133_ registers\[14\]\[31\] _3360_ VGND VGND VPWR VPWR _3395_ sky130_fd_sc_hd__mux2_1
XANTENNA__4718__S _1346_ VGND VGND VPWR VPWR sky130_fd_sc_hd__diode_2
XANTENNA__7812__A0 _3083_ VGND VGND VPWR VPWR sky130_fd_sc_hd__diode_2
X_8961_ clknet_leaf_112_clk _0058_ VGND VGND VPWR VPWR registers\[18\]\[1\] sky130_fd_sc_hd__dfxtp_1
XFILLER_0_78_603 VGND VGND VPWR VPWR sky130_fd_sc_hd__decap_6
XANTENNA__6933__S _3346_ VGND VGND VPWR VPWR sky130_fd_sc_hd__diode_2
X_7912_ _3115_ registers\[27\]\[22\] _3887_ VGND VGND VPWR VPWR _3890_ sky130_fd_sc_hd__mux2_1
X_8892_ clknet_leaf_105_clk _1013_ VGND VGND VPWR VPWR registers\[15\]\[28\] sky130_fd_sc_hd__dfxtp_1
XANTENNA__4721__S0 _1404_ VGND VGND VPWR VPWR sky130_fd_sc_hd__diode_2
XFILLER_0_53_61 VGND VGND VPWR VPWR sky130_fd_sc_hd__decap_4
X_7843_ _3853_ VGND VGND VPWR VPWR _0334_ sky130_fd_sc_hd__clkbuf_1
XFILLER_0_93_617 VGND VGND VPWR VPWR sky130_fd_sc_hd__fill_2
X_4986_ _1705_ VGND VGND VPWR VPWR _1748_ sky130_fd_sc_hd__clkbuf_8
XANTENNA__6234__A _2182_ VGND VGND VPWR VPWR sky130_fd_sc_hd__diode_2
X_7774_ _3113_ registers\[25\]\[21\] _3815_ VGND VGND VPWR VPWR _3817_ sky130_fd_sc_hd__mux2_1
X_9513_ clknet_leaf_18_clk _0610_ VGND VGND VPWR VPWR registers\[8\]\[9\] sky130_fd_sc_hd__dfxtp_1
XFILLER_0_46_533 VGND VGND VPWR VPWR sky130_fd_sc_hd__fill_1
XFILLER_0_18_213 VGND VGND VPWR VPWR sky130_fd_sc_hd__fill_2
X_6725_ registers\[10\]\[26\] _3016_ _3236_ VGND VGND VPWR VPWR _3243_ sky130_fd_sc_hd__mux2_1
XFILLER_0_116_421 VGND VGND VPWR VPWR sky130_fd_sc_hd__decap_3
XTAP_TAPCELL_ROW_34_697 VGND VPWR sky130_fd_sc_hd__tapvpwrvgnd_1
X_9444_ clknet_leaf_29_clk _0541_ VGND VGND VPWR VPWR registers\[31\]\[4\] sky130_fd_sc_hd__dfxtp_1
XANTENNA__8540__A1 net39 VGND VGND VPWR VPWR sky130_fd_sc_hd__diode_2
X_6656_ registers\[0\]\[27\] _3018_ _3197_ VGND VGND VPWR VPWR _3205_ sky130_fd_sc_hd__mux2_1
XFILLER_0_104_627 VGND VGND VPWR VPWR sky130_fd_sc_hd__decap_3
X_5607_ _2340_ _2341_ VGND VGND VPWR VPWR _2342_ sky130_fd_sc_hd__nand2_1
X_6587_ _3167_ VGND VGND VPWR VPWR _0788_ sky130_fd_sc_hd__clkbuf_1
X_9375_ clknet_leaf_2_clk _0472_ VGND VGND VPWR VPWR registers\[30\]\[31\] sky130_fd_sc_hd__dfxtp_1
XFILLER_0_104_649 VGND VGND VPWR VPWR sky130_fd_sc_hd__fill_2
X_5538_ _1049_ net81 VGND VGND VPWR VPWR _2274_ sky130_fd_sc_hd__nor2_2
X_8326_ _3014_ registers\[31\]\[25\] _4103_ VGND VGND VPWR VPWR _4109_ sky130_fd_sc_hd__mux2_1
XFILLER_0_14_452 VGND VGND VPWR VPWR sky130_fd_sc_hd__fill_2
XFILLER_0_14_474 VGND VGND VPWR VPWR sky130_fd_sc_hd__fill_2
XFILLER_0_41_293 VGND VGND VPWR VPWR sky130_fd_sc_hd__fill_2
X_8257_ _4072_ VGND VGND VPWR VPWR _0529_ sky130_fd_sc_hd__clkbuf_1
XFILLER_0_112_682 VGND VGND VPWR VPWR sky130_fd_sc_hd__decap_8
X_7208_ _3516_ VGND VGND VPWR VPWR _0036_ sky130_fd_sc_hd__clkbuf_1
XANTENNA__5201__S1 _1821_ VGND VGND VPWR VPWR sky130_fd_sc_hd__diode_2
X_5469_ _1286_ _1302_ _1319_ _1337_ VGND VGND VPWR VPWR _2205_ sky130_fd_sc_hd__and4_1
XTAP_TAPCELL_ROW_6_334 VGND VPWR sky130_fd_sc_hd__tapvpwrvgnd_1
X_8188_ registers\[9\]\[24\] _3485_ _4031_ VGND VGND VPWR VPWR _4036_ sky130_fd_sc_hd__mux2_1
XTAP_TAPCELL_ROW_70_1165 VGND VPWR sky130_fd_sc_hd__tapvpwrvgnd_1
X_7139_ registers\[16\]\[18\] _3472_ _3456_ VGND VGND VPWR VPWR _3473_ sky130_fd_sc_hd__mux2_1
XANTENNA__4614__A1_N _1372_ VGND VGND VPWR VPWR sky130_fd_sc_hd__diode_2
XANTENNA__7004__S _3383_ VGND VGND VPWR VPWR sky130_fd_sc_hd__diode_2
XANTENNA__4712__S0 _1418_ VGND VGND VPWR VPWR sky130_fd_sc_hd__diode_2
XANTENNA__5967__B _2362_ VGND VGND VPWR VPWR sky130_fd_sc_hd__diode_2
XFILLER_0_68_168 VGND VGND VPWR VPWR sky130_fd_sc_hd__fill_2
XFILLER_0_68_157 VGND VGND VPWR VPWR sky130_fd_sc_hd__fill_2
XTAP_TAPCELL_ROW_53_951 VGND VPWR sky130_fd_sc_hd__tapvpwrvgnd_1
XANTENNA__5268__S1 _1969_ VGND VGND VPWR VPWR sky130_fd_sc_hd__diode_2
XFILLER_0_37_533 VGND VGND VPWR VPWR sky130_fd_sc_hd__fill_1
XFILLER_0_119_281 VPWR VGND VPWR VGND sky130_ef_sc_hd__decap_12
XFILLER_0_92_661 VGND VGND VPWR VPWR sky130_fd_sc_hd__decap_3
XANTENNA__7674__S _3757_ VGND VGND VPWR VPWR sky130_fd_sc_hd__diode_2
XFILLER_0_64_341 VGND VGND VPWR VPWR sky130_fd_sc_hd__decap_4
Xinput18 wd3[11] VGND VGND VPWR VPWR net18 sky130_fd_sc_hd__buf_2
XFILLER_0_64_363 VGND VGND VPWR VPWR sky130_fd_sc_hd__fill_1
XFILLER_0_9_490 VGND VGND VPWR VPWR sky130_fd_sc_hd__fill_1
Xinput29 wd3[21] VGND VGND VPWR VPWR net29 sky130_fd_sc_hd__clkbuf_4
XANTENNA__4599__A _1124_ VGND VGND VPWR VPWR sky130_fd_sc_hd__diode_2
XANTENNA__5896__A2 _2587_ VGND VGND VPWR VPWR sky130_fd_sc_hd__diode_2
XANTENNA__5440__S1 _1760_ VGND VGND VPWR VPWR sky130_fd_sc_hd__diode_2
XANTENNA__7703__A _3756_ VGND VGND VPWR VPWR sky130_fd_sc_hd__diode_2
XFILLER_0_102_192 VGND VGND VPWR VPWR sky130_fd_sc_hd__fill_2
XFILLER_0_20_499 VGND VGND VPWR VPWR sky130_fd_sc_hd__fill_2
XANTENNA__4951__S0 _1690_ VGND VGND VPWR VPWR sky130_fd_sc_hd__diode_2
XANTENNA__6319__A net28 VGND VGND VPWR VPWR sky130_fd_sc_hd__diode_2
XTAP_TAPCELL_ROW_88_1404 VGND VPWR sky130_fd_sc_hd__tapvpwrvgnd_1
XFILLER_0_74_27 VGND VGND VPWR VPWR sky130_fd_sc_hd__fill_1
XANTENNA__6058__C1 _1979_ VGND VGND VPWR VPWR sky130_fd_sc_hd__diode_2
XANTENNA__5223__A _1756_ VGND VGND VPWR VPWR sky130_fd_sc_hd__diode_2
XANTENNA__7270__A1 _3453_ VGND VGND VPWR VPWR sky130_fd_sc_hd__diode_2
XANTENNA__6753__S _3250_ VGND VGND VPWR VPWR sky130_fd_sc_hd__diode_2
XANTENNA__4703__S0 _1415_ VGND VGND VPWR VPWR sky130_fd_sc_hd__diode_2
XFILLER_0_114_22 VGND VGND VPWR VPWR sky130_fd_sc_hd__fill_2
XFILLER_0_114_11 VGND VGND VPWR VPWR sky130_fd_sc_hd__fill_2
XANTENNA__6054__A _2362_ VGND VGND VPWR VPWR sky130_fd_sc_hd__diode_2
XFILLER_0_75_628 VGND VGND VPWR VPWR sky130_fd_sc_hd__fill_1
XANTENNA__5259__S1 _1760_ VGND VGND VPWR VPWR sky130_fd_sc_hd__diode_2
X_4840_ _1607_ _1608_ _1386_ VGND VGND VPWR VPWR _1609_ sky130_fd_sc_hd__mux2_1
XFILLER_0_87_499 VGND VGND VPWR VPWR sky130_fd_sc_hd__fill_2
XFILLER_0_28_533 VGND VGND VPWR VPWR sky130_fd_sc_hd__fill_2
XFILLER_0_114_99 VGND VGND VPWR VPWR sky130_fd_sc_hd__fill_2
XFILLER_0_7_449 VGND VGND VPWR VPWR sky130_fd_sc_hd__fill_2
X_4771_ _1513_ _1543_ _1124_ VGND VGND VPWR VPWR _1544_ sky130_fd_sc_hd__a21o_1
X_6510_ _3123_ registers\[29\]\[26\] _3111_ VGND VGND VPWR VPWR _3124_ sky130_fd_sc_hd__mux2_1
XFILLER_0_28_544 VGND VGND VPWR VPWR sky130_fd_sc_hd__fill_2
XTAP_TAPCELL_ROW_99_1544 VGND VPWR sky130_fd_sc_hd__tapvpwrvgnd_1
X_7490_ _3102_ registers\[21\]\[16\] _3659_ VGND VGND VPWR VPWR _3666_ sky130_fd_sc_hd__mux2_1
XANTENNA__8522__A1 net29 VGND VGND VPWR VPWR sky130_fd_sc_hd__diode_2
XTAP_TAPCELL_ROW_31_656 VGND VPWR sky130_fd_sc_hd__tapvpwrvgnd_1
XTAP_TAPCELL_ROW_31_667 VGND VPWR sky130_fd_sc_hd__tapvpwrvgnd_1
X_6441_ net42 VGND VGND VPWR VPWR _3077_ sky130_fd_sc_hd__clkbuf_2
XFILLER_0_99_57 VGND VGND VPWR VPWR sky130_fd_sc_hd__fill_2
X_6372_ _3037_ VGND VGND VPWR VPWR _0703_ sky130_fd_sc_hd__clkbuf_1
X_9160_ clknet_leaf_19_clk _0257_ VGND VGND VPWR VPWR registers\[24\]\[8\] sky130_fd_sc_hd__dfxtp_1
XANTENNA__4302__A _1031_ VGND VGND VPWR VPWR sky130_fd_sc_hd__diode_2
XANTENNA__5431__S1 _1997_ VGND VGND VPWR VPWR sky130_fd_sc_hd__diode_2
XFILLER_0_2_121 VPWR VGND VPWR VGND sky130_ef_sc_hd__decap_12
XFILLER_0_101_608 VGND VGND VPWR VPWR sky130_fd_sc_hd__decap_8
XFILLER_0_70_399 VGND VGND VPWR VPWR sky130_fd_sc_hd__decap_4
X_5323_ _2065_ _2066_ _2031_ VGND VGND VPWR VPWR _2067_ sky130_fd_sc_hd__mux2_1
X_8111_ _3972_ VGND VGND VPWR VPWR _3995_ sky130_fd_sc_hd__buf_4
X_9091_ clknet_leaf_22_clk _0188_ VGND VGND VPWR VPWR registers\[22\]\[3\] sky130_fd_sc_hd__dfxtp_1
XANTENNA__7613__A _3719_ VGND VGND VPWR VPWR sky130_fd_sc_hd__diode_2
XANTENNA__6836__A1 _2989_ VGND VGND VPWR VPWR sky130_fd_sc_hd__diode_2
X_8042_ _3958_ VGND VGND VPWR VPWR _0428_ sky130_fd_sc_hd__clkbuf_1
XFILLER_0_48_50 VGND VGND VPWR VPWR sky130_fd_sc_hd__fill_2
X_5254_ _1998_ _1999_ _2000_ _2001_ _1856_ _1771_ VGND VGND VPWR VPWR _2002_ sky130_fd_sc_hd__mux4_2
X_5185_ registers\[12\]\[16\] registers\[13\]\[16\] registers\[14\]\[16\] registers\[15\]\[16\]
+ _1742_ _1743_ VGND VGND VPWR VPWR _1937_ sky130_fd_sc_hd__mux4_1
XTAP_TAPCELL_ROW_3_304 VGND VPWR sky130_fd_sc_hd__tapvpwrvgnd_1
XFILLER_0_3_30 VGND VGND VPWR VPWR sky130_fd_sc_hd__fill_2
XANTENNA__7759__S _3804_ VGND VGND VPWR VPWR sky130_fd_sc_hd__diode_2
XFILLER_0_3_52 VGND VGND VPWR VPWR sky130_fd_sc_hd__decap_4
X_8944_ clknet_leaf_62_clk _0041_ VGND VGND VPWR VPWR registers\[17\]\[16\] sky130_fd_sc_hd__dfxtp_1
XTAP_TAPCELL_ROW_39_767 VGND VPWR sky130_fd_sc_hd__tapvpwrvgnd_1
XTAP_TAPCELL_ROW_108_1662 VGND VPWR sky130_fd_sc_hd__tapvpwrvgnd_1
X_8875_ clknet_leaf_53_clk _0996_ VGND VGND VPWR VPWR registers\[15\]\[11\] sky130_fd_sc_hd__dfxtp_1
X_7826_ _3844_ VGND VGND VPWR VPWR _0326_ sky130_fd_sc_hd__clkbuf_1
XTAP_TAPCELL_ROW_50_910 VGND VPWR sky130_fd_sc_hd__tapvpwrvgnd_1
X_4969_ registers\[8\]\[5\] registers\[9\]\[5\] registers\[10\]\[5\] registers\[11\]\[5\]
+ _1731_ _1691_ VGND VGND VPWR VPWR _1732_ sky130_fd_sc_hd__mux4_1
X_7757_ _3096_ registers\[25\]\[13\] _3804_ VGND VGND VPWR VPWR _3808_ sky130_fd_sc_hd__mux2_1
XFILLER_0_93_458 VGND VGND VPWR VPWR sky130_fd_sc_hd__fill_2
XFILLER_0_74_661 VGND VGND VPWR VPWR sky130_fd_sc_hd__decap_4
XANTENNA__7494__S _3659_ VGND VGND VPWR VPWR sky130_fd_sc_hd__diode_2
X_7688_ _3771_ VGND VGND VPWR VPWR _0261_ sky130_fd_sc_hd__clkbuf_1
XANTENNA__8513__A1 net24 VGND VGND VPWR VPWR sky130_fd_sc_hd__diode_2
XFILLER_0_74_672 VGND VGND VPWR VPWR sky130_fd_sc_hd__fill_2
X_6708_ registers\[10\]\[18\] _2999_ _3225_ VGND VGND VPWR VPWR _3234_ sky130_fd_sc_hd__mux2_1
X_9427_ clknet_leaf_14_clk _0524_ VGND VGND VPWR VPWR registers\[6\]\[19\] sky130_fd_sc_hd__dfxtp_1
X_6639_ registers\[0\]\[19\] _3001_ _3186_ VGND VGND VPWR VPWR _3196_ sky130_fd_sc_hd__mux2_1
XFILLER_0_34_569 VGND VGND VPWR VPWR sky130_fd_sc_hd__fill_1
XANTENNA__5878__A2 _2587_ VGND VGND VPWR VPWR sky130_fd_sc_hd__diode_2
XTAP_TAPCELL_ROW_59_1027 VGND VPWR sky130_fd_sc_hd__tapvpwrvgnd_1
XANTENNA__5422__S1 _2120_ VGND VGND VPWR VPWR sky130_fd_sc_hd__diode_2
X_9358_ clknet_leaf_54_clk _0455_ VGND VGND VPWR VPWR registers\[30\]\[14\] sky130_fd_sc_hd__dfxtp_1
XFILLER_0_104_468 VGND VGND VPWR VPWR sky130_fd_sc_hd__fill_2
X_8309_ _2997_ registers\[31\]\[17\] _4092_ VGND VGND VPWR VPWR _4100_ sky130_fd_sc_hd__mux2_1
XANTENNA__6838__S _3299_ VGND VGND VPWR VPWR sky130_fd_sc_hd__diode_2
X_9289_ clknet_leaf_8_clk _0386_ VGND VGND VPWR VPWR registers\[28\]\[9\] sky130_fd_sc_hd__dfxtp_1
XANTENNA__6827__A1 _2980_ VGND VGND VPWR VPWR sky130_fd_sc_hd__diode_2
XPHY_EDGE_ROW_110_Right_110 VGND VGND VPWR VPWR sky130_fd_sc_hd__decap_3
XANTENNA__4933__S0 _1678_ VGND VGND VPWR VPWR sky130_fd_sc_hd__diode_2
XANTENNA__7252__A1 _3433_ VGND VGND VPWR VPWR sky130_fd_sc_hd__diode_2
XFILLER_0_97_720 VGND VGND VPWR VPWR sky130_fd_sc_hd__decap_8
XFILLER_0_84_403 VGND VGND VPWR VPWR sky130_fd_sc_hd__fill_2
XTAP_TAPCELL_ROW_83_1334 VGND VPWR sky130_fd_sc_hd__tapvpwrvgnd_1
XFILLER_0_69_466 VGND VGND VPWR VPWR sky130_fd_sc_hd__fill_2
XANTENNA__5189__S _1752_ VGND VGND VPWR VPWR sky130_fd_sc_hd__diode_2
XANTENNA_clkbuf_leaf_70_clk_A clknet_4_11_0_clk VGND VGND VPWR VPWR sky130_fd_sc_hd__diode_2
XFILLER_0_96_285 VGND VGND VPWR VPWR sky130_fd_sc_hd__fill_2
XFILLER_0_84_458 VGND VGND VPWR VPWR sky130_fd_sc_hd__decap_6
XFILLER_0_65_661 VGND VGND VPWR VPWR sky130_fd_sc_hd__decap_4
XFILLER_0_60_29 VGND VGND VPWR VPWR sky130_fd_sc_hd__decap_4
XFILLER_0_71_119 VGND VGND VPWR VPWR sky130_fd_sc_hd__decap_3
XFILLER_0_65_683 VGND VGND VPWR VPWR sky130_fd_sc_hd__fill_1
XANTENNA__4821__S _1421_ VGND VGND VPWR VPWR sky130_fd_sc_hd__diode_2
XANTENNA_clkbuf_leaf_85_clk_A clknet_4_8_0_clk VGND VGND VPWR VPWR sky130_fd_sc_hd__diode_2
XFILLER_0_80_642 VGND VGND VPWR VPWR sky130_fd_sc_hd__fill_2
XANTENNA__5318__B2 _1701_ VGND VGND VPWR VPWR sky130_fd_sc_hd__diode_2
XFILLER_0_80_664 VGND VGND VPWR VPWR sky130_fd_sc_hd__fill_2
XANTENNA__5218__A _1810_ VGND VGND VPWR VPWR sky130_fd_sc_hd__diode_2
XTAP_TAPCELL_ROW_94_1485 VGND VPWR sky130_fd_sc_hd__tapvpwrvgnd_1
XANTENNA_clkbuf_leaf_23_clk_A clknet_4_4_0_clk VGND VGND VPWR VPWR sky130_fd_sc_hd__diode_2
XFILLER_0_109_77 VGND VGND VPWR VPWR sky130_fd_sc_hd__fill_2
XANTENNA__7579__S _3706_ VGND VGND VPWR VPWR sky130_fd_sc_hd__diode_2
XFILLER_0_79_208 VPWR VGND VPWR VGND sky130_ef_sc_hd__decap_12
Xclkbuf_4_1_0_clk clknet_0_clk VGND VGND VPWR VPWR clknet_4_1_0_clk sky130_fd_sc_hd__clkbuf_8
XANTENNA__4792__A _1389_ VGND VGND VPWR VPWR sky130_fd_sc_hd__diode_2
X_6990_ _3113_ registers\[14\]\[21\] _3383_ VGND VGND VPWR VPWR _3385_ sky130_fd_sc_hd__mux2_1
XANTENNA_clkbuf_leaf_38_clk_A clknet_4_7_0_clk VGND VGND VPWR VPWR sky130_fd_sc_hd__diode_2
X_5941_ _1899_ _2644_ _2645_ _2623_ _1882_ VGND VGND VPWR VPWR _2663_ sky130_fd_sc_hd__a311o_1
XTAP_TAPCELL_ROW_36_726 VGND VPWR sky130_fd_sc_hd__tapvpwrvgnd_1
XFILLER_0_87_252 VGND VGND VPWR VPWR sky130_fd_sc_hd__fill_1
XFILLER_0_34_52 VGND VGND VPWR VPWR sky130_fd_sc_hd__fill_1
XFILLER_0_87_285 VGND VGND VPWR VPWR sky130_fd_sc_hd__decap_4
XFILLER_0_75_425 VGND VGND VPWR VPWR sky130_fd_sc_hd__fill_1
X_5872_ _1851_ _2596_ VGND VGND VPWR VPWR _2598_ sky130_fd_sc_hd__and2_1
XFILLER_0_34_85 VGND VGND VPWR VPWR sky130_fd_sc_hd__decap_3
X_8660_ clknet_leaf_92_clk _0781_ VGND VGND VPWR VPWR registers\[7\]\[20\] sky130_fd_sc_hd__dfxtp_1
XANTENNA__5101__S0 _1773_ VGND VGND VPWR VPWR sky130_fd_sc_hd__diode_2
X_8591_ clknet_leaf_47_clk _0712_ VGND VGND VPWR VPWR registers\[3\]\[15\] sky130_fd_sc_hd__dfxtp_1
X_4823_ registers\[8\]\[30\] registers\[9\]\[30\] registers\[10\]\[30\] registers\[11\]\[30\]
+ _1382_ _1383_ VGND VGND VPWR VPWR _1593_ sky130_fd_sc_hd__mux4_1
X_7611_ _3087_ registers\[23\]\[9\] _3720_ VGND VGND VPWR VPWR _3730_ sky130_fd_sc_hd__mux2_1
XFILLER_0_8_714 VPWR VGND VPWR VGND sky130_ef_sc_hd__decap_12
XTAP_TAPCELL_ROW_16_461 VGND VPWR sky130_fd_sc_hd__tapvpwrvgnd_1
XTAP_TAPCELL_ROW_16_472 VGND VPWR sky130_fd_sc_hd__tapvpwrvgnd_1
XTAP_TAPCELL_ROW_103_1592 VGND VPWR sky130_fd_sc_hd__tapvpwrvgnd_1
XFILLER_0_62_108 VGND VGND VPWR VPWR sky130_fd_sc_hd__decap_3
X_7542_ _3693_ VGND VGND VPWR VPWR _0193_ sky130_fd_sc_hd__clkbuf_1
XANTENNA__4731__S _1421_ VGND VGND VPWR VPWR sky130_fd_sc_hd__diode_2
XANTENNA__6512__A net35 VGND VGND VPWR VPWR sky130_fd_sc_hd__diode_2
X_4754_ registers\[4\]\[26\] registers\[5\]\[26\] registers\[6\]\[26\] registers\[7\]\[26\]
+ _1323_ _1324_ VGND VGND VPWR VPWR _1528_ sky130_fd_sc_hd__mux4_1
XFILLER_0_83_480 VGND VGND VPWR VPWR sky130_fd_sc_hd__fill_2
XFILLER_0_71_653 VGND VGND VPWR VPWR sky130_fd_sc_hd__fill_2
XFILLER_0_71_631 VGND VGND VPWR VPWR sky130_fd_sc_hd__fill_2
X_7473_ _3085_ registers\[21\]\[8\] _3648_ VGND VGND VPWR VPWR _3657_ sky130_fd_sc_hd__mux2_1
XFILLER_0_55_193 VGND VGND VPWR VPWR sky130_fd_sc_hd__fill_2
XANTENNA__5128__A _1731_ VGND VGND VPWR VPWR sky130_fd_sc_hd__diode_2
X_4685_ _1362_ _1462_ _1135_ VGND VGND VPWR VPWR _1463_ sky130_fd_sc_hd__o21a_1
XANTENNA__5404__S1 _2073_ VGND VGND VPWR VPWR sky130_fd_sc_hd__diode_2
X_9212_ clknet_leaf_103_clk _0309_ VGND VGND VPWR VPWR registers\[25\]\[28\] sky130_fd_sc_hd__dfxtp_1
X_6424_ _3064_ VGND VGND VPWR VPWR _0728_ sky130_fd_sc_hd__clkbuf_1
XANTENNA__5190__C1 _1778_ VGND VGND VPWR VPWR sky130_fd_sc_hd__diode_2
XANTENNA__6658__S _3197_ VGND VGND VPWR VPWR sky130_fd_sc_hd__diode_2
XFILLER_0_11_241 VGND VGND VPWR VPWR sky130_fd_sc_hd__fill_2
X_6355_ _3027_ VGND VGND VPWR VPWR _0696_ sky130_fd_sc_hd__clkbuf_1
X_9143_ clknet_leaf_75_clk _0240_ VGND VGND VPWR VPWR registers\[23\]\[23\] sky130_fd_sc_hd__dfxtp_1
XANTENNA__5168__S0 _1748_ VGND VGND VPWR VPWR sky130_fd_sc_hd__diode_2
X_9074_ clknet_leaf_72_clk _0171_ VGND VGND VPWR VPWR registers\[21\]\[18\] sky130_fd_sc_hd__dfxtp_1
X_6286_ registers\[19\]\[9\] _2980_ _2962_ VGND VGND VPWR VPWR _2981_ sky130_fd_sc_hd__mux2_1
X_5306_ _2049_ _2050_ _1695_ VGND VGND VPWR VPWR _2051_ sky130_fd_sc_hd__mux2_1
XFILLER_0_11_252 VGND VGND VPWR VPWR sky130_fd_sc_hd__decap_3
XANTENNA__6809__A1 _2958_ VGND VGND VPWR VPWR sky130_fd_sc_hd__diode_2
X_8025_ registers\[2\]\[11\] _3458_ _3948_ VGND VGND VPWR VPWR _3950_ sky130_fd_sc_hd__mux2_1
X_5237_ _1982_ _1985_ _1687_ VGND VGND VPWR VPWR _1986_ sky130_fd_sc_hd__mux2_1
XANTENNA__4915__S0 _1678_ VGND VGND VPWR VPWR sky130_fd_sc_hd__diode_2
X_5168_ registers\[4\]\[15\] registers\[5\]\[15\] registers\[6\]\[15\] registers\[7\]\[15\]
+ _1748_ _1749_ VGND VGND VPWR VPWR _1921_ sky130_fd_sc_hd__mux4_1
X_5099_ _1689_ VGND VGND VPWR VPWR _1856_ sky130_fd_sc_hd__buf_6
XANTENNA__7234__A1 _3485_ VGND VGND VPWR VPWR sky130_fd_sc_hd__diode_2
X_8927_ clknet_leaf_100_clk _0024_ VGND VGND VPWR VPWR registers\[16\]\[31\] sky130_fd_sc_hd__dfxtp_1
XFILLER_0_94_701 VPWR VGND VPWR VGND sky130_ef_sc_hd__decap_12
XFILLER_0_39_617 VGND VGND VPWR VPWR sky130_fd_sc_hd__fill_2
XFILLER_0_93_211 VGND VGND VPWR VPWR sky130_fd_sc_hd__fill_2
XFILLER_0_91_80 VGND VGND VPWR VPWR sky130_fd_sc_hd__fill_1
X_8858_ clknet_leaf_91_clk _0979_ VGND VGND VPWR VPWR registers\[14\]\[26\] sky130_fd_sc_hd__dfxtp_1
XANTENNA__5548__A1 _1913_ VGND VGND VPWR VPWR sky130_fd_sc_hd__diode_2
X_7809_ _3835_ VGND VGND VPWR VPWR _0318_ sky130_fd_sc_hd__clkbuf_1
XFILLER_0_81_406 VGND VGND VPWR VPWR sky130_fd_sc_hd__fill_2
XFILLER_0_66_469 VGND VGND VPWR VPWR sky130_fd_sc_hd__fill_2
XFILLER_0_54_609 VGND VGND VPWR VPWR sky130_fd_sc_hd__decap_3
X_8789_ clknet_leaf_83_clk _0910_ VGND VGND VPWR VPWR registers\[12\]\[21\] sky130_fd_sc_hd__dfxtp_1
XFILLER_0_53_119 VGND VGND VPWR VPWR sky130_fd_sc_hd__fill_2
XFILLER_0_104_221 VGND VGND VPWR VPWR sky130_fd_sc_hd__decap_4
XFILLER_0_61_152 VGND VGND VPWR VPWR sky130_fd_sc_hd__fill_2
XANTENNA__7952__S _3901_ VGND VGND VPWR VPWR sky130_fd_sc_hd__diode_2
XANTENNA__5038__A _1731_ VGND VGND VPWR VPWR sky130_fd_sc_hd__diode_2
XANTENNA_input43_A wd3[5] VGND VGND VPWR VPWR sky130_fd_sc_hd__diode_2
XANTENNA__4906__S0 _1642_ VGND VGND VPWR VPWR sky130_fd_sc_hd__diode_2
XANTENNA__4382__S1 _1161_ VGND VGND VPWR VPWR sky130_fd_sc_hd__diode_2
XANTENNA__7399__S _3612_ VGND VGND VPWR VPWR sky130_fd_sc_hd__diode_2
XFILLER_0_97_561 VPWR VGND VPWR VGND sky130_ef_sc_hd__decap_12
XANTENNA__5331__S0 _2072_ VGND VGND VPWR VPWR sky130_fd_sc_hd__diode_2
XFILLER_0_84_222 VGND VGND VPWR VPWR sky130_fd_sc_hd__decap_4
XFILLER_0_29_127 VGND VGND VPWR VPWR sky130_fd_sc_hd__fill_2
XFILLER_0_57_469 VGND VGND VPWR VPWR sky130_fd_sc_hd__fill_2
XFILLER_0_38_650 VGND VGND VPWR VPWR sky130_fd_sc_hd__decap_3
XANTENNA__8023__S _3948_ VGND VGND VPWR VPWR sky130_fd_sc_hd__diode_2
XANTENNA__6332__A net32 VGND VGND VPWR VPWR sky130_fd_sc_hd__diode_2
XTAP_TAPCELL_ROW_13_431 VGND VPWR sky130_fd_sc_hd__tapvpwrvgnd_1
XFILLER_0_111_23 VGND VGND VPWR VPWR sky130_fd_sc_hd__decap_6
XTAP_TAPCELL_ROW_96_1503 VGND VPWR sky130_fd_sc_hd__tapvpwrvgnd_1
XFILLER_0_52_141 VGND VGND VPWR VPWR sky130_fd_sc_hd__fill_2
XTAP_TAPCELL_ROW_41_795 VGND VPWR sky130_fd_sc_hd__tapvpwrvgnd_1
XANTENNA__7862__S _3828_ VGND VGND VPWR VPWR sky130_fd_sc_hd__diode_2
X_4470_ registers\[24\]\[11\] registers\[25\]\[11\] registers\[26\]\[11\] registers\[27\]\[11\]
+ _1197_ _1203_ VGND VGND VPWR VPWR _1259_ sky130_fd_sc_hd__mux4_1
XFILLER_0_111_78 VGND VGND VPWR VPWR sky130_fd_sc_hd__decap_4
XFILLER_0_40_325 VGND VGND VPWR VPWR sky130_fd_sc_hd__fill_1
XANTENNA__5398__S0 _2097_ VGND VGND VPWR VPWR sky130_fd_sc_hd__diode_2
XFILLER_0_20_76 VGND VGND VPWR VPWR sky130_fd_sc_hd__fill_1
XFILLER_0_40_369 VGND VGND VPWR VPWR sky130_fd_sc_hd__fill_2
X_6140_ _2298_ _2787_ _2850_ _2321_ VGND VGND VPWR VPWR _2851_ sky130_fd_sc_hd__a22o_1
XANTENNA__7163__A net34 VGND VGND VPWR VPWR sky130_fd_sc_hd__diode_2
XFILLER_0_21_561 VGND VGND VPWR VPWR sky130_fd_sc_hd__fill_2
XFILLER_0_21_572 VGND VGND VPWR VPWR sky130_fd_sc_hd__fill_2
XFILLER_0_0_477 VGND VGND VPWR VPWR sky130_fd_sc_hd__fill_2
X_6071_ _2368_ _2374_ VGND VGND VPWR VPWR _2786_ sky130_fd_sc_hd__nand2_1
XFILLER_0_29_63 VGND VGND VPWR VPWR sky130_fd_sc_hd__fill_2
X_5022_ _1781_ _1782_ _1627_ VGND VGND VPWR VPWR _1783_ sky130_fd_sc_hd__mux2_1
XFILLER_0_31_7 VGND VGND VPWR VPWR sky130_fd_sc_hd__decap_3
XANTENNA__7102__S _3435_ VGND VGND VPWR VPWR sky130_fd_sc_hd__diode_2
XTAP_TAPCELL_ROW_105_1621 VGND VPWR sky130_fd_sc_hd__tapvpwrvgnd_1
X_6973_ _3096_ registers\[14\]\[13\] _3372_ VGND VGND VPWR VPWR _3376_ sky130_fd_sc_hd__mux2_1
XFILLER_0_76_701 VPWR VGND VPWR VGND sky130_ef_sc_hd__decap_12
XTAP_TAPCELL_ROW_49_895 VGND VPWR sky130_fd_sc_hd__tapvpwrvgnd_1
XFILLER_0_45_84 VGND VGND VPWR VPWR sky130_fd_sc_hd__fill_2
XANTENNA__5322__S0 _2020_ VGND VGND VPWR VPWR sky130_fd_sc_hd__diode_2
XFILLER_0_88_594 VGND VGND VPWR VPWR sky130_fd_sc_hd__fill_1
XFILLER_0_88_572 VGND VGND VPWR VPWR sky130_fd_sc_hd__decap_3
X_8712_ clknet_leaf_18_clk _0833_ VGND VGND VPWR VPWR registers\[10\]\[8\] sky130_fd_sc_hd__dfxtp_1
XFILLER_0_75_222 VGND VGND VPWR VPWR sky130_fd_sc_hd__fill_2
X_5924_ _1899_ _2646_ VGND VGND VPWR VPWR _2647_ sky130_fd_sc_hd__xnor2_1
XFILLER_0_48_414 VGND VGND VPWR VPWR sky130_fd_sc_hd__fill_2
XANTENNA__6941__S _3323_ VGND VGND VPWR VPWR sky130_fd_sc_hd__diode_2
X_5855_ _2494_ _2581_ _2344_ VGND VGND VPWR VPWR _2582_ sky130_fd_sc_hd__mux2_1
X_8643_ clknet_leaf_22_clk _0764_ VGND VGND VPWR VPWR registers\[7\]\[3\] sky130_fd_sc_hd__dfxtp_1
XFILLER_0_61_61 VGND VGND VPWR VPWR sky130_fd_sc_hd__fill_1
XFILLER_0_8_522 VGND VGND VPWR VPWR sky130_fd_sc_hd__fill_1
XFILLER_0_0_53 VGND VGND VPWR VPWR sky130_fd_sc_hd__decap_3
XFILLER_0_61_72 VGND VGND VPWR VPWR sky130_fd_sc_hd__fill_2
XFILLER_0_8_555 VGND VGND VPWR VPWR sky130_fd_sc_hd__fill_2
XFILLER_0_8_533 VGND VGND VPWR VPWR sky130_fd_sc_hd__fill_2
XFILLER_0_0_97 VPWR VGND VPWR VGND sky130_ef_sc_hd__decap_12
X_4806_ registers\[4\]\[29\] registers\[5\]\[29\] registers\[6\]\[29\] registers\[7\]\[29\]
+ _1550_ _1551_ VGND VGND VPWR VPWR _1577_ sky130_fd_sc_hd__mux4_1
X_5786_ _2483_ _2514_ _2515_ VGND VGND VPWR VPWR _2516_ sky130_fd_sc_hd__o21a_1
X_8574_ clknet_leaf_97_clk _0695_ VGND VGND VPWR VPWR registers\[19\]\[30\] sky130_fd_sc_hd__dfxtp_1
XFILLER_0_16_333 VGND VGND VPWR VPWR sky130_fd_sc_hd__fill_2
XFILLER_0_29_694 VGND VGND VPWR VPWR sky130_fd_sc_hd__fill_2
XFILLER_0_9_51 VGND VGND VPWR VPWR sky130_fd_sc_hd__fill_2
X_4737_ _1386_ _1511_ VGND VGND VPWR VPWR _1512_ sky130_fd_sc_hd__and2_1
X_7525_ _3065_ registers\[22\]\[0\] _3684_ VGND VGND VPWR VPWR _3685_ sky130_fd_sc_hd__mux2_1
XANTENNA__7772__S _3815_ VGND VGND VPWR VPWR sky130_fd_sc_hd__diode_2
X_7456_ _3647_ VGND VGND VPWR VPWR _3648_ sky130_fd_sc_hd__clkbuf_8
X_4668_ registers\[12\]\[21\] registers\[13\]\[21\] registers\[14\]\[21\] registers\[15\]\[21\]
+ _1427_ _1428_ VGND VGND VPWR VPWR _1447_ sky130_fd_sc_hd__mux4_1
XANTENNA__5389__S0 _2126_ VGND VGND VPWR VPWR sky130_fd_sc_hd__diode_2
XTAP_TAPCELL_ROW_116_1761 VGND VPWR sky130_fd_sc_hd__tapvpwrvgnd_1
XANTENNA__6388__S _3041_ VGND VGND VPWR VPWR sky130_fd_sc_hd__diode_2
XFILLER_0_3_260 VGND VGND VPWR VPWR sky130_fd_sc_hd__fill_1
XFILLER_0_31_369 VGND VGND VPWR VPWR sky130_fd_sc_hd__fill_2
X_6407_ registers\[3\]\[23\] _3010_ _3052_ VGND VGND VPWR VPWR _3056_ sky130_fd_sc_hd__mux2_1
XTAP_TAPCELL_ROW_116_1772 VGND VPWR sky130_fd_sc_hd__tapvpwrvgnd_1
X_9126_ clknet_leaf_34_clk _0223_ VGND VGND VPWR VPWR registers\[23\]\[6\] sky130_fd_sc_hd__dfxtp_1
X_4599_ _1124_ VGND VGND VPWR VPWR _1381_ sky130_fd_sc_hd__buf_4
X_7387_ _3285_ _3610_ VGND VGND VPWR VPWR _3611_ sky130_fd_sc_hd__and2_2
XFILLER_0_101_279 VGND VGND VPWR VPWR sky130_fd_sc_hd__fill_1
X_6338_ net34 VGND VGND VPWR VPWR _3016_ sky130_fd_sc_hd__buf_2
X_6269_ _2969_ VGND VGND VPWR VPWR _0668_ sky130_fd_sc_hd__clkbuf_1
X_9057_ clknet_leaf_110_clk _0154_ VGND VGND VPWR VPWR registers\[21\]\[1\] sky130_fd_sc_hd__dfxtp_1
X_8008_ registers\[2\]\[3\] _3441_ _3937_ VGND VGND VPWR VPWR _3941_ sky130_fd_sc_hd__mux2_1
XANTENNA__7207__A1 _3458_ VGND VGND VPWR VPWR sky130_fd_sc_hd__diode_2
XANTENNA__5769__B2 _2321_ VGND VGND VPWR VPWR sky130_fd_sc_hd__diode_2
XTAP_TAPCELL_ROW_67_1126 VGND VPWR sky130_fd_sc_hd__tapvpwrvgnd_1
XANTENNA__5313__S0 _1762_ VGND VGND VPWR VPWR sky130_fd_sc_hd__diode_2
XFILLER_0_67_723 VGND VGND VPWR VPWR sky130_fd_sc_hd__fill_2
XFILLER_0_39_403 VGND VGND VPWR VPWR sky130_fd_sc_hd__fill_2
XANTENNA__6851__S _3310_ VGND VGND VPWR VPWR sky130_fd_sc_hd__diode_2
XFILLER_0_109_302 VGND VGND VPWR VPWR sky130_fd_sc_hd__decap_3
XTAP_TAPCELL_ROW_80_1304 VGND VPWR sky130_fd_sc_hd__tapvpwrvgnd_1
XFILLER_0_39_458 VGND VGND VPWR VPWR sky130_fd_sc_hd__fill_1
XFILLER_0_94_597 VGND VGND VPWR VPWR sky130_fd_sc_hd__fill_1
XFILLER_0_109_379 VGND VGND VPWR VPWR sky130_fd_sc_hd__fill_2
XFILLER_0_81_225 VGND VGND VPWR VPWR sky130_fd_sc_hd__decap_3
XFILLER_0_35_620 VGND VGND VPWR VPWR sky130_fd_sc_hd__fill_2
XANTENNA__5941__A1 _1899_ VGND VGND VPWR VPWR sky130_fd_sc_hd__diode_2
XFILLER_0_62_450 VGND VGND VPWR VPWR sky130_fd_sc_hd__decap_4
XFILLER_0_34_141 VGND VGND VPWR VPWR sky130_fd_sc_hd__fill_2
XFILLER_0_117_390 VGND VGND VPWR VPWR sky130_fd_sc_hd__fill_2
XFILLER_0_2_709 VPWR VGND VPWR VGND sky130_ef_sc_hd__decap_12
XTAP_TAPCELL_ROW_78_1277 VGND VPWR sky130_fd_sc_hd__tapvpwrvgnd_1
XFILLER_0_50_645 VGND VGND VPWR VPWR sky130_fd_sc_hd__fill_1
XTAP_TAPCELL_ROW_91_1444 VGND VPWR sky130_fd_sc_hd__tapvpwrvgnd_1
XANTENNA__4355__S1 _1113_ VGND VGND VPWR VPWR sky130_fd_sc_hd__diode_2
XPHY_EDGE_ROW_13_Right_13 VGND VGND VPWR VPWR sky130_fd_sc_hd__decap_3
XANTENNA__8018__S _3937_ VGND VGND VPWR VPWR sky130_fd_sc_hd__diode_2
XFILLER_0_58_701 VGND VGND VPWR VPWR sky130_fd_sc_hd__fill_2
XANTENNA__5304__S0 _1883_ VGND VGND VPWR VPWR sky130_fd_sc_hd__diode_2
XFILLER_0_106_78 VGND VGND VPWR VPWR sky130_fd_sc_hd__fill_2
XANTENNA__4432__A1 _1073_ VGND VGND VPWR VPWR sky130_fd_sc_hd__diode_2
XFILLER_0_58_723 VGND VGND VPWR VPWR sky130_fd_sc_hd__fill_1
XTAP_TAPCELL_ROW_46_854 VGND VPWR sky130_fd_sc_hd__tapvpwrvgnd_1
XFILLER_0_73_704 VGND VGND VPWR VPWR sky130_fd_sc_hd__decap_3
XFILLER_0_57_222 VGND VGND VPWR VPWR sky130_fd_sc_hd__fill_2
XFILLER_0_85_597 VGND VGND VPWR VPWR sky130_fd_sc_hd__decap_4
XFILLER_0_85_575 VGND VGND VPWR VPWR sky130_fd_sc_hd__fill_1
XFILLER_0_73_715 VGND VGND VPWR VPWR sky130_fd_sc_hd__fill_2
XFILLER_0_17_108 VGND VGND VPWR VPWR sky130_fd_sc_hd__fill_2
XANTENNA__4281__S _1030_ VGND VGND VPWR VPWR sky130_fd_sc_hd__diode_2
XTAP_TAPCELL_ROW_100_1562 VGND VPWR sky130_fd_sc_hd__tapvpwrvgnd_1
X_5640_ _2373_ _2374_ VGND VGND VPWR VPWR _2375_ sky130_fd_sc_hd__nand2_1
XFILLER_0_5_503 VGND VGND VPWR VPWR sky130_fd_sc_hd__fill_1
X_5571_ _2293_ VGND VGND VPWR VPWR _2307_ sky130_fd_sc_hd__clkbuf_4
XPHY_EDGE_ROW_22_Right_22 VGND VGND VPWR VPWR sky130_fd_sc_hd__decap_3
XFILLER_0_25_141 VGND VGND VPWR VPWR sky130_fd_sc_hd__decap_3
X_4522_ registers\[16\]\[14\] registers\[17\]\[14\] registers\[18\]\[14\] registers\[19\]\[14\]
+ _1136_ _1137_ VGND VGND VPWR VPWR _1308_ sky130_fd_sc_hd__mux4_1
X_8290_ _2978_ registers\[31\]\[8\] _4081_ VGND VGND VPWR VPWR _4090_ sky130_fd_sc_hd__mux2_1
X_7310_ registers\[18\]\[28\] _3493_ _3561_ VGND VGND VPWR VPWR _3570_ sky130_fd_sc_hd__mux2_1
XFILLER_0_5_558 VGND VGND VPWR VPWR sky130_fd_sc_hd__fill_2
XFILLER_0_26_686 VGND VGND VPWR VPWR sky130_fd_sc_hd__fill_2
XANTENNA__7685__A1 _3458_ VGND VGND VPWR VPWR sky130_fd_sc_hd__diode_2
X_4453_ registers\[16\]\[10\] registers\[17\]\[10\] registers\[18\]\[10\] registers\[19\]\[10\]
+ _1110_ _1112_ VGND VGND VPWR VPWR _1243_ sky130_fd_sc_hd__mux4_1
X_7241_ _3533_ VGND VGND VPWR VPWR _0052_ sky130_fd_sc_hd__clkbuf_1
XFILLER_0_111_533 VGND VGND VPWR VPWR sky130_fd_sc_hd__fill_2
X_4384_ _1176_ _1177_ _1140_ VGND VGND VPWR VPWR _1178_ sky130_fd_sc_hd__mux2_1
XANTENNA__4310__A _1106_ VGND VGND VPWR VPWR sky130_fd_sc_hd__diode_2
XANTENNA__4594__S1 _1339_ VGND VGND VPWR VPWR sky130_fd_sc_hd__diode_2
X_7172_ net37 VGND VGND VPWR VPWR _3495_ sky130_fd_sc_hd__buf_2
X_6123_ _2822_ _2830_ _2831_ _2801_ _2820_ VGND VGND VPWR VPWR _2835_ sky130_fd_sc_hd__a221o_1
XANTENNA__7437__A1 _3483_ VGND VGND VPWR VPWR sky130_fd_sc_hd__diode_2
X_6054_ _2362_ _2466_ VGND VGND VPWR VPWR _2770_ sky130_fd_sc_hd__nor2_1
XPHY_EDGE_ROW_31_Right_31 VGND VGND VPWR VPWR sky130_fd_sc_hd__decap_3
X_5005_ _1627_ VGND VGND VPWR VPWR _1767_ sky130_fd_sc_hd__clkbuf_8
XFILLER_0_22_3 VGND VGND VPWR VPWR sky130_fd_sc_hd__decap_3
XANTENNA__6948__A0 _3071_ VGND VGND VPWR VPWR sky130_fd_sc_hd__diode_2
X_6956_ _3079_ registers\[14\]\[5\] _3361_ VGND VGND VPWR VPWR _3367_ sky130_fd_sc_hd__mux2_1
XANTENNA__4980__A _1678_ VGND VGND VPWR VPWR sky130_fd_sc_hd__diode_2
XFILLER_0_76_520 VGND VGND VPWR VPWR sky130_fd_sc_hd__fill_2
XANTENNA__7767__S _3804_ VGND VGND VPWR VPWR sky130_fd_sc_hd__diode_2
XANTENNA__6671__S _3214_ VGND VGND VPWR VPWR sky130_fd_sc_hd__diode_2
XFILLER_0_76_542 VGND VGND VPWR VPWR sky130_fd_sc_hd__fill_2
X_5907_ _2553_ _2555_ _2627_ _2630_ VGND VGND VPWR VPWR _2631_ sky130_fd_sc_hd__a31o_1
X_6887_ _3079_ registers\[13\]\[5\] _3324_ VGND VGND VPWR VPWR _3330_ sky130_fd_sc_hd__mux2_1
XFILLER_0_36_417 VGND VGND VPWR VPWR sky130_fd_sc_hd__decap_3
X_5838_ _2269_ _2465_ _2565_ _2279_ VGND VGND VPWR VPWR _2566_ sky130_fd_sc_hd__o22a_1
XTAP_TAPCELL_ROW_62_1067 VGND VPWR sky130_fd_sc_hd__tapvpwrvgnd_1
X_8626_ clknet_leaf_68_clk _0747_ VGND VGND VPWR VPWR registers\[29\]\[18\] sky130_fd_sc_hd__dfxtp_1
XPHY_EDGE_ROW_40_Right_40 VGND VGND VPWR VPWR sky130_fd_sc_hd__decap_3
XFILLER_0_29_491 VGND VGND VPWR VPWR sky130_fd_sc_hd__decap_3
X_8557_ clknet_leaf_57_clk _0678_ VGND VGND VPWR VPWR registers\[19\]\[13\] sky130_fd_sc_hd__dfxtp_1
X_5769_ _2297_ _2343_ _2354_ _2321_ VGND VGND VPWR VPWR _2500_ sky130_fd_sc_hd__a22o_1
XFILLER_0_16_141 VGND VGND VPWR VPWR sky130_fd_sc_hd__decap_4
XFILLER_0_44_472 VGND VGND VPWR VPWR sky130_fd_sc_hd__decap_4
X_7508_ _3675_ VGND VGND VPWR VPWR _0177_ sky130_fd_sc_hd__clkbuf_1
XFILLER_0_16_152 VGND VGND VPWR VPWR sky130_fd_sc_hd__fill_2
XFILLER_0_32_623 VGND VGND VPWR VPWR sky130_fd_sc_hd__fill_2
XFILLER_0_32_634 VGND VGND VPWR VPWR sky130_fd_sc_hd__fill_2
X_8488_ registers\[4\]\[5\] net43 _4189_ VGND VGND VPWR VPWR _4195_ sky130_fd_sc_hd__mux2_1
XANTENNA__7676__A1 _3449_ VGND VGND VPWR VPWR sky130_fd_sc_hd__diode_2
XPHY_EDGE_ROW_15_Left_135 VGND VGND VPWR VPWR sky130_fd_sc_hd__decap_3
XFILLER_0_31_111 VGND VGND VPWR VPWR sky130_fd_sc_hd__fill_1
XFILLER_0_32_656 VGND VGND VPWR VPWR sky130_fd_sc_hd__fill_1
XFILLER_0_114_382 VGND VGND VPWR VPWR sky130_fd_sc_hd__decap_6
XFILLER_0_102_522 VGND VGND VPWR VPWR sky130_fd_sc_hd__fill_2
X_7439_ registers\[20\]\[24\] _3485_ _3634_ VGND VGND VPWR VPWR _3639_ sky130_fd_sc_hd__mux2_1
XANTENNA__4585__S1 _1204_ VGND VGND VPWR VPWR sky130_fd_sc_hd__diode_2
XANTENNA__6846__S _3299_ VGND VGND VPWR VPWR sky130_fd_sc_hd__diode_2
X_9109_ clknet_leaf_79_clk _0206_ VGND VGND VPWR VPWR registers\[22\]\[21\] sky130_fd_sc_hd__dfxtp_1
XANTENNA__5439__B1 _1754_ VGND VGND VPWR VPWR sky130_fd_sc_hd__diode_2
XANTENNA__5051__A _1706_ VGND VGND VPWR VPWR sky130_fd_sc_hd__diode_2
XANTENNA__6147__A _1517_ VGND VGND VPWR VPWR sky130_fd_sc_hd__diode_2
XPHY_EDGE_ROW_24_Left_144 VGND VGND VPWR VPWR sky130_fd_sc_hd__decap_3
XANTENNA__6939__A0 _3131_ VGND VGND VPWR VPWR sky130_fd_sc_hd__diode_2
XANTENNA__4414__A1 _1135_ VGND VGND VPWR VPWR sky130_fd_sc_hd__diode_2
XTAP_TAPCELL_ROW_43_824 VGND VPWR sky130_fd_sc_hd__tapvpwrvgnd_1
XTAP_TAPCELL_ROW_43_813 VGND VPWR sky130_fd_sc_hd__tapvpwrvgnd_1
XFILLER_0_39_244 VGND VGND VPWR VPWR sky130_fd_sc_hd__decap_3
XFILLER_0_67_586 VGND VGND VPWR VPWR sky130_fd_sc_hd__fill_1
XFILLER_0_109_132 VGND VGND VPWR VPWR sky130_fd_sc_hd__fill_2
XFILLER_0_94_394 VGND VGND VPWR VPWR sky130_fd_sc_hd__fill_1
XFILLER_0_82_589 VGND VGND VPWR VPWR sky130_fd_sc_hd__decap_6
XFILLER_0_82_578 VGND VGND VPWR VPWR sky130_fd_sc_hd__decap_8
XANTENNA__5375__C1 _1960_ VGND VGND VPWR VPWR sky130_fd_sc_hd__diode_2
XANTENNA__8301__S _4092_ VGND VGND VPWR VPWR sky130_fd_sc_hd__diode_2
XFILLER_0_23_612 VGND VGND VPWR VPWR sky130_fd_sc_hd__fill_2
XPHY_EDGE_ROW_33_Left_153 VGND VGND VPWR VPWR sky130_fd_sc_hd__decap_3
XFILLER_0_105_393 VGND VGND VPWR VPWR sky130_fd_sc_hd__fill_2
XANTENNA__4576__S1 _1161_ VGND VGND VPWR VPWR sky130_fd_sc_hd__diode_2
XPHY_EDGE_ROW_42_Left_162 VGND VGND VPWR VPWR sky130_fd_sc_hd__decap_3
XFILLER_0_117_55 VGND VGND VPWR VPWR sky130_fd_sc_hd__fill_1
XANTENNA__7587__S _3683_ VGND VGND VPWR VPWR sky130_fd_sc_hd__diode_2
X_6810_ _3289_ VGND VGND VPWR VPWR _0889_ sky130_fd_sc_hd__clkbuf_1
XFILLER_0_58_520 VGND VGND VPWR VPWR sky130_fd_sc_hd__fill_2
X_7790_ _3129_ registers\[25\]\[29\] _3815_ VGND VGND VPWR VPWR _3825_ sky130_fd_sc_hd__mux2_1
XFILLER_0_9_105 VGND VGND VPWR VPWR sky130_fd_sc_hd__decap_3
XANTENNA__4500__S1 _1168_ VGND VGND VPWR VPWR sky130_fd_sc_hd__diode_2
X_6741_ registers\[11\]\[1\] _2964_ _3250_ VGND VGND VPWR VPWR _3252_ sky130_fd_sc_hd__mux2_1
X_6672_ _3215_ VGND VGND VPWR VPWR _0825_ sky130_fd_sc_hd__clkbuf_1
XFILLER_0_42_96 VGND VGND VPWR VPWR sky130_fd_sc_hd__fill_2
XFILLER_0_42_74 VGND VGND VPWR VPWR sky130_fd_sc_hd__fill_1
X_9460_ clknet_leaf_75_clk _0557_ VGND VGND VPWR VPWR registers\[31\]\[20\] sky130_fd_sc_hd__dfxtp_1
XFILLER_0_116_625 VPWR VGND VPWR VGND sky130_ef_sc_hd__decap_12
XFILLER_0_115_102 VGND VGND VPWR VPWR sky130_fd_sc_hd__decap_3
X_5623_ _2219_ _2310_ VGND VGND VPWR VPWR _2358_ sky130_fd_sc_hd__or2_1
X_9391_ clknet_leaf_47_clk _0488_ VGND VGND VPWR VPWR registers\[9\]\[15\] sky130_fd_sc_hd__dfxtp_1
XPHY_EDGE_ROW_51_Left_171 VGND VGND VPWR VPWR sky130_fd_sc_hd__decap_3
X_8411_ _4154_ VGND VGND VPWR VPWR _0601_ sky130_fd_sc_hd__clkbuf_1
XTAP_TAPCELL_ROW_21_529 VGND VPWR sky130_fd_sc_hd__tapvpwrvgnd_1
XFILLER_0_116_669 VPWR VGND VPWR VGND sky130_ef_sc_hd__decap_12
X_8342_ registers\[5\]\[0\] _3433_ _4117_ VGND VGND VPWR VPWR _4118_ sky130_fd_sc_hd__mux2_1
X_5554_ _1819_ _2213_ VGND VGND VPWR VPWR _2290_ sky130_fd_sc_hd__or2_1
X_4505_ _1290_ _1291_ _1117_ VGND VGND VPWR VPWR _1292_ sky130_fd_sc_hd__mux2_1
X_5485_ _1943_ _2216_ _2220_ VGND VGND VPWR VPWR _2221_ sky130_fd_sc_hd__o21ai_1
XFILLER_0_13_144 VGND VGND VPWR VPWR sky130_fd_sc_hd__decap_8
XFILLER_0_13_155 VGND VGND VPWR VPWR sky130_fd_sc_hd__fill_2
XFILLER_0_13_166 VGND VGND VPWR VPWR sky130_fd_sc_hd__fill_2
XFILLER_0_13_177 VGND VGND VPWR VPWR sky130_fd_sc_hd__fill_2
X_8273_ _4080_ VGND VGND VPWR VPWR _4081_ sky130_fd_sc_hd__buf_6
XTAP_TAPCELL_ROW_113_1731 VGND VPWR sky130_fd_sc_hd__tapvpwrvgnd_1
X_7224_ _3524_ VGND VGND VPWR VPWR _0044_ sky130_fd_sc_hd__clkbuf_1
X_4436_ _1225_ _1226_ _1031_ VGND VGND VPWR VPWR _1227_ sky130_fd_sc_hd__mux2_1
XFILLER_0_1_550 VGND VGND VPWR VPWR sky130_fd_sc_hd__decap_6
X_4367_ registers\[4\]\[5\] registers\[5\]\[5\] registers\[6\]\[5\] registers\[7\]\[5\]
+ _1160_ _1161_ VGND VGND VPWR VPWR _1162_ sky130_fd_sc_hd__mux4_1
X_7155_ registers\[16\]\[23\] _3483_ _3477_ VGND VGND VPWR VPWR _3484_ sky130_fd_sc_hd__mux2_1
XFILLER_0_1_594 VGND VGND VPWR VPWR sky130_fd_sc_hd__fill_1
XFILLER_0_67_82 VGND VGND VPWR VPWR sky130_fd_sc_hd__fill_2
XPHY_EDGE_ROW_60_Left_180 VGND VGND VPWR VPWR sky130_fd_sc_hd__decap_3
X_6106_ _2816_ _2818_ net96 VGND VGND VPWR VPWR _2819_ sky130_fd_sc_hd__a21oi_1
XANTENNA__4892__A1 _1655_ VGND VGND VPWR VPWR sky130_fd_sc_hd__diode_2
XFILLER_0_6_85 VGND VGND VPWR VPWR sky130_fd_sc_hd__fill_2
XANTENNA__4319__S1 _1113_ VGND VGND VPWR VPWR sky130_fd_sc_hd__diode_2
X_4298_ registers\[24\]\[3\] registers\[25\]\[3\] registers\[26\]\[3\] registers\[27\]\[3\]
+ _1060_ _1061_ VGND VGND VPWR VPWR _1095_ sky130_fd_sc_hd__mux4_1
X_7086_ net27 VGND VGND VPWR VPWR _3437_ sky130_fd_sc_hd__buf_2
X_6037_ _2752_ _2753_ VGND VGND VPWR VPWR _2754_ sky130_fd_sc_hd__xnor2_1
XFILLER_0_96_604 VGND VGND VPWR VPWR sky130_fd_sc_hd__decap_3
XTAP_TAPCELL_ROW_1_276 VGND VPWR sky130_fd_sc_hd__tapvpwrvgnd_1
X_7988_ _3016_ registers\[28\]\[26\] _3923_ VGND VGND VPWR VPWR _3930_ sky130_fd_sc_hd__mux2_1
XFILLER_0_95_169 VGND VGND VPWR VPWR sky130_fd_sc_hd__fill_1
X_6939_ _3131_ registers\[13\]\[30\] _3323_ VGND VGND VPWR VPWR _3357_ sky130_fd_sc_hd__mux2_1
XFILLER_0_107_647 VGND VGND VPWR VPWR sky130_fd_sc_hd__fill_2
XFILLER_0_91_331 VGND VGND VPWR VPWR sky130_fd_sc_hd__decap_3
XANTENNA__5357__C1 _1960_ VGND VGND VPWR VPWR sky130_fd_sc_hd__diode_2
X_8609_ clknet_leaf_109_clk _0730_ VGND VGND VPWR VPWR registers\[29\]\[1\] sky130_fd_sc_hd__dfxtp_1
XFILLER_0_107_669 VGND VGND VPWR VPWR sky130_fd_sc_hd__decap_3
XFILLER_0_44_291 VGND VGND VPWR VPWR sky130_fd_sc_hd__fill_2
XFILLER_0_20_604 VGND VGND VPWR VPWR sky130_fd_sc_hd__fill_1
XFILLER_0_32_453 VGND VGND VPWR VPWR sky130_fd_sc_hd__fill_1
XANTENNA__5046__A _1705_ VGND VGND VPWR VPWR sky130_fd_sc_hd__diode_2
XTAP_TAPCELL_ROW_75_1236 VGND VPWR sky130_fd_sc_hd__tapvpwrvgnd_1
XANTENNA__4558__S1 _1321_ VGND VGND VPWR VPWR sky130_fd_sc_hd__diode_2
XANTENNA__6321__A1 _3003_ VGND VGND VPWR VPWR sky130_fd_sc_hd__diode_2
XFILLER_0_102_374 VGND VGND VPWR VPWR sky130_fd_sc_hd__fill_2
XANTENNA__6576__S _3159_ VGND VGND VPWR VPWR sky130_fd_sc_hd__diode_2
XTAP_TAPCELL_ROW_9_376 VGND VPWR sky130_fd_sc_hd__tapvpwrvgnd_1
XFILLER_0_99_497 VGND VGND VPWR VPWR sky130_fd_sc_hd__fill_2
XANTENNA__4730__S1 _1416_ VGND VGND VPWR VPWR sky130_fd_sc_hd__diode_2
XANTENNA__6388__A1 _2991_ VGND VGND VPWR VPWR sky130_fd_sc_hd__diode_2
XTAP_TAPCELL_ROW_86_1376 VGND VPWR sky130_fd_sc_hd__tapvpwrvgnd_1
XFILLER_0_86_136 VGND VGND VPWR VPWR sky130_fd_sc_hd__fill_2
XANTENNA__7200__S _3503_ VGND VGND VPWR VPWR sky130_fd_sc_hd__diode_2
XTAP_TAPCELL_ROW_56_993 VGND VPWR sky130_fd_sc_hd__tapvpwrvgnd_1
XTAP_TAPCELL_ROW_56_982 VGND VPWR sky130_fd_sc_hd__tapvpwrvgnd_1
XANTENNA_output112_A net112 VGND VGND VPWR VPWR sky130_fd_sc_hd__diode_2
XFILLER_0_74_309 VGND VGND VPWR VPWR sky130_fd_sc_hd__decap_3
XANTENNA__4494__S0 _1201_ VGND VGND VPWR VPWR sky130_fd_sc_hd__diode_2
XFILLER_0_27_225 VGND VGND VPWR VPWR sky130_fd_sc_hd__fill_2
XFILLER_0_103_46 VGND VGND VPWR VPWR sky130_fd_sc_hd__fill_2
XANTENNA__8031__S _3948_ VGND VGND VPWR VPWR sky130_fd_sc_hd__diode_2
XFILLER_0_43_729 VGND VGND VPWR VPWR sky130_fd_sc_hd__fill_1
XANTENNA__4246__S0 _1039_ VGND VGND VPWR VPWR sky130_fd_sc_hd__diode_2
XFILLER_0_113_617 VGND VGND VPWR VPWR sky130_fd_sc_hd__fill_2
Xoutput106 net106 VGND VGND VPWR VPWR rd1[3] sky130_fd_sc_hd__buf_1
XANTENNA__7870__S _3865_ VGND VGND VPWR VPWR sky130_fd_sc_hd__diode_2
Xoutput139 net139 VGND VGND VPWR VPWR rd2[4] sky130_fd_sc_hd__buf_1
Xoutput117 net117 VGND VGND VPWR VPWR rd2[13] sky130_fd_sc_hd__buf_1
Xoutput128 net128 VGND VGND VPWR VPWR rd2[23] sky130_fd_sc_hd__buf_1
X_5270_ _2015_ _2016_ _1768_ VGND VGND VPWR VPWR _2017_ sky130_fd_sc_hd__mux2_1
XANTENNA__4549__S1 _1199_ VGND VGND VPWR VPWR sky130_fd_sc_hd__diode_2
X_8960_ clknet_leaf_0_clk _0057_ VGND VGND VPWR VPWR registers\[18\]\[0\] sky130_fd_sc_hd__dfxtp_1
XFILLER_0_37_52 VGND VGND VPWR VPWR sky130_fd_sc_hd__fill_2
X_7911_ _3889_ VGND VGND VPWR VPWR _0366_ sky130_fd_sc_hd__clkbuf_1
XANTENNA__4721__S1 _1405_ VGND VGND VPWR VPWR sky130_fd_sc_hd__diode_2
X_8891_ clknet_leaf_101_clk _1012_ VGND VGND VPWR VPWR registers\[15\]\[27\] sky130_fd_sc_hd__dfxtp_1
XFILLER_0_53_51 VGND VGND VPWR VPWR sky130_fd_sc_hd__fill_2
XANTENNA__6515__A net36 VGND VGND VPWR VPWR sky130_fd_sc_hd__diode_2
X_7842_ _3113_ registers\[26\]\[21\] _3851_ VGND VGND VPWR VPWR _3853_ sky130_fd_sc_hd__mux2_1
XANTENNA__8206__S _4045_ VGND VGND VPWR VPWR sky130_fd_sc_hd__diode_2
XFILLER_0_93_607 VGND VGND VPWR VPWR sky130_fd_sc_hd__decap_8
X_4985_ _1744_ _1745_ _1746_ VGND VGND VPWR VPWR _1747_ sky130_fd_sc_hd__mux2_1
XFILLER_0_77_169 VGND VGND VPWR VPWR sky130_fd_sc_hd__decap_4
XFILLER_0_58_361 VGND VGND VPWR VPWR sky130_fd_sc_hd__decap_3
X_7773_ _3816_ VGND VGND VPWR VPWR _0301_ sky130_fd_sc_hd__clkbuf_1
X_9512_ clknet_leaf_25_clk _0609_ VGND VGND VPWR VPWR registers\[8\]\[8\] sky130_fd_sc_hd__dfxtp_1
XFILLER_0_58_394 VGND VGND VPWR VPWR sky130_fd_sc_hd__fill_2
X_6724_ _3242_ VGND VGND VPWR VPWR _0850_ sky130_fd_sc_hd__clkbuf_1
XFILLER_0_19_726 VGND VGND VPWR VPWR sky130_fd_sc_hd__fill_2
X_9443_ clknet_leaf_22_clk _0540_ VGND VGND VPWR VPWR registers\[31\]\[3\] sky130_fd_sc_hd__dfxtp_1
XFILLER_0_18_269 VGND VGND VPWR VPWR sky130_fd_sc_hd__decap_3
XTAP_TAPCELL_ROW_34_698 VGND VPWR sky130_fd_sc_hd__tapvpwrvgnd_1
XANTENNA__5565__S net113 VGND VGND VPWR VPWR sky130_fd_sc_hd__diode_2
X_6655_ _3204_ VGND VGND VPWR VPWR _0819_ sky130_fd_sc_hd__clkbuf_1
XFILLER_0_34_729 VGND VGND VPWR VPWR sky130_fd_sc_hd__fill_1
XFILLER_0_116_477 VGND VGND VPWR VPWR sky130_fd_sc_hd__fill_2
XFILLER_0_103_105 VGND VGND VPWR VPWR sky130_fd_sc_hd__decap_4
X_5606_ _1866_ _2215_ _2219_ VGND VGND VPWR VPWR _2341_ sky130_fd_sc_hd__o21ai_1
XFILLER_0_61_559 VGND VGND VPWR VPWR sky130_fd_sc_hd__fill_1
X_9374_ clknet_leaf_97_clk _0471_ VGND VGND VPWR VPWR registers\[30\]\[30\] sky130_fd_sc_hd__dfxtp_1
X_6586_ registers\[7\]\[27\] _3018_ _3159_ VGND VGND VPWR VPWR _3167_ sky130_fd_sc_hd__mux2_1
X_5537_ net139 _2272_ VGND VGND VPWR VPWR _2273_ sky130_fd_sc_hd__or2_1
X_8325_ _4108_ VGND VGND VPWR VPWR _0561_ sky130_fd_sc_hd__clkbuf_1
XFILLER_0_14_442 VGND VGND VPWR VPWR sky130_fd_sc_hd__fill_1
X_8256_ registers\[6\]\[24\] _3485_ _4067_ VGND VGND VPWR VPWR _4072_ sky130_fd_sc_hd__mux2_1
XANTENNA__7780__S _3815_ VGND VGND VPWR VPWR sky130_fd_sc_hd__diode_2
X_7207_ registers\[17\]\[11\] _3458_ _3514_ VGND VGND VPWR VPWR _3516_ sky130_fd_sc_hd__mux2_1
XANTENNA__6396__S _3041_ VGND VGND VPWR VPWR sky130_fd_sc_hd__diode_2
X_5468_ net125 net126 net136 net137 VGND VGND VPWR VPWR _2204_ sky130_fd_sc_hd__or4_1
X_4419_ _1209_ _1210_ net6 VGND VGND VPWR VPWR _1211_ sky130_fd_sc_hd__mux2_1
X_8187_ _4035_ VGND VGND VPWR VPWR _0496_ sky130_fd_sc_hd__clkbuf_1
X_5399_ _2137_ _2138_ _2031_ VGND VGND VPWR VPWR _2139_ sky130_fd_sc_hd__mux2_1
XTAP_TAPCELL_ROW_6_335 VGND VPWR sky130_fd_sc_hd__tapvpwrvgnd_1
XANTENNA__7081__A net16 VGND VGND VPWR VPWR sky130_fd_sc_hd__diode_2
X_7138_ net25 VGND VGND VPWR VPWR _3472_ sky130_fd_sc_hd__buf_2
XANTENNA__8056__A1 _3489_ VGND VGND VPWR VPWR sky130_fd_sc_hd__diode_2
XTAP_TAPCELL_ROW_70_1166 VGND VPWR sky130_fd_sc_hd__tapvpwrvgnd_1
X_7069_ _3123_ registers\[15\]\[26\] _3420_ VGND VGND VPWR VPWR _3427_ sky130_fd_sc_hd__mux2_1
XFILLER_0_69_615 VGND VGND VPWR VPWR sky130_fd_sc_hd__fill_1
XANTENNA__4712__S1 _1419_ VGND VGND VPWR VPWR sky130_fd_sc_hd__diode_2
XFILLER_0_68_136 VGND VGND VPWR VPWR sky130_fd_sc_hd__fill_2
XANTENNA__7567__A0 _3110_ VGND VGND VPWR VPWR sky130_fd_sc_hd__diode_2
XANTENNA__6425__A net16 VGND VGND VPWR VPWR sky130_fd_sc_hd__diode_2
XANTENNA__8116__S _3995_ VGND VGND VPWR VPWR sky130_fd_sc_hd__diode_2
XFILLER_0_83_106 VGND VGND VPWR VPWR sky130_fd_sc_hd__fill_2
XFILLER_0_56_309 VGND VGND VPWR VPWR sky130_fd_sc_hd__fill_2
XTAP_TAPCELL_ROW_53_952 VGND VPWR sky130_fd_sc_hd__tapvpwrvgnd_1
XFILLER_0_37_501 VGND VGND VPWR VPWR sky130_fd_sc_hd__decap_3
XANTENNA__7955__S _3912_ VGND VGND VPWR VPWR sky130_fd_sc_hd__diode_2
XFILLER_0_83_117 VGND VGND VPWR VPWR sky130_fd_sc_hd__fill_2
XFILLER_0_119_293 VPWR VGND VPWR VGND sky130_ef_sc_hd__decap_12
XFILLER_0_92_695 VGND VGND VPWR VPWR sky130_fd_sc_hd__decap_4
Xinput19 wd3[12] VGND VGND VPWR VPWR net19 sky130_fd_sc_hd__clkbuf_2
XANTENNA__4228__S0 _1026_ VGND VGND VPWR VPWR sky130_fd_sc_hd__diode_2
XFILLER_0_24_206 VGND VGND VPWR VPWR sky130_fd_sc_hd__fill_2
XFILLER_0_25_729 VGND VGND VPWR VPWR sky130_fd_sc_hd__fill_1
XFILLER_0_91_183 VGND VGND VPWR VPWR sky130_fd_sc_hd__fill_1
XFILLER_0_110_609 VGND VGND VPWR VPWR sky130_fd_sc_hd__fill_2
XFILLER_0_32_294 VGND VGND VPWR VPWR sky130_fd_sc_hd__decap_3
XFILLER_0_102_182 VGND VGND VPWR VPWR sky130_fd_sc_hd__fill_2
XANTENNA__4400__S0 _1136_ VGND VGND VPWR VPWR sky130_fd_sc_hd__diode_2
XANTENNA__5504__A _2101_ VGND VGND VPWR VPWR sky130_fd_sc_hd__diode_2
XANTENNA__4951__S1 _1692_ VGND VGND VPWR VPWR sky130_fd_sc_hd__diode_2
XTAP_TAPCELL_ROW_88_1405 VGND VPWR sky130_fd_sc_hd__tapvpwrvgnd_1
XFILLER_0_99_272 VGND VGND VPWR VPWR sky130_fd_sc_hd__decap_3
XANTENNA__4703__S1 _1416_ VGND VGND VPWR VPWR sky130_fd_sc_hd__diode_2
XFILLER_0_87_445 VGND VGND VPWR VPWR sky130_fd_sc_hd__decap_3
XFILLER_0_59_125 VGND VGND VPWR VPWR sky130_fd_sc_hd__fill_1
XANTENNA__6335__A net33 VGND VGND VPWR VPWR sky130_fd_sc_hd__diode_2
XFILLER_0_87_478 VGND VGND VPWR VPWR sky130_fd_sc_hd__fill_2
XFILLER_0_59_169 VGND VGND VPWR VPWR sky130_fd_sc_hd__decap_3
XANTENNA__4467__S0 _1197_ VGND VGND VPWR VPWR sky130_fd_sc_hd__diode_2
XFILLER_0_74_139 VGND VGND VPWR VPWR sky130_fd_sc_hd__fill_1
XFILLER_0_28_501 VGND VGND VPWR VPWR sky130_fd_sc_hd__fill_1
XFILLER_0_117_208 VGND VGND VPWR VPWR sky130_fd_sc_hd__decap_6
XFILLER_0_114_89 VGND VGND VPWR VPWR sky130_fd_sc_hd__fill_2
XFILLER_0_67_191 VGND VGND VPWR VPWR sky130_fd_sc_hd__fill_2
X_4770_ registers\[0\]\[27\] registers\[1\]\[27\] registers\[2\]\[27\] registers\[3\]\[27\]
+ _1433_ _1434_ VGND VGND VPWR VPWR _1543_ sky130_fd_sc_hd__mux4_1
XANTENNA__6781__A1 _3003_ VGND VGND VPWR VPWR sky130_fd_sc_hd__diode_2
XFILLER_0_28_567 VGND VGND VPWR VPWR sky130_fd_sc_hd__fill_2
XTAP_TAPCELL_ROW_99_1545 VGND VPWR sky130_fd_sc_hd__tapvpwrvgnd_1
XFILLER_0_99_36 VGND VGND VPWR VPWR sky130_fd_sc_hd__fill_2
XFILLER_0_83_673 VGND VGND VPWR VPWR sky130_fd_sc_hd__decap_4
XFILLER_0_82_150 VGND VGND VPWR VPWR sky130_fd_sc_hd__fill_2
XFILLER_0_70_301 VGND VGND VPWR VPWR sky130_fd_sc_hd__decap_4
XFILLER_0_15_206 VGND VGND VPWR VPWR sky130_fd_sc_hd__fill_2
XANTENNA__7166__A net35 VGND VGND VPWR VPWR sky130_fd_sc_hd__diode_2
XTAP_TAPCELL_ROW_31_657 VGND VPWR sky130_fd_sc_hd__tapvpwrvgnd_1
XTAP_TAPCELL_ROW_31_668 VGND VPWR sky130_fd_sc_hd__tapvpwrvgnd_1
X_6440_ _3076_ VGND VGND VPWR VPWR _0732_ sky130_fd_sc_hd__clkbuf_1
XANTENNA__7730__A0 _3065_ VGND VGND VPWR VPWR sky130_fd_sc_hd__diode_2
XFILLER_0_15_228 VGND VGND VPWR VPWR sky130_fd_sc_hd__decap_4
XFILLER_0_113_436 VGND VGND VPWR VPWR sky130_fd_sc_hd__fill_2
X_6371_ registers\[3\]\[6\] _2974_ _3030_ VGND VGND VPWR VPWR _3037_ sky130_fd_sc_hd__mux2_1
XFILLER_0_70_378 VGND VGND VPWR VPWR sky130_fd_sc_hd__fill_1
X_8110_ _3994_ VGND VGND VPWR VPWR _0460_ sky130_fd_sc_hd__clkbuf_1
XFILLER_0_51_581 VGND VGND VPWR VPWR sky130_fd_sc_hd__fill_1
XFILLER_0_3_656 VGND VGND VPWR VPWR sky130_fd_sc_hd__fill_1
X_5322_ registers\[16\]\[24\] registers\[17\]\[24\] registers\[18\]\[24\] registers\[19\]\[24\]
+ _2020_ _2021_ VGND VGND VPWR VPWR _2066_ sky130_fd_sc_hd__mux4_1
XFILLER_0_23_272 VGND VGND VPWR VPWR sky130_fd_sc_hd__fill_2
XFILLER_0_2_188 VGND VGND VPWR VPWR sky130_fd_sc_hd__fill_2
X_9090_ clknet_leaf_1_clk _0187_ VGND VGND VPWR VPWR registers\[22\]\[2\] sky130_fd_sc_hd__dfxtp_1
XANTENNA__7105__S _3435_ VGND VGND VPWR VPWR sky130_fd_sc_hd__diode_2
X_8041_ registers\[2\]\[19\] _3474_ _3948_ VGND VGND VPWR VPWR _3958_ sky130_fd_sc_hd__mux2_1
X_5253_ registers\[20\]\[20\] registers\[21\]\[20\] registers\[22\]\[20\] registers\[23\]\[20\]
+ _1996_ _1997_ VGND VGND VPWR VPWR _2001_ sky130_fd_sc_hd__mux4_1
X_5184_ _1809_ _1935_ VGND VGND VPWR VPWR _1936_ sky130_fd_sc_hd__or2_1
XFILLER_0_48_73 VGND VGND VPWR VPWR sky130_fd_sc_hd__fill_2
X_8943_ clknet_leaf_65_clk _0040_ VGND VGND VPWR VPWR registers\[17\]\[15\] sky130_fd_sc_hd__dfxtp_1
XTAP_TAPCELL_ROW_39_768 VGND VPWR sky130_fd_sc_hd__tapvpwrvgnd_1
XTAP_TAPCELL_ROW_108_1663 VGND VPWR sky130_fd_sc_hd__tapvpwrvgnd_1
X_8874_ clknet_leaf_37_clk _0995_ VGND VGND VPWR VPWR registers\[15\]\[10\] sky130_fd_sc_hd__dfxtp_1
XANTENNA__4480__C1 _1142_ VGND VGND VPWR VPWR sky130_fd_sc_hd__diode_2
X_7825_ _3096_ registers\[26\]\[13\] _3840_ VGND VGND VPWR VPWR _3844_ sky130_fd_sc_hd__mux2_1
XFILLER_0_78_467 VGND VGND VPWR VPWR sky130_fd_sc_hd__decap_3
XFILLER_0_66_629 VGND VGND VPWR VPWR sky130_fd_sc_hd__fill_2
XANTENNA__8210__A1 _3439_ VGND VGND VPWR VPWR sky130_fd_sc_hd__diode_2
XFILLER_0_93_415 VGND VGND VPWR VPWR sky130_fd_sc_hd__fill_2
XFILLER_0_80_60 VGND VGND VPWR VPWR sky130_fd_sc_hd__fill_1
XFILLER_0_65_117 VGND VGND VPWR VPWR sky130_fd_sc_hd__decap_3
X_7756_ _3807_ VGND VGND VPWR VPWR _0293_ sky130_fd_sc_hd__clkbuf_1
XTAP_TAPCELL_ROW_50_911 VGND VPWR sky130_fd_sc_hd__tapvpwrvgnd_1
X_4968_ _1617_ VGND VGND VPWR VPWR _1731_ sky130_fd_sc_hd__clkbuf_8
X_7687_ registers\[24\]\[12\] _3460_ _3768_ VGND VGND VPWR VPWR _3771_ sky130_fd_sc_hd__mux2_1
X_6707_ _3233_ VGND VGND VPWR VPWR _0842_ sky130_fd_sc_hd__clkbuf_1
XFILLER_0_73_150 VGND VGND VPWR VPWR sky130_fd_sc_hd__fill_2
X_4899_ registers\[24\]\[2\] registers\[25\]\[2\] registers\[26\]\[2\] registers\[27\]\[2\]
+ _1617_ _1618_ VGND VGND VPWR VPWR _1665_ sky130_fd_sc_hd__mux4_1
XFILLER_0_61_345 VGND VGND VPWR VPWR sky130_fd_sc_hd__fill_2
X_6638_ _3195_ VGND VGND VPWR VPWR _0811_ sky130_fd_sc_hd__clkbuf_1
X_9426_ clknet_leaf_66_clk _0523_ VGND VGND VPWR VPWR registers\[6\]\[18\] sky130_fd_sc_hd__dfxtp_1
XFILLER_0_116_296 VGND VGND VPWR VPWR sky130_fd_sc_hd__fill_2
X_9357_ clknet_leaf_55_clk _0454_ VGND VGND VPWR VPWR registers\[30\]\[13\] sky130_fd_sc_hd__dfxtp_1
XTAP_TAPCELL_ROW_59_1028 VGND VPWR sky130_fd_sc_hd__tapvpwrvgnd_1
X_6569_ registers\[7\]\[19\] _3001_ _3148_ VGND VGND VPWR VPWR _3158_ sky130_fd_sc_hd__mux2_1
X_8308_ _4099_ VGND VGND VPWR VPWR _0553_ sky130_fd_sc_hd__clkbuf_1
XANTENNA__4630__S0 _1347_ VGND VGND VPWR VPWR sky130_fd_sc_hd__diode_2
X_9288_ clknet_leaf_20_clk _0385_ VGND VGND VPWR VPWR registers\[28\]\[8\] sky130_fd_sc_hd__dfxtp_1
XFILLER_0_100_642 VGND VGND VPWR VPWR sky130_fd_sc_hd__fill_2
X_8239_ registers\[6\]\[16\] _3468_ _4056_ VGND VGND VPWR VPWR _4063_ sky130_fd_sc_hd__mux2_1
XANTENNA__7015__S _3398_ VGND VGND VPWR VPWR sky130_fd_sc_hd__diode_2
XFILLER_0_100_664 VGND VGND VPWR VPWR sky130_fd_sc_hd__fill_2
XANTENNA__8029__A1 _3462_ VGND VGND VPWR VPWR sky130_fd_sc_hd__diode_2
XANTENNA__4933__S1 _1679_ VGND VGND VPWR VPWR sky130_fd_sc_hd__diode_2
XANTENNA__5263__A1 _1960_ VGND VGND VPWR VPWR sky130_fd_sc_hd__diode_2
XFILLER_0_69_445 VGND VGND VPWR VPWR sky130_fd_sc_hd__decap_3
XFILLER_0_96_253 VGND VGND VPWR VPWR sky130_fd_sc_hd__decap_3
XFILLER_0_96_242 VGND VGND VPWR VPWR sky130_fd_sc_hd__decap_3
XTAP_TAPCELL_ROW_83_1335 VGND VPWR sky130_fd_sc_hd__tapvpwrvgnd_1
XANTENNA__7685__S _3768_ VGND VGND VPWR VPWR sky130_fd_sc_hd__diode_2
XFILLER_0_84_415 VGND VGND VPWR VPWR sky130_fd_sc_hd__fill_2
XPHY_EDGE_ROW_69_Right_69 VGND VGND VPWR VPWR sky130_fd_sc_hd__decap_3
XPHY_EDGE_ROW_7_Left_127 VGND VGND VPWR VPWR sky130_fd_sc_hd__decap_3
XFILLER_0_92_481 VGND VGND VPWR VPWR sky130_fd_sc_hd__fill_2
XFILLER_0_80_621 VGND VGND VPWR VPWR sky130_fd_sc_hd__fill_1
XANTENNA__4403__A _1060_ VGND VGND VPWR VPWR sky130_fd_sc_hd__diode_2
XFILLER_0_4_409 VGND VGND VPWR VPWR sky130_fd_sc_hd__fill_2
XFILLER_0_107_296 VGND VGND VPWR VPWR sky130_fd_sc_hd__decap_4
XFILLER_0_107_274 VGND VGND VPWR VPWR sky130_fd_sc_hd__fill_2
XFILLER_0_40_507 VGND VGND VPWR VPWR sky130_fd_sc_hd__decap_3
XFILLER_0_100_25 VGND VGND VPWR VPWR sky130_fd_sc_hd__decap_3
XANTENNA__5723__C1 _2270_ VGND VGND VPWR VPWR sky130_fd_sc_hd__diode_2
XFILLER_0_40_529 VGND VGND VPWR VPWR sky130_fd_sc_hd__decap_3
XFILLER_0_21_710 VGND VGND VPWR VPWR sky130_fd_sc_hd__fill_2
XTAP_TAPCELL_ROW_94_1475 VGND VPWR sky130_fd_sc_hd__tapvpwrvgnd_1
XPHY_EDGE_ROW_78_Right_78 VGND VGND VPWR VPWR sky130_fd_sc_hd__decap_3
XFILLER_0_0_637 VGND VGND VPWR VPWR sky130_fd_sc_hd__decap_4
XTAP_TAPCELL_ROW_94_1486 VGND VPWR sky130_fd_sc_hd__tapvpwrvgnd_1
XFILLER_0_0_659 VGND VGND VPWR VPWR sky130_fd_sc_hd__decap_8
XFILLER_0_20_253 VGND VGND VPWR VPWR sky130_fd_sc_hd__decap_3
XANTENNA__4660__A1_N _1372_ VGND VGND VPWR VPWR sky130_fd_sc_hd__diode_2
XFILLER_0_109_34 VGND VGND VPWR VPWR sky130_fd_sc_hd__fill_2
XANTENNA__6764__S _3261_ VGND VGND VPWR VPWR sky130_fd_sc_hd__diode_2
XFILLER_0_18_76 VGND VGND VPWR VPWR sky130_fd_sc_hd__fill_1
XANTENNA__4675__A1_N _1372_ VGND VGND VPWR VPWR sky130_fd_sc_hd__diode_2
XFILLER_0_88_710 VGND VGND VPWR VPWR sky130_fd_sc_hd__fill_2
XANTENNA__6451__A0 _3083_ VGND VGND VPWR VPWR sky130_fd_sc_hd__diode_2
X_5940_ net86 _2661_ VGND VGND VPWR VPWR _2662_ sky130_fd_sc_hd__xnor2_2
XTAP_TAPCELL_ROW_36_727 VGND VPWR sky130_fd_sc_hd__tapvpwrvgnd_1
XPHY_EDGE_ROW_87_Right_87 VGND VGND VPWR VPWR sky130_fd_sc_hd__decap_3
X_5871_ _1851_ _2596_ VGND VGND VPWR VPWR _2597_ sky130_fd_sc_hd__nor2_1
X_7610_ _3729_ VGND VGND VPWR VPWR _0225_ sky130_fd_sc_hd__clkbuf_1
XANTENNA__7595__S _3720_ VGND VGND VPWR VPWR sky130_fd_sc_hd__diode_2
XANTENNA__5101__S1 _1775_ VGND VGND VPWR VPWR sky130_fd_sc_hd__diode_2
X_8590_ clknet_leaf_39_clk _0711_ VGND VGND VPWR VPWR registers\[3\]\[14\] sky130_fd_sc_hd__dfxtp_1
XFILLER_0_47_139 VGND VGND VPWR VPWR sky130_fd_sc_hd__fill_1
X_4822_ _1588_ _1591_ _1379_ VGND VGND VPWR VPWR _1592_ sky130_fd_sc_hd__mux2_1
XFILLER_0_8_726 VGND VGND VPWR VPWR sky130_fd_sc_hd__decap_6
XTAP_TAPCELL_ROW_16_462 VGND VPWR sky130_fd_sc_hd__tapvpwrvgnd_1
XTAP_TAPCELL_ROW_16_473 VGND VPWR sky130_fd_sc_hd__tapvpwrvgnd_1
XTAP_TAPCELL_ROW_103_1593 VGND VPWR sky130_fd_sc_hd__tapvpwrvgnd_1
XFILLER_0_90_429 VGND VGND VPWR VPWR sky130_fd_sc_hd__fill_2
XFILLER_0_90_418 VGND VGND VPWR VPWR sky130_fd_sc_hd__fill_2
X_7541_ _3085_ registers\[22\]\[8\] _3684_ VGND VGND VPWR VPWR _3693_ sky130_fd_sc_hd__mux2_1
XFILLER_0_55_161 VGND VGND VPWR VPWR sky130_fd_sc_hd__fill_2
XFILLER_0_7_225 VGND VGND VPWR VPWR sky130_fd_sc_hd__fill_2
X_4753_ _1525_ _1526_ _1346_ VGND VGND VPWR VPWR _1527_ sky130_fd_sc_hd__mux2_1
XFILLER_0_114_701 VPWR VGND VPWR VGND sky130_ef_sc_hd__decap_12
XANTENNA__4313__A _1073_ VGND VGND VPWR VPWR sky130_fd_sc_hd__diode_2
X_7472_ _3656_ VGND VGND VPWR VPWR _0160_ sky130_fd_sc_hd__clkbuf_1
XFILLER_0_71_621 VGND VGND VPWR VPWR sky130_fd_sc_hd__fill_1
XFILLER_0_50_85 VGND VGND VPWR VPWR sky130_fd_sc_hd__decap_4
XFILLER_0_43_345 VGND VGND VPWR VPWR sky130_fd_sc_hd__fill_2
X_4684_ registers\[0\]\[22\] registers\[1\]\[22\] registers\[2\]\[22\] registers\[3\]\[22\]
+ _1418_ _1419_ VGND VGND VPWR VPWR _1462_ sky130_fd_sc_hd__mux4_1
X_9211_ clknet_leaf_89_clk _0308_ VGND VGND VPWR VPWR registers\[25\]\[27\] sky130_fd_sc_hd__dfxtp_1
X_6423_ registers\[3\]\[31\] _3026_ _3029_ VGND VGND VPWR VPWR _3064_ sky130_fd_sc_hd__mux2_1
XPHY_EDGE_ROW_96_Right_96 VGND VGND VPWR VPWR sky130_fd_sc_hd__decap_3
XANTENNA__6939__S _3323_ VGND VGND VPWR VPWR sky130_fd_sc_hd__diode_2
XFILLER_0_101_428 VGND VGND VPWR VPWR sky130_fd_sc_hd__fill_2
XFILLER_0_101_406 VGND VGND VPWR VPWR sky130_fd_sc_hd__fill_2
X_6354_ registers\[19\]\[31\] _3026_ _2961_ VGND VGND VPWR VPWR _3027_ sky130_fd_sc_hd__mux2_1
X_9142_ clknet_leaf_94_clk _0239_ VGND VGND VPWR VPWR registers\[23\]\[22\] sky130_fd_sc_hd__dfxtp_1
X_9073_ clknet_leaf_54_clk _0170_ VGND VGND VPWR VPWR registers\[21\]\[17\] sky130_fd_sc_hd__dfxtp_1
XANTENNA__5168__S1 _1749_ VGND VGND VPWR VPWR sky130_fd_sc_hd__diode_2
X_6285_ net47 VGND VGND VPWR VPWR _2980_ sky130_fd_sc_hd__buf_2
X_5305_ registers\[16\]\[23\] registers\[17\]\[23\] registers\[18\]\[23\] registers\[19\]\[23\]
+ _1883_ _1774_ VGND VGND VPWR VPWR _2050_ sky130_fd_sc_hd__mux4_1
X_8024_ _3949_ VGND VGND VPWR VPWR _0419_ sky130_fd_sc_hd__clkbuf_1
X_5236_ _1983_ _1984_ _1682_ VGND VGND VPWR VPWR _1985_ sky130_fd_sc_hd__mux2_1
XANTENNA__5493__A1 _2011_ VGND VGND VPWR VPWR sky130_fd_sc_hd__diode_2
XANTENNA__4915__S1 _1679_ VGND VGND VPWR VPWR sky130_fd_sc_hd__diode_2
X_5167_ _1916_ _1919_ _1714_ VGND VGND VPWR VPWR _1920_ sky130_fd_sc_hd__mux2_1
X_5098_ registers\[20\]\[11\] registers\[21\]\[11\] registers\[22\]\[11\] registers\[23\]\[11\]
+ _1763_ _1765_ VGND VGND VPWR VPWR _1855_ sky130_fd_sc_hd__mux4_1
XANTENNA__8431__A1 net17 VGND VGND VPWR VPWR sky130_fd_sc_hd__diode_2
XFILLER_0_98_529 VGND VGND VPWR VPWR sky130_fd_sc_hd__decap_3
XANTENNA__5245__B2 _1714_ VGND VGND VPWR VPWR sky130_fd_sc_hd__diode_2
XANTENNA__4679__S0 _1433_ VGND VGND VPWR VPWR sky130_fd_sc_hd__diode_2
X_8926_ clknet_leaf_97_clk _0023_ VGND VGND VPWR VPWR registers\[16\]\[30\] sky130_fd_sc_hd__dfxtp_1
XFILLER_0_94_713 VGND VGND VPWR VPWR sky130_fd_sc_hd__fill_2
XFILLER_0_78_253 VGND VGND VPWR VPWR sky130_fd_sc_hd__fill_2
XFILLER_0_39_607 VGND VGND VPWR VPWR sky130_fd_sc_hd__fill_2
XFILLER_0_93_223 VGND VGND VPWR VPWR sky130_fd_sc_hd__fill_1
XFILLER_0_78_275 VGND VGND VPWR VPWR sky130_fd_sc_hd__fill_2
XFILLER_0_78_264 VGND VGND VPWR VPWR sky130_fd_sc_hd__fill_2
XFILLER_0_38_128 VGND VGND VPWR VPWR sky130_fd_sc_hd__fill_2
X_8857_ clknet_leaf_82_clk _0978_ VGND VGND VPWR VPWR registers\[14\]\[25\] sky130_fd_sc_hd__dfxtp_1
X_7808_ _3079_ registers\[26\]\[5\] _3829_ VGND VGND VPWR VPWR _3835_ sky130_fd_sc_hd__mux2_1
XTAP_TAPCELL_ROW_65_1098 VGND VPWR sky130_fd_sc_hd__tapvpwrvgnd_1
X_8788_ clknet_leaf_76_clk _0909_ VGND VGND VPWR VPWR registers\[12\]\[20\] sky130_fd_sc_hd__dfxtp_1
X_7739_ _3798_ VGND VGND VPWR VPWR _0285_ sky130_fd_sc_hd__clkbuf_1
XFILLER_0_81_429 VGND VGND VPWR VPWR sky130_fd_sc_hd__decap_3
XFILLER_0_47_673 VGND VGND VPWR VPWR sky130_fd_sc_hd__decap_8
XFILLER_0_117_561 VGND VGND VPWR VPWR sky130_fd_sc_hd__fill_1
XFILLER_0_105_701 VPWR VGND VPWR VGND sky130_ef_sc_hd__decap_12
XANTENNA__4851__S0 _1617_ VGND VGND VPWR VPWR sky130_fd_sc_hd__diode_2
X_9409_ clknet_leaf_6_clk _0506_ VGND VGND VPWR VPWR registers\[6\]\[1\] sky130_fd_sc_hd__dfxtp_1
XFILLER_0_34_345 VGND VGND VPWR VPWR sky130_fd_sc_hd__decap_3
XANTENNA__4603__S0 _1382_ VGND VGND VPWR VPWR sky130_fd_sc_hd__diode_2
XANTENNA__7170__A1 _3493_ VGND VGND VPWR VPWR sky130_fd_sc_hd__diode_2
XFILLER_0_15_570 VGND VGND VPWR VPWR sky130_fd_sc_hd__fill_2
XANTENNA__4369__S _1140_ VGND VGND VPWR VPWR sky130_fd_sc_hd__diode_2
XFILLER_0_30_573 VGND VGND VPWR VPWR sky130_fd_sc_hd__fill_2
XANTENNA__5054__A _1706_ VGND VGND VPWR VPWR sky130_fd_sc_hd__diode_2
XANTENNA__4906__S1 _1643_ VGND VGND VPWR VPWR sky130_fd_sc_hd__diode_2
XANTENNA_input36_A wd3[28] VGND VGND VPWR VPWR sky130_fd_sc_hd__diode_2
XANTENNA__6584__S _3159_ VGND VGND VPWR VPWR sky130_fd_sc_hd__diode_2
XANTENNA__8422__A1 net44 VGND VGND VPWR VPWR sky130_fd_sc_hd__diode_2
XANTENNA__6433__A0 _3071_ VGND VGND VPWR VPWR sky130_fd_sc_hd__diode_2
XANTENNA__4444__C1 _1034_ VGND VGND VPWR VPWR sky130_fd_sc_hd__diode_2
XANTENNA__5331__S1 _2073_ VGND VGND VPWR VPWR sky130_fd_sc_hd__diode_2
XFILLER_0_85_724 VGND VGND VPWR VPWR sky130_fd_sc_hd__decap_4
XFILLER_0_57_437 VGND VGND VPWR VPWR sky130_fd_sc_hd__fill_2
XFILLER_0_29_106 VGND VGND VPWR VPWR sky130_fd_sc_hd__decap_4
XANTENNA__5095__S0 _1758_ VGND VGND VPWR VPWR sky130_fd_sc_hd__diode_2
XFILLER_0_72_418 VGND VGND VPWR VPWR sky130_fd_sc_hd__fill_2
XFILLER_0_44_109 VGND VGND VPWR VPWR sky130_fd_sc_hd__fill_2
XTAP_TAPCELL_ROW_13_432 VGND VPWR sky130_fd_sc_hd__tapvpwrvgnd_1
XFILLER_0_53_621 VGND VGND VPWR VPWR sky130_fd_sc_hd__fill_2
XFILLER_0_5_729 VGND VGND VPWR VPWR sky130_fd_sc_hd__decap_4
XANTENNA__4842__S0 _1427_ VGND VGND VPWR VPWR sky130_fd_sc_hd__diode_2
XTAP_TAPCELL_ROW_96_1504 VGND VPWR sky130_fd_sc_hd__tapvpwrvgnd_1
XTAP_TAPCELL_ROW_41_796 VGND VPWR sky130_fd_sc_hd__tapvpwrvgnd_1
XANTENNA__7161__A1 _3487_ VGND VGND VPWR VPWR sky130_fd_sc_hd__diode_2
XANTENNA__5398__S1 _2109_ VGND VGND VPWR VPWR sky130_fd_sc_hd__diode_2
XFILLER_0_25_389 VGND VGND VPWR VPWR sky130_fd_sc_hd__decap_3
XFILLER_0_52_197 VGND VGND VPWR VPWR sky130_fd_sc_hd__fill_2
XFILLER_0_21_540 VGND VGND VPWR VPWR sky130_fd_sc_hd__fill_2
XFILLER_0_96_48 VGND VGND VPWR VPWR sky130_fd_sc_hd__fill_2
XFILLER_0_29_53 VGND VGND VPWR VPWR sky130_fd_sc_hd__fill_1
XANTENNA__5899__A _1286_ VGND VGND VPWR VPWR sky130_fd_sc_hd__diode_2
X_6070_ _2779_ _2780_ _2783_ _2420_ VGND VGND VPWR VPWR _2785_ sky130_fd_sc_hd__a31o_1
X_5021_ registers\[16\]\[7\] registers\[17\]\[7\] registers\[18\]\[7\] registers\[19\]\[7\]
+ _1731_ _1629_ VGND VGND VPWR VPWR _1782_ sky130_fd_sc_hd__mux4_1
X_8711_ clknet_leaf_29_clk _0832_ VGND VGND VPWR VPWR registers\[10\]\[7\] sky130_fd_sc_hd__dfxtp_1
XTAP_TAPCELL_ROW_105_1622 VGND VPWR sky130_fd_sc_hd__tapvpwrvgnd_1
X_6972_ _3375_ VGND VGND VPWR VPWR _0965_ sky130_fd_sc_hd__clkbuf_1
XTAP_TAPCELL_ROW_49_896 VGND VPWR sky130_fd_sc_hd__tapvpwrvgnd_1
XANTENNA__5322__S1 _2021_ VGND VGND VPWR VPWR sky130_fd_sc_hd__diode_2
XFILLER_0_88_584 VGND VGND VPWR VPWR sky130_fd_sc_hd__fill_2
XFILLER_0_76_713 VGND VGND VPWR VPWR sky130_fd_sc_hd__decap_6
X_5923_ _2644_ _2645_ VGND VGND VPWR VPWR _2646_ sky130_fd_sc_hd__nand2_1
XANTENNA__8214__S _4045_ VGND VGND VPWR VPWR sky130_fd_sc_hd__diode_2
X_5854_ _2539_ _2580_ _2293_ VGND VGND VPWR VPWR _2581_ sky130_fd_sc_hd__mux2_1
XFILLER_0_48_459 VGND VGND VPWR VPWR sky130_fd_sc_hd__fill_2
XANTENNA__6727__A1 _3018_ VGND VGND VPWR VPWR sky130_fd_sc_hd__diode_2
X_8642_ clknet_leaf_4_clk _0763_ VGND VGND VPWR VPWR registers\[7\]\[2\] sky130_fd_sc_hd__dfxtp_1
XANTENNA__5086__S0 _1773_ VGND VGND VPWR VPWR sky130_fd_sc_hd__diode_2
X_4805_ _1572_ _1575_ _1381_ VGND VGND VPWR VPWR _1576_ sky130_fd_sc_hd__mux2_1
X_8573_ clknet_leaf_101_clk _0694_ VGND VGND VPWR VPWR registers\[19\]\[29\] sky130_fd_sc_hd__dfxtp_1
XANTENNA__5139__A _1754_ VGND VGND VPWR VPWR sky130_fd_sc_hd__diode_2
XFILLER_0_90_226 VGND VGND VPWR VPWR sky130_fd_sc_hd__fill_2
X_5785_ _2484_ VGND VGND VPWR VPWR _2515_ sky130_fd_sc_hd__clkbuf_4
X_7524_ _3683_ VGND VGND VPWR VPWR _3684_ sky130_fd_sc_hd__clkbuf_8
XANTENNA__4833__S0 _1555_ VGND VGND VPWR VPWR sky130_fd_sc_hd__diode_2
XFILLER_0_28_161 VGND VGND VPWR VPWR sky130_fd_sc_hd__decap_3
XFILLER_0_29_684 VGND VGND VPWR VPWR sky130_fd_sc_hd__decap_3
XFILLER_0_44_676 VGND VGND VPWR VPWR sky130_fd_sc_hd__fill_2
X_4736_ registers\[4\]\[25\] registers\[5\]\[25\] registers\[6\]\[25\] registers\[7\]\[25\]
+ _1390_ _1391_ VGND VGND VPWR VPWR _1511_ sky130_fd_sc_hd__mux4_1
XFILLER_0_114_542 VGND VGND VPWR VPWR sky130_fd_sc_hd__decap_3
XANTENNA__4978__A _1740_ VGND VGND VPWR VPWR sky130_fd_sc_hd__diode_2
XANTENNA__5389__S1 _2127_ VGND VGND VPWR VPWR sky130_fd_sc_hd__diode_2
X_4667_ registers\[8\]\[21\] registers\[9\]\[21\] registers\[10\]\[21\] registers\[11\]\[21\]
+ _1427_ _1428_ VGND VGND VPWR VPWR _1446_ sky130_fd_sc_hd__mux4_1
X_7455_ _3067_ _3610_ VGND VGND VPWR VPWR _3647_ sky130_fd_sc_hd__nand2_4
X_6406_ _3055_ VGND VGND VPWR VPWR _0719_ sky130_fd_sc_hd__clkbuf_1
X_7386_ net12 net11 net13 VGND VGND VPWR VPWR _3610_ sky130_fd_sc_hd__and3b_2
XTAP_TAPCELL_ROW_116_1773 VGND VPWR sky130_fd_sc_hd__tapvpwrvgnd_1
XTAP_TAPCELL_ROW_116_1762 VGND VPWR sky130_fd_sc_hd__tapvpwrvgnd_1
XFILLER_0_101_225 VGND VGND VPWR VPWR sky130_fd_sc_hd__fill_2
XFILLER_0_101_214 VGND VGND VPWR VPWR sky130_fd_sc_hd__decap_4
X_9125_ clknet_leaf_27_clk _0222_ VGND VGND VPWR VPWR registers\[23\]\[5\] sky130_fd_sc_hd__dfxtp_1
X_4598_ _1375_ _1378_ _1379_ VGND VGND VPWR VPWR _1380_ sky130_fd_sc_hd__mux2_1
X_6337_ _3015_ VGND VGND VPWR VPWR _0690_ sky130_fd_sc_hd__clkbuf_1
XANTENNA__5010__S0 _1763_ VGND VGND VPWR VPWR sky130_fd_sc_hd__diode_2
X_6268_ registers\[19\]\[3\] _2968_ _2962_ VGND VGND VPWR VPWR _2969_ sky130_fd_sc_hd__mux2_1
X_9056_ clknet_leaf_111_clk _0153_ VGND VGND VPWR VPWR registers\[21\]\[0\] sky130_fd_sc_hd__dfxtp_1
X_5219_ _1811_ VGND VGND VPWR VPWR _1969_ sky130_fd_sc_hd__buf_4
X_6199_ _2837_ _2903_ _2906_ VGND VGND VPWR VPWR _2907_ sky130_fd_sc_hd__o21ba_1
X_8007_ _3940_ VGND VGND VPWR VPWR _0411_ sky130_fd_sc_hd__clkbuf_1
XANTENNA_clkbuf_leaf_84_clk_A clknet_4_10_0_clk VGND VGND VPWR VPWR sky130_fd_sc_hd__diode_2
XPHY_EDGE_ROW_88_Left_208 VGND VGND VPWR VPWR sky130_fd_sc_hd__decap_3
XTAP_TAPCELL_ROW_67_1127 VGND VPWR sky130_fd_sc_hd__tapvpwrvgnd_1
XANTENNA__5313__S1 _1764_ VGND VGND VPWR VPWR sky130_fd_sc_hd__diode_2
X_8909_ clknet_leaf_58_clk _0006_ VGND VGND VPWR VPWR registers\[16\]\[13\] sky130_fd_sc_hd__dfxtp_1
XTAP_TAPCELL_ROW_80_1305 VGND VPWR sky130_fd_sc_hd__tapvpwrvgnd_1
XANTENNA__8124__S _3995_ VGND VGND VPWR VPWR sky130_fd_sc_hd__diode_2
XANTENNA_clkbuf_leaf_99_clk_A clknet_4_3_0_clk VGND VGND VPWR VPWR sky130_fd_sc_hd__diode_2
XFILLER_0_54_407 VGND VGND VPWR VPWR sky130_fd_sc_hd__fill_2
XANTENNA__7963__S _3912_ VGND VGND VPWR VPWR sky130_fd_sc_hd__diode_2
XFILLER_0_109_358 VGND VGND VPWR VPWR sky130_fd_sc_hd__decap_8
XANTENNA_clkbuf_leaf_22_clk_A clknet_4_1_0_clk VGND VGND VPWR VPWR sky130_fd_sc_hd__diode_2
XANTENNA__5049__A _1631_ VGND VGND VPWR VPWR sky130_fd_sc_hd__diode_2
XANTENNA__4824__S0 _1404_ VGND VGND VPWR VPWR sky130_fd_sc_hd__diode_2
XANTENNA__7391__A1 _3437_ VGND VGND VPWR VPWR sky130_fd_sc_hd__diode_2
XFILLER_0_19_172 VGND VGND VPWR VPWR sky130_fd_sc_hd__fill_2
XFILLER_0_105_542 VGND VGND VPWR VPWR sky130_fd_sc_hd__decap_4
XFILLER_0_62_473 VGND VGND VPWR VPWR sky130_fd_sc_hd__decap_3
XFILLER_0_22_304 VGND VGND VPWR VPWR sky130_fd_sc_hd__fill_2
XFILLER_0_34_164 VGND VGND VPWR VPWR sky130_fd_sc_hd__fill_2
XPHY_EDGE_ROW_97_Left_217 VGND VGND VPWR VPWR sky130_fd_sc_hd__decap_3
XTAP_TAPCELL_ROW_78_1278 VGND VPWR sky130_fd_sc_hd__tapvpwrvgnd_1
XTAP_TAPCELL_ROW_78_1267 VGND VPWR sky130_fd_sc_hd__tapvpwrvgnd_1
Xclkbuf_4_0_0_clk clknet_0_clk VGND VGND VPWR VPWR clknet_4_0_0_clk sky130_fd_sc_hd__clkbuf_8
XFILLER_0_34_197 VGND VGND VPWR VPWR sky130_fd_sc_hd__decap_3
XANTENNA_clkbuf_leaf_37_clk_A clknet_4_7_0_clk VGND VGND VPWR VPWR sky130_fd_sc_hd__diode_2
XTAP_TAPCELL_ROW_91_1445 VGND VPWR sky130_fd_sc_hd__tapvpwrvgnd_1
XFILLER_0_66_29 VGND VGND VPWR VPWR sky130_fd_sc_hd__fill_2
XFILLER_0_89_304 VGND VGND VPWR VPWR sky130_fd_sc_hd__decap_4
XFILLER_0_82_39 VGND VGND VPWR VPWR sky130_fd_sc_hd__decap_4
XANTENNA__5304__S1 _1774_ VGND VGND VPWR VPWR sky130_fd_sc_hd__diode_2
XANTENNA_clkload1_A clknet_4_2_0_clk VGND VGND VPWR VPWR sky130_fd_sc_hd__diode_2
XFILLER_0_85_521 VGND VGND VPWR VPWR sky130_fd_sc_hd__fill_2
XTAP_TAPCELL_ROW_46_855 VGND VPWR sky130_fd_sc_hd__tapvpwrvgnd_1
XFILLER_0_15_55 VGND VGND VPWR VPWR sky130_fd_sc_hd__fill_1
XANTENNA__5068__S0 _1762_ VGND VGND VPWR VPWR sky130_fd_sc_hd__diode_2
XANTENNA__6185__A2 _2886_ VGND VGND VPWR VPWR sky130_fd_sc_hd__diode_2
XFILLER_0_72_226 VGND VGND VPWR VPWR sky130_fd_sc_hd__fill_2
XFILLER_0_72_215 VGND VGND VPWR VPWR sky130_fd_sc_hd__fill_1
XFILLER_0_38_492 VGND VGND VPWR VPWR sky130_fd_sc_hd__decap_4
X_5570_ _2303_ _2305_ VGND VGND VPWR VPWR _2306_ sky130_fd_sc_hd__and2b_1
XTAP_TAPCELL_ROW_100_1563 VGND VPWR sky130_fd_sc_hd__tapvpwrvgnd_1
XANTENNA__5932__A2 _2587_ VGND VGND VPWR VPWR sky130_fd_sc_hd__diode_2
XFILLER_0_26_643 VGND VGND VPWR VPWR sky130_fd_sc_hd__fill_1
X_4521_ registers\[20\]\[14\] registers\[21\]\[14\] registers\[22\]\[14\] registers\[23\]\[14\]
+ _1136_ _1137_ VGND VGND VPWR VPWR _1307_ sky130_fd_sc_hd__mux4_1
XANTENNA__4798__A _1569_ VGND VGND VPWR VPWR sky130_fd_sc_hd__diode_2
XANTENNA__5393__S _2081_ VGND VGND VPWR VPWR sky130_fd_sc_hd__diode_2
X_4452_ registers\[28\]\[10\] registers\[29\]\[10\] registers\[30\]\[10\] registers\[31\]\[10\]
+ _1110_ _1112_ VGND VGND VPWR VPWR _1242_ sky130_fd_sc_hd__mux4_1
XFILLER_0_41_657 VGND VGND VPWR VPWR sky130_fd_sc_hd__fill_2
XFILLER_0_13_337 VGND VGND VPWR VPWR sky130_fd_sc_hd__decap_4
X_7240_ registers\[17\]\[27\] _3491_ _3525_ VGND VGND VPWR VPWR _3533_ sky130_fd_sc_hd__mux2_1
XANTENNA__6893__A0 _3085_ VGND VGND VPWR VPWR sky130_fd_sc_hd__diode_2
XANTENNA__5240__S0 _1798_ VGND VGND VPWR VPWR sky130_fd_sc_hd__diode_2
X_4383_ registers\[8\]\[6\] registers\[9\]\[6\] registers\[10\]\[6\] registers\[11\]\[6\]
+ _1160_ _1161_ VGND VGND VPWR VPWR _1177_ sky130_fd_sc_hd__mux4_1
X_7171_ _3494_ VGND VGND VPWR VPWR _0021_ sky130_fd_sc_hd__clkbuf_1
XFILLER_0_0_253 VGND VGND VPWR VPWR sky130_fd_sc_hd__fill_2
XFILLER_0_21_381 VGND VGND VPWR VPWR sky130_fd_sc_hd__fill_2
X_6122_ _2699_ _2700_ _2703_ _2832_ _2833_ VGND VGND VPWR VPWR _2834_ sky130_fd_sc_hd__a311o_1
XFILLER_0_0_297 VGND VGND VPWR VPWR sky130_fd_sc_hd__fill_2
X_6053_ _2468_ _2765_ _2768_ _2429_ VGND VGND VPWR VPWR _2769_ sky130_fd_sc_hd__a211o_1
XANTENNA__6518__A net37 VGND VGND VPWR VPWR sky130_fd_sc_hd__diode_2
X_5004_ registers\[8\]\[6\] registers\[9\]\[6\] registers\[10\]\[6\] registers\[11\]\[6\]
+ _1763_ _1765_ VGND VGND VPWR VPWR _1766_ sky130_fd_sc_hd__mux4_1
XANTENNA__6952__S _3361_ VGND VGND VPWR VPWR sky130_fd_sc_hd__diode_2
X_6955_ _3366_ VGND VGND VPWR VPWR _0957_ sky130_fd_sc_hd__clkbuf_1
XFILLER_0_72_61 VGND VGND VPWR VPWR sky130_fd_sc_hd__fill_2
XFILLER_0_119_601 VPWR VGND VPWR VGND sky130_ef_sc_hd__decap_12
XANTENNA__4472__S _1122_ VGND VGND VPWR VPWR sky130_fd_sc_hd__diode_2
XFILLER_0_72_83 VGND VGND VPWR VPWR sky130_fd_sc_hd__fill_1
X_5906_ _2599_ _2592_ _2612_ _2628_ _2629_ VGND VGND VPWR VPWR _2630_ sky130_fd_sc_hd__a311o_1
XFILLER_0_119_645 VPWR VGND VPWR VGND sky130_ef_sc_hd__decap_12
X_8625_ clknet_leaf_54_clk _0746_ VGND VGND VPWR VPWR registers\[29\]\[17\] sky130_fd_sc_hd__dfxtp_1
X_6886_ _3329_ VGND VGND VPWR VPWR _0925_ sky130_fd_sc_hd__clkbuf_1
X_5837_ _2460_ _2563_ _2564_ VGND VGND VPWR VPWR _2565_ sky130_fd_sc_hd__a21oi_1
XTAP_TAPCELL_ROW_62_1068 VGND VPWR sky130_fd_sc_hd__tapvpwrvgnd_1
XANTENNA__4806__S0 _1550_ VGND VGND VPWR VPWR sky130_fd_sc_hd__diode_2
XFILLER_0_36_429 VGND VGND VPWR VPWR sky130_fd_sc_hd__fill_2
X_8556_ clknet_leaf_42_clk _0677_ VGND VGND VPWR VPWR registers\[19\]\[12\] sky130_fd_sc_hd__dfxtp_1
X_5768_ _2336_ _2371_ _1090_ VGND VGND VPWR VPWR _2499_ sky130_fd_sc_hd__mux2_1
XFILLER_0_44_440 VGND VGND VPWR VPWR sky130_fd_sc_hd__fill_2
XFILLER_0_16_131 VGND VGND VPWR VPWR sky130_fd_sc_hd__decap_8
X_8487_ _4194_ VGND VGND VPWR VPWR _0637_ sky130_fd_sc_hd__clkbuf_1
X_7507_ _3119_ registers\[21\]\[24\] _3670_ VGND VGND VPWR VPWR _3675_ sky130_fd_sc_hd__mux2_1
X_4719_ _1379_ _1494_ VGND VGND VPWR VPWR _1495_ sky130_fd_sc_hd__nor2_1
XFILLER_0_114_361 VGND VGND VPWR VPWR sky130_fd_sc_hd__decap_3
X_5699_ _1704_ _2431_ VGND VGND VPWR VPWR _2432_ sky130_fd_sc_hd__and2_1
XFILLER_0_71_281 VGND VGND VPWR VPWR sky130_fd_sc_hd__decap_3
X_7438_ _3638_ VGND VGND VPWR VPWR _0144_ sky130_fd_sc_hd__clkbuf_1
XFILLER_0_114_394 VGND VGND VPWR VPWR sky130_fd_sc_hd__fill_2
XANTENNA__5231__S0 _1719_ VGND VGND VPWR VPWR sky130_fd_sc_hd__diode_2
XFILLER_0_31_178 VGND VGND VPWR VPWR sky130_fd_sc_hd__decap_4
XFILLER_0_12_381 VGND VGND VPWR VPWR sky130_fd_sc_hd__fill_1
X_7369_ _3601_ VGND VGND VPWR VPWR _0112_ sky130_fd_sc_hd__clkbuf_1
XFILLER_0_102_589 VGND VGND VPWR VPWR sky130_fd_sc_hd__decap_4
X_9108_ clknet_leaf_74_clk _0205_ VGND VGND VPWR VPWR registers\[22\]\[20\] sky130_fd_sc_hd__dfxtp_1
X_9039_ clknet_leaf_65_clk _0136_ VGND VGND VPWR VPWR registers\[20\]\[15\] sky130_fd_sc_hd__dfxtp_1
XANTENNA__5439__A1 _1768_ VGND VGND VPWR VPWR sky130_fd_sc_hd__diode_2
XANTENNA__7023__S _3398_ VGND VGND VPWR VPWR sky130_fd_sc_hd__diode_2
XFILLER_0_99_613 VGND VGND VPWR VPWR sky130_fd_sc_hd__decap_3
XANTENNA__5332__A _1856_ VGND VGND VPWR VPWR sky130_fd_sc_hd__diode_2
XFILLER_0_99_679 VGND VGND VPWR VPWR sky130_fd_sc_hd__fill_1
XFILLER_0_98_145 VGND VGND VPWR VPWR sky130_fd_sc_hd__fill_2
XFILLER_0_98_178 VGND VGND VPWR VPWR sky130_fd_sc_hd__fill_2
XFILLER_0_86_307 VGND VGND VPWR VPWR sky130_fd_sc_hd__fill_1
XANTENNA__5298__S0 _1762_ VGND VGND VPWR VPWR sky130_fd_sc_hd__diode_2
XPHY_EDGE_ROW_105_Right_105 VGND VGND VPWR VPWR sky130_fd_sc_hd__decap_3
XTAP_TAPCELL_ROW_43_814 VGND VPWR sky130_fd_sc_hd__tapvpwrvgnd_1
XFILLER_0_109_155 VGND VGND VPWR VPWR sky130_fd_sc_hd__fill_2
XANTENNA__7693__S _3768_ VGND VGND VPWR VPWR sky130_fd_sc_hd__diode_2
XANTENNA__7364__A1 _3479_ VGND VGND VPWR VPWR sky130_fd_sc_hd__diode_2
XFILLER_0_82_557 VGND VGND VPWR VPWR sky130_fd_sc_hd__fill_2
XTAP_TAPCELL_ROW_23_560 VGND VPWR sky130_fd_sc_hd__tapvpwrvgnd_1
XFILLER_0_22_101 VGND VGND VPWR VPWR sky130_fd_sc_hd__fill_2
XFILLER_0_112_309 VGND VGND VPWR VPWR sky130_fd_sc_hd__fill_2
XANTENNA__4411__A _1203_ VGND VGND VPWR VPWR sky130_fd_sc_hd__diode_2
XFILLER_0_50_421 VGND VGND VPWR VPWR sky130_fd_sc_hd__fill_2
XFILLER_0_105_372 VPWR VGND VPWR VGND sky130_ef_sc_hd__decap_12
XFILLER_0_10_307 VGND VGND VPWR VPWR sky130_fd_sc_hd__fill_1
XFILLER_0_10_318 VGND VGND VPWR VPWR sky130_fd_sc_hd__fill_1
XANTENNA__8029__S _3948_ VGND VGND VPWR VPWR sky130_fd_sc_hd__diode_2
XANTENNA__6338__A net34 VGND VGND VPWR VPWR sky130_fd_sc_hd__diode_2
XFILLER_0_93_49 VGND VGND VPWR VPWR sky130_fd_sc_hd__decap_4
XANTENNA__7868__S _3865_ VGND VGND VPWR VPWR sky130_fd_sc_hd__diode_2
XANTENNA__6772__S _3261_ VGND VGND VPWR VPWR sky130_fd_sc_hd__diode_2
XFILLER_0_89_178 VGND VGND VPWR VPWR sky130_fd_sc_hd__fill_2
XANTENNA__5289__S0 _1810_ VGND VGND VPWR VPWR sky130_fd_sc_hd__diode_2
X_6740_ _3251_ VGND VGND VPWR VPWR _0857_ sky130_fd_sc_hd__clkbuf_1
Xclkbuf_leaf_109_clk clknet_4_0_0_clk VGND VGND VPWR VPWR clknet_leaf_109_clk sky130_fd_sc_hd__clkbuf_8
XANTENNA__7169__A net36 VGND VGND VPWR VPWR sky130_fd_sc_hd__diode_2
XFILLER_0_58_576 VGND VGND VPWR VPWR sky130_fd_sc_hd__fill_2
XFILLER_0_46_727 VGND VGND VPWR VPWR sky130_fd_sc_hd__decap_3
XANTENNA__7355__A1 _3470_ VGND VGND VPWR VPWR sky130_fd_sc_hd__diode_2
XFILLER_0_73_535 VGND VGND VPWR VPWR sky130_fd_sc_hd__decap_3
XFILLER_0_58_587 VGND VGND VPWR VPWR sky130_fd_sc_hd__fill_1
X_6671_ registers\[10\]\[0\] _2958_ _3214_ VGND VGND VPWR VPWR _3215_ sky130_fd_sc_hd__mux2_1
XFILLER_0_116_637 VGND VGND VPWR VPWR sky130_fd_sc_hd__decap_6
X_9390_ clknet_leaf_39_clk _0487_ VGND VGND VPWR VPWR registers\[9\]\[14\] sky130_fd_sc_hd__dfxtp_1
X_5622_ _2355_ _2356_ VGND VGND VPWR VPWR _2357_ sky130_fd_sc_hd__nand2_1
X_8410_ registers\[8\]\[0\] net16 _4153_ VGND VGND VPWR VPWR _4154_ sky130_fd_sc_hd__mux2_1
X_5553_ _2267_ _2287_ _2288_ VGND VGND VPWR VPWR _2289_ sky130_fd_sc_hd__a21bo_1
X_8341_ _4116_ VGND VGND VPWR VPWR _4117_ sky130_fd_sc_hd__clkbuf_8
XFILLER_0_5_323 VGND VGND VPWR VPWR sky130_fd_sc_hd__fill_2
XFILLER_0_26_451 VGND VGND VPWR VPWR sky130_fd_sc_hd__fill_2
XFILLER_0_115_169 VGND VGND VPWR VPWR sky130_fd_sc_hd__decap_8
X_4504_ registers\[24\]\[13\] registers\[25\]\[13\] registers\[26\]\[13\] registers\[27\]\[13\]
+ _1167_ _1168_ VGND VGND VPWR VPWR _1291_ sky130_fd_sc_hd__mux4_1
XANTENNA__7108__S _3435_ VGND VGND VPWR VPWR sky130_fd_sc_hd__diode_2
XANTENNA__4321__A _1116_ VGND VGND VPWR VPWR sky130_fd_sc_hd__diode_2
X_5484_ _2219_ VGND VGND VPWR VPWR _2220_ sky130_fd_sc_hd__buf_2
X_8272_ _3396_ _3066_ VGND VGND VPWR VPWR _4080_ sky130_fd_sc_hd__nand2_4
XTAP_TAPCELL_ROW_113_1732 VGND VPWR sky130_fd_sc_hd__tapvpwrvgnd_1
X_7223_ registers\[17\]\[19\] _3474_ _3514_ VGND VGND VPWR VPWR _3524_ sky130_fd_sc_hd__mux2_1
X_4435_ registers\[16\]\[9\] registers\[17\]\[9\] registers\[18\]\[9\] registers\[19\]\[9\]
+ _1053_ _1054_ VGND VGND VPWR VPWR _1226_ sky130_fd_sc_hd__mux4_1
X_4366_ _1127_ VGND VGND VPWR VPWR _1161_ sky130_fd_sc_hd__buf_4
X_7154_ net31 VGND VGND VPWR VPWR _3483_ sky130_fd_sc_hd__buf_2
X_6105_ _2817_ _1484_ _2803_ VGND VGND VPWR VPWR _2818_ sky130_fd_sc_hd__or3b_1
X_4297_ registers\[28\]\[3\] registers\[29\]\[3\] registers\[30\]\[3\] registers\[31\]\[3\]
+ _1060_ _1061_ VGND VGND VPWR VPWR _1094_ sky130_fd_sc_hd__mux4_1
X_7085_ _3436_ VGND VGND VPWR VPWR _1017_ sky130_fd_sc_hd__clkbuf_1
X_6036_ _1979_ _2740_ _2747_ VGND VGND VPWR VPWR _2753_ sky130_fd_sc_hd__o21ai_1
XANTENNA__7778__S _3815_ VGND VGND VPWR VPWR sky130_fd_sc_hd__diode_2
XTAP_TAPCELL_ROW_1_266 VGND VPWR sky130_fd_sc_hd__tapvpwrvgnd_1
X_7987_ _3929_ VGND VGND VPWR VPWR _0402_ sky130_fd_sc_hd__clkbuf_1
XTAP_TAPCELL_ROW_1_277 VGND VPWR sky130_fd_sc_hd__tapvpwrvgnd_1
XFILLER_0_76_351 VGND VGND VPWR VPWR sky130_fd_sc_hd__fill_2
XFILLER_0_49_565 VGND VGND VPWR VPWR sky130_fd_sc_hd__fill_2
XFILLER_0_49_554 VGND VGND VPWR VPWR sky130_fd_sc_hd__fill_2
X_6938_ _3356_ VGND VGND VPWR VPWR _0950_ sky130_fd_sc_hd__clkbuf_1
XFILLER_0_119_464 VGND VGND VPWR VPWR sky130_fd_sc_hd__fill_2
XFILLER_0_119_453 VGND VGND VPWR VPWR sky130_fd_sc_hd__decap_4
XFILLER_0_9_640 VGND VGND VPWR VPWR sky130_fd_sc_hd__fill_2
X_6869_ registers\[12\]\[29\] _3022_ _3310_ VGND VGND VPWR VPWR _3320_ sky130_fd_sc_hd__mux2_1
XFILLER_0_119_475 VGND VGND VPWR VPWR sky130_fd_sc_hd__fill_1
X_8608_ clknet_leaf_111_clk _0729_ VGND VGND VPWR VPWR registers\[29\]\[0\] sky130_fd_sc_hd__dfxtp_1
XFILLER_0_9_673 VGND VGND VPWR VPWR sky130_fd_sc_hd__fill_2
XANTENNA__8402__S _4139_ VGND VGND VPWR VPWR sky130_fd_sc_hd__diode_2
XFILLER_0_36_248 VGND VGND VPWR VPWR sky130_fd_sc_hd__fill_1
XFILLER_0_91_387 VGND VGND VPWR VPWR sky130_fd_sc_hd__fill_2
XFILLER_0_8_194 VGND VGND VPWR VPWR sky130_fd_sc_hd__fill_2
X_8539_ _4221_ VGND VGND VPWR VPWR _0662_ sky130_fd_sc_hd__clkbuf_1
XANTENNA__5204__S0 _1820_ VGND VGND VPWR VPWR sky130_fd_sc_hd__diode_2
XANTENNA__4231__A _1030_ VGND VGND VPWR VPWR sky130_fd_sc_hd__diode_2
XTAP_TAPCELL_ROW_75_1237 VGND VPWR sky130_fd_sc_hd__tapvpwrvgnd_1
XANTENNA__6857__S _3310_ VGND VGND VPWR VPWR sky130_fd_sc_hd__diode_2
XFILLER_0_20_638 VGND VGND VPWR VPWR sky130_fd_sc_hd__decap_3
XFILLER_0_4_3 VGND VGND VPWR VPWR sky130_fd_sc_hd__fill_2
XTAP_TAPCELL_ROW_9_377 VGND VPWR sky130_fd_sc_hd__tapvpwrvgnd_1
XFILLER_0_102_397 VGND VGND VPWR VPWR sky130_fd_sc_hd__fill_2
XANTENNA__4377__S _1117_ VGND VGND VPWR VPWR sky130_fd_sc_hd__diode_2
XANTENNA__5062__A _1692_ VGND VGND VPWR VPWR sky130_fd_sc_hd__diode_2
XFILLER_0_87_627 VGND VGND VPWR VPWR sky130_fd_sc_hd__fill_2
XTAP_TAPCELL_ROW_86_1377 VGND VPWR sky130_fd_sc_hd__tapvpwrvgnd_1
XTAP_TAPCELL_ROW_56_983 VGND VPWR sky130_fd_sc_hd__tapvpwrvgnd_1
XANTENNA__4406__A _1127_ VGND VGND VPWR VPWR sky130_fd_sc_hd__diode_2
XANTENNA__4494__S1 _1204_ VGND VGND VPWR VPWR sky130_fd_sc_hd__diode_2
XFILLER_0_28_727 VGND VGND VPWR VPWR sky130_fd_sc_hd__decap_3
XFILLER_0_55_546 VPWR VGND VPWR VGND sky130_ef_sc_hd__decap_12
XANTENNA__4840__S _1386_ VGND VGND VPWR VPWR sky130_fd_sc_hd__diode_2
XFILLER_0_82_365 VGND VGND VPWR VPWR sky130_fd_sc_hd__decap_8
XFILLER_0_70_527 VGND VGND VPWR VPWR sky130_fd_sc_hd__fill_2
XFILLER_0_70_505 VGND VGND VPWR VPWR sky130_fd_sc_hd__fill_2
XANTENNA__4246__S1 _1040_ VGND VGND VPWR VPWR sky130_fd_sc_hd__diode_2
XFILLER_0_12_67 VGND VGND VPWR VPWR sky130_fd_sc_hd__fill_2
XFILLER_0_12_89 VGND VGND VPWR VPWR sky130_fd_sc_hd__fill_2
XFILLER_0_35_281 VGND VGND VPWR VPWR sky130_fd_sc_hd__decap_3
XFILLER_0_106_692 VGND VGND VPWR VPWR sky130_fd_sc_hd__fill_2
XFILLER_0_88_38 VGND VGND VPWR VPWR sky130_fd_sc_hd__fill_1
Xoutput107 net107 VGND VGND VPWR VPWR rd1[4] sky130_fd_sc_hd__buf_1
XFILLER_0_23_443 VGND VGND VPWR VPWR sky130_fd_sc_hd__fill_2
XFILLER_0_23_465 VGND VGND VPWR VPWR sky130_fd_sc_hd__fill_2
Xoutput118 net118 VGND VGND VPWR VPWR rd2[14] sky130_fd_sc_hd__buf_1
Xoutput129 net129 VGND VGND VPWR VPWR rd2[24] sky130_fd_sc_hd__buf_1
XFILLER_0_11_638 VGND VGND VPWR VPWR sky130_fd_sc_hd__fill_1
XFILLER_0_23_487 VGND VGND VPWR VPWR sky130_fd_sc_hd__fill_1
XANTENNA__6076__A1 _2362_ VGND VGND VPWR VPWR sky130_fd_sc_hd__diode_2
XANTENNA__6068__A _2034_ VGND VGND VPWR VPWR sky130_fd_sc_hd__diode_2
XFILLER_0_37_20 VGND VGND VPWR VPWR sky130_fd_sc_hd__fill_2
X_7910_ _3113_ registers\[27\]\[21\] _3887_ VGND VGND VPWR VPWR _3889_ sky130_fd_sc_hd__mux2_1
X_8890_ clknet_leaf_89_clk _1011_ VGND VGND VPWR VPWR registers\[15\]\[26\] sky130_fd_sc_hd__dfxtp_1
XANTENNA__7025__A0 _3079_ VGND VGND VPWR VPWR sky130_fd_sc_hd__diode_2
XFILLER_0_77_104 VGND VGND VPWR VPWR sky130_fd_sc_hd__decap_4
XANTENNA__5700__A _1704_ VGND VGND VPWR VPWR sky130_fd_sc_hd__diode_2
X_7841_ _3852_ VGND VGND VPWR VPWR _0333_ sky130_fd_sc_hd__clkbuf_1
XFILLER_0_78_649 VGND VGND VPWR VPWR sky130_fd_sc_hd__fill_2
X_4984_ _1682_ VGND VGND VPWR VPWR _1746_ sky130_fd_sc_hd__buf_4
XANTENNA__4316__A _1061_ VGND VGND VPWR VPWR sky130_fd_sc_hd__diode_2
XFILLER_0_53_74 VGND VGND VPWR VPWR sky130_fd_sc_hd__decap_4
X_7772_ _3110_ registers\[25\]\[20\] _3815_ VGND VGND VPWR VPWR _3816_ sky130_fd_sc_hd__mux2_1
XANTENNA__7328__A1 _3443_ VGND VGND VPWR VPWR sky130_fd_sc_hd__diode_2
X_9511_ clknet_leaf_29_clk _0608_ VGND VGND VPWR VPWR registers\[8\]\[7\] sky130_fd_sc_hd__dfxtp_1
X_6723_ registers\[10\]\[25\] _3014_ _3236_ VGND VGND VPWR VPWR _3242_ sky130_fd_sc_hd__mux2_1
XFILLER_0_116_401 VGND VGND VPWR VPWR sky130_fd_sc_hd__decap_3
XFILLER_0_85_192 VGND VGND VPWR VPWR sky130_fd_sc_hd__decap_3
XANTENNA__8222__S _4045_ VGND VGND VPWR VPWR sky130_fd_sc_hd__diode_2
XFILLER_0_73_332 VGND VGND VPWR VPWR sky130_fd_sc_hd__fill_2
XANTENNA__5339__B1 _1960_ VGND VGND VPWR VPWR sky130_fd_sc_hd__diode_2
X_6654_ registers\[0\]\[26\] _3016_ _3197_ VGND VGND VPWR VPWR _3204_ sky130_fd_sc_hd__mux2_1
XANTENNA__4750__S _1379_ VGND VGND VPWR VPWR sky130_fd_sc_hd__diode_2
X_9442_ clknet_leaf_0_clk _0539_ VGND VGND VPWR VPWR registers\[31\]\[2\] sky130_fd_sc_hd__dfxtp_1
XTAP_TAPCELL_ROW_34_699 VGND VPWR sky130_fd_sc_hd__tapvpwrvgnd_1
X_5605_ _1882_ _2215_ _1050_ VGND VGND VPWR VPWR _2340_ sky130_fd_sc_hd__o21ai_1
XFILLER_0_61_505 VGND VGND VPWR VPWR sky130_fd_sc_hd__fill_2
XANTENNA__5434__S0 _1996_ VGND VGND VPWR VPWR sky130_fd_sc_hd__diode_2
XFILLER_0_116_489 VGND VGND VPWR VPWR sky130_fd_sc_hd__fill_2
XFILLER_0_14_421 VGND VGND VPWR VPWR sky130_fd_sc_hd__decap_8
X_9373_ clknet_leaf_102_clk _0470_ VGND VGND VPWR VPWR registers\[30\]\[29\] sky130_fd_sc_hd__dfxtp_1
XFILLER_0_26_270 VGND VGND VPWR VPWR sky130_fd_sc_hd__fill_2
X_6585_ _3166_ VGND VGND VPWR VPWR _0787_ sky130_fd_sc_hd__clkbuf_1
X_5536_ _2270_ _2271_ VGND VGND VPWR VPWR _2272_ sky130_fd_sc_hd__nand2_1
X_8324_ _3012_ registers\[31\]\[24\] _4103_ VGND VGND VPWR VPWR _4108_ sky130_fd_sc_hd__mux2_1
XFILLER_0_112_662 VPWR VGND VPWR VGND sky130_ef_sc_hd__decap_12
XANTENNA__4986__A _1705_ VGND VGND VPWR VPWR sky130_fd_sc_hd__diode_2
X_5467_ net143 net144 net114 _1270_ VGND VGND VPWR VPWR _2203_ sky130_fd_sc_hd__or4b_4
XANTENNA__6677__S _3214_ VGND VGND VPWR VPWR sky130_fd_sc_hd__diode_2
XFILLER_0_41_262 VGND VGND VPWR VPWR sky130_fd_sc_hd__fill_2
X_8255_ _4071_ VGND VGND VPWR VPWR _0528_ sky130_fd_sc_hd__clkbuf_1
X_7206_ _3515_ VGND VGND VPWR VPWR _0035_ sky130_fd_sc_hd__clkbuf_1
XFILLER_0_111_150 VGND VGND VPWR VPWR sky130_fd_sc_hd__decap_4
XFILLER_0_78_82 VGND VGND VPWR VPWR sky130_fd_sc_hd__fill_2
X_4418_ registers\[28\]\[8\] registers\[29\]\[8\] registers\[30\]\[8\] registers\[31\]\[8\]
+ _1196_ _1202_ VGND VGND VPWR VPWR _1210_ sky130_fd_sc_hd__mux4_1
XFILLER_0_111_194 VGND VGND VPWR VPWR sky130_fd_sc_hd__fill_2
X_8186_ registers\[9\]\[23\] _3483_ _4031_ VGND VGND VPWR VPWR _4035_ sky130_fd_sc_hd__mux2_1
X_5398_ registers\[16\]\[28\] registers\[17\]\[28\] registers\[18\]\[28\] registers\[19\]\[28\]
+ _2097_ _2109_ VGND VGND VPWR VPWR _2138_ sky130_fd_sc_hd__mux4_1
X_7137_ _3471_ VGND VGND VPWR VPWR _0010_ sky130_fd_sc_hd__clkbuf_1
X_4349_ _1109_ _1123_ _1134_ _1144_ VGND VGND VPWR VPWR _1145_ sky130_fd_sc_hd__a2bb2o_4
XTAP_TAPCELL_ROW_6_336 VGND VPWR sky130_fd_sc_hd__tapvpwrvgnd_1
XTAP_TAPCELL_ROW_70_1167 VGND VPWR sky130_fd_sc_hd__tapvpwrvgnd_1
X_7068_ _3426_ VGND VGND VPWR VPWR _1010_ sky130_fd_sc_hd__clkbuf_1
X_6019_ _2731_ _2735_ _2736_ VGND VGND VPWR VPWR _2737_ sky130_fd_sc_hd__a21oi_1
XFILLER_0_68_104 VGND VGND VPWR VPWR sky130_fd_sc_hd__decap_3
XTAP_TAPCELL_ROW_53_942 VGND VPWR sky130_fd_sc_hd__tapvpwrvgnd_1
XANTENNA__4226__A a2[0] VGND VGND VPWR VPWR sky130_fd_sc_hd__diode_2
XFILLER_0_77_671 VGND VGND VPWR VPWR sky130_fd_sc_hd__fill_1
XTAP_TAPCELL_ROW_53_953 VGND VPWR sky130_fd_sc_hd__tapvpwrvgnd_1
XFILLER_0_76_181 VGND VGND VPWR VPWR sky130_fd_sc_hd__fill_2
XANTENNA__8132__S _3972_ VGND VGND VPWR VPWR sky130_fd_sc_hd__diode_2
XFILLER_0_107_445 VGND VGND VPWR VPWR sky130_fd_sc_hd__decap_3
XFILLER_0_107_434 VGND VGND VPWR VPWR sky130_fd_sc_hd__fill_2
XFILLER_0_91_151 VGND VGND VPWR VPWR sky130_fd_sc_hd__fill_2
XFILLER_0_64_365 VGND VGND VPWR VPWR sky130_fd_sc_hd__decap_8
XANTENNA__4228__S1 _1027_ VGND VGND VPWR VPWR sky130_fd_sc_hd__diode_2
XANTENNA__5425__S0 _2126_ VGND VGND VPWR VPWR sky130_fd_sc_hd__diode_2
XFILLER_0_64_398 VGND VGND VPWR VPWR sky130_fd_sc_hd__decap_3
XANTENNA__7971__S _3912_ VGND VGND VPWR VPWR sky130_fd_sc_hd__diode_2
XFILLER_0_52_549 VGND VGND VPWR VPWR sky130_fd_sc_hd__decap_3
XFILLER_0_17_281 VGND VGND VPWR VPWR sky130_fd_sc_hd__fill_2
XFILLER_0_103_673 VGND VGND VPWR VPWR sky130_fd_sc_hd__fill_1
XANTENNA__7272__A _3538_ VGND VGND VPWR VPWR sky130_fd_sc_hd__diode_2
XANTENNA__4400__S1 _1137_ VGND VGND VPWR VPWR sky130_fd_sc_hd__diode_2
XANTENNA__5504__B _2213_ VGND VGND VPWR VPWR sky130_fd_sc_hd__diode_2
XANTENNA__6058__A1 _1995_ VGND VGND VPWR VPWR sky130_fd_sc_hd__diode_2
XTAP_TAPCELL_ROW_88_1406 VGND VPWR sky130_fd_sc_hd__tapvpwrvgnd_1
XFILLER_0_74_29 VGND VGND VPWR VPWR sky130_fd_sc_hd__fill_2
XANTENNA__8307__S _4092_ VGND VGND VPWR VPWR sky130_fd_sc_hd__diode_2
XANTENNA__7211__S _3514_ VGND VGND VPWR VPWR sky130_fd_sc_hd__diode_2
XFILLER_0_99_251 VGND VGND VPWR VPWR sky130_fd_sc_hd__decap_3
XFILLER_0_59_148 VGND VGND VPWR VPWR sky130_fd_sc_hd__fill_2
XFILLER_0_114_46 VGND VGND VPWR VPWR sky130_fd_sc_hd__decap_3
XANTENNA__4467__S1 _1203_ VGND VGND VPWR VPWR sky130_fd_sc_hd__diode_2
XANTENNA__6230__A1 net138 VGND VGND VPWR VPWR sky130_fd_sc_hd__diode_2
XANTENNA__5666__S _2353_ VGND VGND VPWR VPWR sky130_fd_sc_hd__diode_2
XFILLER_0_7_429 VGND VGND VPWR VPWR sky130_fd_sc_hd__fill_1
XFILLER_0_7_418 VGND VGND VPWR VPWR sky130_fd_sc_hd__fill_1
Xclkbuf_leaf_40_clk clknet_4_7_0_clk VGND VGND VPWR VPWR clknet_leaf_40_clk sky130_fd_sc_hd__clkbuf_8
XFILLER_0_55_387 VGND VGND VPWR VPWR sky130_fd_sc_hd__fill_2
XFILLER_0_43_505 VGND VGND VPWR VPWR sky130_fd_sc_hd__fill_2
XFILLER_0_28_579 VGND VGND VPWR VPWR sky130_fd_sc_hd__fill_2
XTAP_TAPCELL_ROW_31_658 VGND VPWR sky130_fd_sc_hd__tapvpwrvgnd_1
XTAP_TAPCELL_ROW_99_1546 VGND VPWR sky130_fd_sc_hd__tapvpwrvgnd_1
XFILLER_0_82_195 VGND VGND VPWR VPWR sky130_fd_sc_hd__fill_1
X_6370_ _3036_ VGND VGND VPWR VPWR _0702_ sky130_fd_sc_hd__clkbuf_1
XFILLER_0_70_368 VGND VGND VPWR VPWR sky130_fd_sc_hd__decap_8
X_5321_ registers\[20\]\[24\] registers\[21\]\[24\] registers\[22\]\[24\] registers\[23\]\[24\]
+ _2020_ _2021_ VGND VGND VPWR VPWR _2065_ sky130_fd_sc_hd__mux4_1
XFILLER_0_3_668 VGND VGND VPWR VPWR sky130_fd_sc_hd__fill_2
XFILLER_0_11_402 VGND VGND VPWR VPWR sky130_fd_sc_hd__fill_1
XFILLER_0_11_413 VGND VGND VPWR VPWR sky130_fd_sc_hd__decap_6
XFILLER_0_61_8 VGND VGND VPWR VPWR sky130_fd_sc_hd__fill_2
X_8040_ _3957_ VGND VGND VPWR VPWR _0427_ sky130_fd_sc_hd__clkbuf_1
XFILLER_0_11_435 VGND VGND VPWR VPWR sky130_fd_sc_hd__fill_2
XFILLER_0_23_295 VGND VGND VPWR VPWR sky130_fd_sc_hd__fill_2
X_5252_ registers\[16\]\[20\] registers\[17\]\[20\] registers\[18\]\[20\] registers\[19\]\[20\]
+ _1996_ _1997_ VGND VGND VPWR VPWR _2000_ sky130_fd_sc_hd__mux4_1
X_5183_ registers\[8\]\[16\] registers\[9\]\[16\] registers\[10\]\[16\] registers\[11\]\[16\]
+ _1742_ _1743_ VGND VGND VPWR VPWR _1935_ sky130_fd_sc_hd__mux4_1
XFILLER_0_48_85 VPWR VGND VPWR VGND sky130_ef_sc_hd__decap_12
X_8942_ clknet_leaf_53_clk _0039_ VGND VGND VPWR VPWR registers\[17\]\[14\] sky130_fd_sc_hd__dfxtp_1
XANTENNA__7121__S _3456_ VGND VGND VPWR VPWR sky130_fd_sc_hd__diode_2
XTAP_TAPCELL_ROW_39_769 VGND VPWR sky130_fd_sc_hd__tapvpwrvgnd_1
XANTENNA__5430__A _2168_ VGND VGND VPWR VPWR sky130_fd_sc_hd__diode_2
XTAP_TAPCELL_ROW_108_1664 VGND VPWR sky130_fd_sc_hd__tapvpwrvgnd_1
X_8873_ clknet_leaf_20_clk _0994_ VGND VGND VPWR VPWR registers\[15\]\[9\] sky130_fd_sc_hd__dfxtp_1
XANTENNA__6960__S _3361_ VGND VGND VPWR VPWR sky130_fd_sc_hd__diode_2
X_7824_ _3843_ VGND VGND VPWR VPWR _0325_ sky130_fd_sc_hd__clkbuf_1
XFILLER_0_93_427 VGND VGND VPWR VPWR sky130_fd_sc_hd__fill_1
XFILLER_0_59_682 VGND VGND VPWR VPWR sky130_fd_sc_hd__fill_2
XFILLER_0_19_502 VGND VGND VPWR VPWR sky130_fd_sc_hd__fill_2
XFILLER_0_108_209 VGND VGND VPWR VPWR sky130_fd_sc_hd__fill_2
X_4967_ _1726_ _1727_ _1728_ _1729_ _1631_ _1655_ VGND VGND VPWR VPWR _1730_ sky130_fd_sc_hd__mux4_1
X_7755_ _3094_ registers\[25\]\[12\] _3804_ VGND VGND VPWR VPWR _3807_ sky130_fd_sc_hd__mux2_1
XFILLER_0_80_83 VGND VGND VPWR VPWR sky130_fd_sc_hd__fill_1
XFILLER_0_80_72 VGND VGND VPWR VPWR sky130_fd_sc_hd__fill_1
XTAP_TAPCELL_ROW_50_912 VGND VPWR sky130_fd_sc_hd__tapvpwrvgnd_1
XFILLER_0_117_721 VGND VGND VPWR VPWR sky130_fd_sc_hd__decap_6
X_7686_ _3770_ VGND VGND VPWR VPWR _0260_ sky130_fd_sc_hd__clkbuf_1
Xclkbuf_leaf_31_clk clknet_4_5_0_clk VGND VGND VPWR VPWR clknet_leaf_31_clk sky130_fd_sc_hd__clkbuf_8
X_6706_ registers\[10\]\[17\] _2997_ _3225_ VGND VGND VPWR VPWR _3233_ sky130_fd_sc_hd__mux2_1
XFILLER_0_73_140 VGND VGND VPWR VPWR sky130_fd_sc_hd__fill_2
XANTENNA__6261__A net27 VGND VGND VPWR VPWR sky130_fd_sc_hd__diode_2
XFILLER_0_46_365 VGND VGND VPWR VPWR sky130_fd_sc_hd__decap_4
X_4898_ registers\[28\]\[2\] registers\[29\]\[2\] registers\[30\]\[2\] registers\[31\]\[2\]
+ _1617_ _1618_ VGND VGND VPWR VPWR _1664_ sky130_fd_sc_hd__mux4_1
XFILLER_0_34_516 VGND VGND VPWR VPWR sky130_fd_sc_hd__fill_2
X_9425_ clknet_leaf_49_clk _0522_ VGND VGND VPWR VPWR registers\[6\]\[17\] sky130_fd_sc_hd__dfxtp_1
X_6637_ registers\[0\]\[18\] _2999_ _3186_ VGND VGND VPWR VPWR _3195_ sky130_fd_sc_hd__mux2_1
XFILLER_0_34_549 VGND VGND VPWR VPWR sky130_fd_sc_hd__fill_1
XFILLER_0_104_437 VGND VGND VPWR VPWR sky130_fd_sc_hd__fill_2
X_9356_ clknet_leaf_44_clk _0453_ VGND VGND VPWR VPWR registers\[30\]\[12\] sky130_fd_sc_hd__dfxtp_1
XTAP_TAPCELL_ROW_59_1029 VGND VPWR sky130_fd_sc_hd__tapvpwrvgnd_1
X_6568_ _3157_ VGND VGND VPWR VPWR _0779_ sky130_fd_sc_hd__clkbuf_1
XFILLER_0_6_484 VGND VGND VPWR VPWR sky130_fd_sc_hd__fill_1
XFILLER_0_104_448 VGND VGND VPWR VPWR sky130_fd_sc_hd__fill_2
XFILLER_0_89_92 VGND VGND VPWR VPWR sky130_fd_sc_hd__fill_2
X_5519_ _2253_ _2254_ VGND VGND VPWR VPWR _2255_ sky130_fd_sc_hd__or2_1
X_8307_ _2995_ registers\[31\]\[16\] _4092_ VGND VGND VPWR VPWR _4099_ sky130_fd_sc_hd__mux2_1
XANTENNA__4630__S1 _1348_ VGND VGND VPWR VPWR sky130_fd_sc_hd__diode_2
XFILLER_0_14_251 VGND VGND VPWR VPWR sky130_fd_sc_hd__fill_1
XFILLER_0_30_722 VGND VGND VPWR VPWR sky130_fd_sc_hd__decap_6
X_9287_ clknet_leaf_23_clk _0384_ VGND VGND VPWR VPWR registers\[28\]\[7\] sky130_fd_sc_hd__dfxtp_1
XANTENNA__7092__A net41 VGND VGND VPWR VPWR sky130_fd_sc_hd__diode_2
XFILLER_0_42_593 VGND VGND VPWR VPWR sky130_fd_sc_hd__fill_1
X_6499_ _3116_ VGND VGND VPWR VPWR _0751_ sky130_fd_sc_hd__clkbuf_1
X_8238_ _4062_ VGND VGND VPWR VPWR _0520_ sky130_fd_sc_hd__clkbuf_1
XFILLER_0_100_654 VGND VGND VPWR VPWR sky130_fd_sc_hd__decap_3
X_8169_ registers\[9\]\[15\] _3466_ _4020_ VGND VGND VPWR VPWR _4026_ sky130_fd_sc_hd__mux2_1
XFILLER_0_10_490 VGND VGND VPWR VPWR sky130_fd_sc_hd__fill_2
Xclkbuf_leaf_98_clk clknet_4_9_0_clk VGND VGND VPWR VPWR clknet_leaf_98_clk sky130_fd_sc_hd__clkbuf_8
XFILLER_0_97_700 VGND VGND VPWR VPWR sky130_fd_sc_hd__fill_1
XANTENNA__7031__S _3398_ VGND VGND VPWR VPWR sky130_fd_sc_hd__diode_2
XTAP_TAPCELL_ROW_83_1336 VGND VPWR sky130_fd_sc_hd__tapvpwrvgnd_1
XFILLER_0_96_298 VGND VGND VPWR VPWR sky130_fd_sc_hd__fill_2
XFILLER_0_84_449 VGND VGND VPWR VPWR sky130_fd_sc_hd__fill_2
XFILLER_0_107_220 VGND VGND VPWR VPWR sky130_fd_sc_hd__fill_2
XFILLER_0_92_460 VGND VGND VPWR VPWR sky130_fd_sc_hd__fill_2
Xclkbuf_leaf_22_clk clknet_4_1_0_clk VGND VGND VPWR VPWR clknet_leaf_22_clk sky130_fd_sc_hd__clkbuf_8
XFILLER_0_64_151 VGND VGND VPWR VPWR sky130_fd_sc_hd__decap_3
XANTENNA__7712__A1 _3485_ VGND VGND VPWR VPWR sky130_fd_sc_hd__diode_2
XFILLER_0_107_264 VGND VGND VPWR VPWR sky130_fd_sc_hd__fill_1
XFILLER_0_80_677 VGND VGND VPWR VPWR sky130_fd_sc_hd__fill_2
XFILLER_0_80_699 VGND VGND VPWR VPWR sky130_fd_sc_hd__fill_1
XFILLER_0_80_688 VGND VGND VPWR VPWR sky130_fd_sc_hd__fill_2
XFILLER_0_21_700 VGND VGND VPWR VPWR sky130_fd_sc_hd__fill_1
XANTENNA__5515__A _2152_ VGND VGND VPWR VPWR sky130_fd_sc_hd__diode_2
XTAP_TAPCELL_ROW_94_1487 VGND VPWR sky130_fd_sc_hd__tapvpwrvgnd_1
XTAP_TAPCELL_ROW_94_1476 VGND VPWR sky130_fd_sc_hd__tapvpwrvgnd_1
XFILLER_0_109_57 VGND VGND VPWR VPWR sky130_fd_sc_hd__decap_4
XFILLER_0_18_22 VGND VGND VPWR VPWR sky130_fd_sc_hd__fill_2
Xclkbuf_leaf_89_clk clknet_4_8_0_clk VGND VGND VPWR VPWR clknet_leaf_89_clk sky130_fd_sc_hd__clkbuf_8
XPHY_EDGE_ROW_108_Left_228 VGND VGND VPWR VPWR sky130_fd_sc_hd__decap_3
XANTENNA__8037__S _3948_ VGND VGND VPWR VPWR sky130_fd_sc_hd__diode_2
XFILLER_0_34_10 VGND VGND VPWR VPWR sky130_fd_sc_hd__fill_2
XANTENNA__7876__S _3865_ VGND VGND VPWR VPWR sky130_fd_sc_hd__diode_2
X_5870_ net114 _2595_ VGND VGND VPWR VPWR _2596_ sky130_fd_sc_hd__xor2_1
XTAP_TAPCELL_ROW_36_728 VGND VPWR sky130_fd_sc_hd__tapvpwrvgnd_1
XFILLER_0_75_405 VPWR VGND VPWR VGND sky130_ef_sc_hd__decap_12
X_4821_ _1589_ _1590_ _1421_ VGND VGND VPWR VPWR _1591_ sky130_fd_sc_hd__mux2_1
XFILLER_0_87_298 VGND VGND VPWR VPWR sky130_fd_sc_hd__fill_2
XFILLER_0_56_630 VGND VGND VPWR VPWR sky130_fd_sc_hd__fill_1
XTAP_TAPCELL_ROW_16_463 VGND VPWR sky130_fd_sc_hd__tapvpwrvgnd_1
XPHY_EDGE_ROW_117_Left_237 VGND VGND VPWR VPWR sky130_fd_sc_hd__decap_3
XTAP_TAPCELL_ROW_103_1594 VGND VPWR sky130_fd_sc_hd__tapvpwrvgnd_1
X_7540_ _3692_ VGND VGND VPWR VPWR _0192_ sky130_fd_sc_hd__clkbuf_1
XFILLER_0_71_611 VGND VGND VPWR VPWR sky130_fd_sc_hd__fill_2
XFILLER_0_56_652 VGND VGND VPWR VPWR sky130_fd_sc_hd__decap_3
XFILLER_0_55_151 VGND VGND VPWR VPWR sky130_fd_sc_hd__decap_4
Xclkbuf_leaf_13_clk clknet_4_3_0_clk VGND VGND VPWR VPWR clknet_leaf_13_clk sky130_fd_sc_hd__clkbuf_8
X_4752_ registers\[8\]\[26\] registers\[9\]\[26\] registers\[10\]\[26\] registers\[11\]\[26\]
+ _1390_ _1391_ VGND VGND VPWR VPWR _1526_ sky130_fd_sc_hd__mux4_1
XFILLER_0_28_365 VGND VGND VPWR VPWR sky130_fd_sc_hd__fill_1
X_7471_ _3083_ registers\[21\]\[7\] _3648_ VGND VGND VPWR VPWR _3656_ sky130_fd_sc_hd__mux2_1
X_4683_ _1421_ _1460_ VGND VGND VPWR VPWR _1461_ sky130_fd_sc_hd__or2_1
XFILLER_0_16_549 VGND VGND VPWR VPWR sky130_fd_sc_hd__fill_1
XFILLER_0_114_713 VPWR VGND VPWR VGND sky130_ef_sc_hd__decap_12
XFILLER_0_71_677 VPWR VGND VPWR VGND sky130_ef_sc_hd__decap_12
X_6422_ _3063_ VGND VGND VPWR VPWR _0727_ sky130_fd_sc_hd__clkbuf_1
XFILLER_0_43_368 VGND VGND VPWR VPWR sky130_fd_sc_hd__decap_3
XFILLER_0_43_357 VGND VGND VPWR VPWR sky130_fd_sc_hd__fill_1
X_9210_ clknet_leaf_77_clk _0307_ VGND VGND VPWR VPWR registers\[25\]\[26\] sky130_fd_sc_hd__dfxtp_1
X_9141_ clknet_leaf_78_clk _0238_ VGND VGND VPWR VPWR registers\[23\]\[21\] sky130_fd_sc_hd__dfxtp_1
XANTENNA__7467__A0 _3079_ VGND VGND VPWR VPWR sky130_fd_sc_hd__diode_2
XANTENNA__5190__B2 _1771_ VGND VGND VPWR VPWR sky130_fd_sc_hd__diode_2
XFILLER_0_59_51 VGND VGND VPWR VPWR sky130_fd_sc_hd__decap_4
XFILLER_0_51_390 VGND VGND VPWR VPWR sky130_fd_sc_hd__fill_2
XFILLER_0_3_476 VGND VGND VPWR VPWR sky130_fd_sc_hd__fill_2
X_6353_ net40 VGND VGND VPWR VPWR _3026_ sky130_fd_sc_hd__buf_2
X_9072_ clknet_leaf_61_clk _0169_ VGND VGND VPWR VPWR registers\[21\]\[16\] sky130_fd_sc_hd__dfxtp_1
X_6284_ _2979_ VGND VGND VPWR VPWR _0673_ sky130_fd_sc_hd__clkbuf_1
X_5304_ registers\[20\]\[23\] registers\[21\]\[23\] registers\[22\]\[23\] registers\[23\]\[23\]
+ _1883_ _1774_ VGND VGND VPWR VPWR _2049_ sky130_fd_sc_hd__mux4_1
XANTENNA__4376__S0 _1167_ VGND VGND VPWR VPWR sky130_fd_sc_hd__diode_2
X_8023_ registers\[2\]\[10\] _3455_ _3948_ VGND VGND VPWR VPWR _3949_ sky130_fd_sc_hd__mux2_1
X_5235_ registers\[24\]\[19\] registers\[25\]\[19\] registers\[26\]\[19\] registers\[27\]\[19\]
+ _1719_ _1720_ VGND VGND VPWR VPWR _1984_ sky130_fd_sc_hd__mux4_1
XANTENNA__5493__A2 _2216_ VGND VGND VPWR VPWR sky130_fd_sc_hd__diode_2
X_5166_ _1917_ _1918_ _1752_ VGND VGND VPWR VPWR _1919_ sky130_fd_sc_hd__mux2_1
X_5097_ registers\[16\]\[11\] registers\[17\]\[11\] registers\[18\]\[11\] registers\[19\]\[11\]
+ _1763_ _1765_ VGND VGND VPWR VPWR _1854_ sky130_fd_sc_hd__mux4_1
XFILLER_0_98_508 VGND VGND VPWR VPWR sky130_fd_sc_hd__fill_1
XFILLER_0_79_711 VGND VGND VPWR VPWR sky130_fd_sc_hd__decap_4
XANTENNA__5160__A _1913_ VGND VGND VPWR VPWR sky130_fd_sc_hd__diode_2
XFILLER_0_78_210 VGND VGND VPWR VPWR sky130_fd_sc_hd__fill_1
XANTENNA__4679__S1 _1434_ VGND VGND VPWR VPWR sky130_fd_sc_hd__diode_2
X_8925_ clknet_leaf_102_clk _0022_ VGND VGND VPWR VPWR registers\[16\]\[29\] sky130_fd_sc_hd__dfxtp_1
XANTENNA__4797__A1_N _1438_ VGND VGND VPWR VPWR sky130_fd_sc_hd__diode_2
XANTENNA__7786__S _3815_ VGND VGND VPWR VPWR sky130_fd_sc_hd__diode_2
X_8856_ clknet_leaf_88_clk _0977_ VGND VGND VPWR VPWR registers\[14\]\[24\] sky130_fd_sc_hd__dfxtp_1
X_7807_ _3834_ VGND VGND VPWR VPWR _0317_ sky130_fd_sc_hd__clkbuf_1
X_5999_ _2714_ _2711_ _2717_ VGND VGND VPWR VPWR _2718_ sky130_fd_sc_hd__or3_1
XFILLER_0_59_490 VGND VGND VPWR VPWR sky130_fd_sc_hd__fill_1
X_8787_ clknet_leaf_13_clk _0908_ VGND VGND VPWR VPWR registers\[12\]\[19\] sky130_fd_sc_hd__dfxtp_1
XFILLER_0_19_310 VGND VGND VPWR VPWR sky130_fd_sc_hd__fill_2
XFILLER_0_19_332 VGND VGND VPWR VPWR sky130_fd_sc_hd__fill_1
X_7738_ _3077_ registers\[25\]\[4\] _3793_ VGND VGND VPWR VPWR _3798_ sky130_fd_sc_hd__mux2_1
XTAP_TAPCELL_ROW_65_1099 VGND VPWR sky130_fd_sc_hd__tapvpwrvgnd_1
XFILLER_0_117_540 VGND VGND VPWR VPWR sky130_fd_sc_hd__fill_2
XANTENNA__4851__S1 _1618_ VGND VGND VPWR VPWR sky130_fd_sc_hd__diode_2
XFILLER_0_105_713 VPWR VGND VPWR VGND sky130_ef_sc_hd__decap_12
X_7669_ _3761_ VGND VGND VPWR VPWR _0252_ sky130_fd_sc_hd__clkbuf_1
XANTENNA__8410__S _4153_ VGND VGND VPWR VPWR sky130_fd_sc_hd__diode_2
X_9408_ clknet_leaf_3_clk _0505_ VGND VGND VPWR VPWR registers\[6\]\[0\] sky130_fd_sc_hd__dfxtp_1
XFILLER_0_22_508 VGND VGND VPWR VPWR sky130_fd_sc_hd__fill_2
XFILLER_0_62_699 VGND VGND VPWR VPWR sky130_fd_sc_hd__fill_1
XANTENNA__4603__S1 _1383_ VGND VGND VPWR VPWR sky130_fd_sc_hd__diode_2
XFILLER_0_6_281 VGND VGND VPWR VPWR sky130_fd_sc_hd__fill_1
XFILLER_0_104_267 VGND VGND VPWR VPWR sky130_fd_sc_hd__fill_2
X_9339_ clknet_leaf_106_clk _0436_ VGND VGND VPWR VPWR registers\[2\]\[27\] sky130_fd_sc_hd__dfxtp_1
XFILLER_0_30_530 VGND VGND VPWR VPWR sky130_fd_sc_hd__fill_2
XFILLER_0_30_541 VGND VGND VPWR VPWR sky130_fd_sc_hd__fill_2
XANTENNA__4367__S0 _1160_ VGND VGND VPWR VPWR sky130_fd_sc_hd__diode_2
XANTENNA__6865__S _3310_ VGND VGND VPWR VPWR sky130_fd_sc_hd__diode_2
XFILLER_0_30_585 VGND VGND VPWR VPWR sky130_fd_sc_hd__fill_1
XANTENNA__6681__A1 _2972_ VGND VGND VPWR VPWR sky130_fd_sc_hd__diode_2
XANTENNA_input29_A wd3[21] VGND VGND VPWR VPWR sky130_fd_sc_hd__diode_2
XFILLER_0_69_254 VGND VGND VPWR VPWR sky130_fd_sc_hd__fill_2
XANTENNA__8186__A1 _3483_ VGND VGND VPWR VPWR sky130_fd_sc_hd__diode_2
XANTENNA__5095__S1 _1760_ VGND VGND VPWR VPWR sky130_fd_sc_hd__diode_2
XTAP_TAPCELL_ROW_13_422 VGND VPWR sky130_fd_sc_hd__tapvpwrvgnd_1
XTAP_TAPCELL_ROW_13_433 VGND VPWR sky130_fd_sc_hd__tapvpwrvgnd_1
XFILLER_0_108_551 VGND VGND VPWR VPWR sky130_fd_sc_hd__decap_3
XFILLER_0_53_633 VGND VGND VPWR VPWR sky130_fd_sc_hd__fill_2
XFILLER_0_52_110 VGND VGND VPWR VPWR sky130_fd_sc_hd__fill_2
XFILLER_0_5_708 VGND VGND VPWR VPWR sky130_fd_sc_hd__fill_2
XANTENNA__4842__S1 _1428_ VGND VGND VPWR VPWR sky130_fd_sc_hd__diode_2
XFILLER_0_112_7 VGND VGND VPWR VPWR sky130_fd_sc_hd__decap_4
XTAP_TAPCELL_ROW_96_1505 VGND VPWR sky130_fd_sc_hd__tapvpwrvgnd_1
XFILLER_0_80_430 VGND VGND VPWR VPWR sky130_fd_sc_hd__fill_2
XFILLER_0_53_677 VGND VGND VPWR VPWR sky130_fd_sc_hd__decap_8
XFILLER_0_52_121 VGND VGND VPWR VPWR sky130_fd_sc_hd__decap_3
XTAP_TAPCELL_ROW_41_797 VGND VPWR sky130_fd_sc_hd__tapvpwrvgnd_1
XTAP_TAPCELL_ROW_41_786 VGND VPWR sky130_fd_sc_hd__tapvpwrvgnd_1
XANTENNA__8320__S _4103_ VGND VGND VPWR VPWR sky130_fd_sc_hd__diode_2
XFILLER_0_25_335 VGND VGND VPWR VPWR sky130_fd_sc_hd__fill_1
XFILLER_0_80_485 VGND VGND VPWR VPWR sky130_fd_sc_hd__fill_2
XFILLER_0_53_699 VGND VGND VPWR VPWR sky130_fd_sc_hd__fill_1
XFILLER_0_52_154 VGND VGND VPWR VPWR sky130_fd_sc_hd__decap_3
XFILLER_0_20_45 VGND VGND VPWR VPWR sky130_fd_sc_hd__decap_4
XFILLER_0_110_215 VGND VGND VPWR VPWR sky130_fd_sc_hd__fill_1
XFILLER_0_96_38 VGND VGND VPWR VPWR sky130_fd_sc_hd__decap_4
XFILLER_0_29_32 VGND VGND VPWR VPWR sky130_fd_sc_hd__fill_2
X_5020_ registers\[20\]\[7\] registers\[21\]\[7\] registers\[22\]\[7\] registers\[23\]\[7\]
+ _1731_ _1691_ VGND VGND VPWR VPWR _1781_ sky130_fd_sc_hd__mux4_1
Xclkbuf_leaf_2_clk clknet_4_0_0_clk VGND VGND VPWR VPWR clknet_leaf_2_clk sky130_fd_sc_hd__clkbuf_8
XPHY_EDGE_ROW_119_Right_119 VGND VGND VPWR VPWR sky130_fd_sc_hd__decap_3
X_8710_ clknet_leaf_36_clk _0831_ VGND VGND VPWR VPWR registers\[10\]\[6\] sky130_fd_sc_hd__dfxtp_1
XTAP_TAPCELL_ROW_105_1623 VGND VPWR sky130_fd_sc_hd__tapvpwrvgnd_1
X_6971_ _3094_ registers\[14\]\[12\] _3372_ VGND VGND VPWR VPWR _3375_ sky130_fd_sc_hd__mux2_1
XTAP_TAPCELL_ROW_49_897 VGND VPWR sky130_fd_sc_hd__tapvpwrvgnd_1
XFILLER_0_17_7 VGND VGND VPWR VPWR sky130_fd_sc_hd__decap_4
XANTENNA__4530__S0 _1198_ VGND VGND VPWR VPWR sky130_fd_sc_hd__diode_2
XFILLER_0_88_563 VGND VGND VPWR VPWR sky130_fd_sc_hd__decap_6
XFILLER_0_75_202 VGND VGND VPWR VPWR sky130_fd_sc_hd__fill_2
X_5922_ _2622_ _2643_ net117 VGND VGND VPWR VPWR _2645_ sky130_fd_sc_hd__o21ai_1
XFILLER_0_118_304 VGND VGND VPWR VPWR sky130_fd_sc_hd__fill_2
X_5853_ _2338_ _2346_ VGND VGND VPWR VPWR _2580_ sky130_fd_sc_hd__and2_1
X_8641_ clknet_leaf_6_clk _0762_ VGND VGND VPWR VPWR registers\[7\]\[1\] sky130_fd_sc_hd__dfxtp_1
XFILLER_0_8_502 VGND VGND VPWR VPWR sky130_fd_sc_hd__fill_2
XFILLER_0_29_630 VPWR VGND VPWR VGND sky130_ef_sc_hd__decap_12
XANTENNA__5086__S1 _1775_ VGND VGND VPWR VPWR sky130_fd_sc_hd__diode_2
X_5784_ _1145_ _1166_ VGND VGND VPWR VPWR _2514_ sky130_fd_sc_hd__nand2_4
XFILLER_0_63_419 VGND VGND VPWR VPWR sky130_fd_sc_hd__fill_1
X_8572_ clknet_leaf_104_clk _0693_ VGND VGND VPWR VPWR registers\[19\]\[28\] sky130_fd_sc_hd__dfxtp_1
X_4804_ _1573_ _1574_ _1513_ VGND VGND VPWR VPWR _1575_ sky130_fd_sc_hd__mux2_1
XFILLER_0_118_359 VGND VGND VPWR VPWR sky130_fd_sc_hd__fill_2
XFILLER_0_90_238 VGND VGND VPWR VPWR sky130_fd_sc_hd__fill_2
XFILLER_0_56_471 VGND VGND VPWR VPWR sky130_fd_sc_hd__fill_2
X_4735_ _1508_ _1509_ _1421_ VGND VGND VPWR VPWR _1510_ sky130_fd_sc_hd__mux2_1
XFILLER_0_16_313 VGND VGND VPWR VPWR sky130_fd_sc_hd__fill_1
XANTENNA__4833__S1 _1556_ VGND VGND VPWR VPWR sky130_fd_sc_hd__diode_2
XFILLER_0_28_173 VGND VGND VPWR VPWR sky130_fd_sc_hd__fill_2
XFILLER_0_28_184 VGND VGND VPWR VPWR sky130_fd_sc_hd__fill_2
X_7523_ _3359_ _3610_ VGND VGND VPWR VPWR _3683_ sky130_fd_sc_hd__nand2_4
XFILLER_0_114_521 VGND VGND VPWR VPWR sky130_fd_sc_hd__fill_2
X_4666_ _1441_ _1442_ _1443_ _1444_ _1386_ _1159_ VGND VGND VPWR VPWR _1445_ sky130_fd_sc_hd__mux4_1
X_7454_ _3646_ VGND VGND VPWR VPWR _0152_ sky130_fd_sc_hd__clkbuf_1
XFILLER_0_114_587 VGND VGND VPWR VPWR sky130_fd_sc_hd__fill_1
X_4597_ _1153_ VGND VGND VPWR VPWR _1379_ sky130_fd_sc_hd__clkbuf_8
XFILLER_0_12_530 VGND VGND VPWR VPWR sky130_fd_sc_hd__fill_2
X_7385_ _3609_ VGND VGND VPWR VPWR _0120_ sky130_fd_sc_hd__clkbuf_1
X_6405_ registers\[3\]\[22\] _3008_ _3052_ VGND VGND VPWR VPWR _3055_ sky130_fd_sc_hd__mux2_1
XTAP_TAPCELL_ROW_116_1763 VGND VPWR sky130_fd_sc_hd__tapvpwrvgnd_1
X_9124_ clknet_leaf_28_clk _0221_ VGND VGND VPWR VPWR registers\[23\]\[4\] sky130_fd_sc_hd__dfxtp_1
XANTENNA__5155__A _1767_ VGND VGND VPWR VPWR sky130_fd_sc_hd__diode_2
X_6336_ registers\[19\]\[25\] _3014_ _3004_ VGND VGND VPWR VPWR _3015_ sky130_fd_sc_hd__mux2_1
XFILLER_0_12_541 VGND VGND VPWR VPWR sky130_fd_sc_hd__decap_3
XANTENNA__4910__A1 _1616_ VGND VGND VPWR VPWR sky130_fd_sc_hd__diode_2
XANTENNA__6685__S _3214_ VGND VGND VPWR VPWR sky130_fd_sc_hd__diode_2
XFILLER_0_12_585 VGND VGND VPWR VPWR sky130_fd_sc_hd__decap_3
X_9055_ clknet_leaf_107_clk _0152_ VGND VGND VPWR VPWR registers\[20\]\[31\] sky130_fd_sc_hd__dfxtp_1
XANTENNA__4994__A _1714_ VGND VGND VPWR VPWR sky130_fd_sc_hd__diode_2
XANTENNA__6112__B1 _2824_ VGND VGND VPWR VPWR sky130_fd_sc_hd__diode_2
X_6267_ net41 VGND VGND VPWR VPWR _2968_ sky130_fd_sc_hd__buf_2
XANTENNA__7860__A0 _3131_ VGND VGND VPWR VPWR sky130_fd_sc_hd__diode_2
XANTENNA__5010__S1 _1765_ VGND VGND VPWR VPWR sky130_fd_sc_hd__diode_2
X_5218_ _1810_ VGND VGND VPWR VPWR _1968_ sky130_fd_sc_hd__clkbuf_8
X_6198_ _2876_ _2902_ _2904_ _2905_ VGND VGND VPWR VPWR _2906_ sky130_fd_sc_hd__a22o_1
X_8006_ registers\[2\]\[2\] _3439_ _3937_ VGND VGND VPWR VPWR _3940_ sky130_fd_sc_hd__mux2_1
XANTENNA__4674__B1 _1143_ VGND VGND VPWR VPWR sky130_fd_sc_hd__diode_2
X_5149_ registers\[24\]\[14\] registers\[25\]\[14\] registers\[26\]\[14\] registers\[27\]\[14\]
+ _1748_ _1749_ VGND VGND VPWR VPWR _1903_ sky130_fd_sc_hd__mux4_1
XANTENNA__6415__A1 _3018_ VGND VGND VPWR VPWR sky130_fd_sc_hd__diode_2
XFILLER_0_79_541 VGND VGND VPWR VPWR sky130_fd_sc_hd__decap_3
XTAP_TAPCELL_ROW_67_1128 VGND VPWR sky130_fd_sc_hd__tapvpwrvgnd_1
XANTENNA__4521__S0 _1136_ VGND VGND VPWR VPWR sky130_fd_sc_hd__diode_2
XANTENNA__4977__A1 _1677_ VGND VGND VPWR VPWR sky130_fd_sc_hd__diode_2
X_8908_ clknet_leaf_43_clk _0005_ VGND VGND VPWR VPWR registers\[16\]\[12\] sky130_fd_sc_hd__dfxtp_1
XFILLER_0_94_555 VPWR VGND VPWR VGND sky130_ef_sc_hd__decap_12
XFILLER_0_94_533 VGND VGND VPWR VPWR sky130_fd_sc_hd__fill_2
X_8839_ clknet_leaf_24_clk _0960_ VGND VGND VPWR VPWR registers\[14\]\[7\] sky130_fd_sc_hd__dfxtp_1
XFILLER_0_66_235 VGND VGND VPWR VPWR sky130_fd_sc_hd__fill_1
XFILLER_0_109_337 VGND VGND VPWR VPWR sky130_fd_sc_hd__decap_4
XANTENNA__4234__A net7 VGND VGND VPWR VPWR sky130_fd_sc_hd__diode_2
XANTENNA__4824__S1 _1405_ VGND VGND VPWR VPWR sky130_fd_sc_hd__diode_2
XFILLER_0_81_249 VGND VGND VPWR VPWR sky130_fd_sc_hd__fill_2
XANTENNA__7545__A _3683_ VGND VGND VPWR VPWR sky130_fd_sc_hd__diode_2
XFILLER_0_50_614 VGND VGND VPWR VPWR sky130_fd_sc_hd__fill_2
XANTENNA__8140__S _4009_ VGND VGND VPWR VPWR sky130_fd_sc_hd__diode_2
XFILLER_0_105_565 VGND VGND VPWR VPWR sky130_fd_sc_hd__fill_1
XTAP_TAPCELL_ROW_78_1279 VGND VPWR sky130_fd_sc_hd__tapvpwrvgnd_1
XTAP_TAPCELL_ROW_78_1268 VGND VPWR sky130_fd_sc_hd__tapvpwrvgnd_1
XFILLER_0_50_669 VGND VGND VPWR VPWR sky130_fd_sc_hd__fill_2
XTAP_TAPCELL_ROW_91_1446 VGND VPWR sky130_fd_sc_hd__tapvpwrvgnd_1
XFILLER_0_100_270 VGND VGND VPWR VPWR sky130_fd_sc_hd__fill_1
XANTENNA__6103__B1 _2515_ VGND VGND VPWR VPWR sky130_fd_sc_hd__diode_2
XFILLER_0_100_281 VGND VGND VPWR VPWR sky130_fd_sc_hd__fill_2
XANTENNA__6654__A1 _3016_ VGND VGND VPWR VPWR sky130_fd_sc_hd__diode_2
XANTENNA_output135_A net135 VGND VGND VPWR VPWR sky130_fd_sc_hd__diode_2
XANTENNA__4409__A _1061_ VGND VGND VPWR VPWR sky130_fd_sc_hd__diode_2
XANTENNA__7603__A0 _3079_ VGND VGND VPWR VPWR sky130_fd_sc_hd__diode_2
XFILLER_0_82_29 VGND VGND VPWR VPWR sky130_fd_sc_hd__fill_1
XFILLER_0_89_349 VGND VGND VPWR VPWR sky130_fd_sc_hd__fill_2
XANTENNA__8159__A1 _3455_ VGND VGND VPWR VPWR sky130_fd_sc_hd__diode_2
XANTENNA__4512__S0 _1198_ VGND VGND VPWR VPWR sky130_fd_sc_hd__diode_2
XTAP_TAPCELL_ROW_46_856 VGND VPWR sky130_fd_sc_hd__tapvpwrvgnd_1
XFILLER_0_85_533 VGND VGND VPWR VPWR sky130_fd_sc_hd__fill_2
XANTENNA__5068__S1 _1764_ VGND VGND VPWR VPWR sky130_fd_sc_hd__diode_2
XFILLER_0_45_408 VGND VGND VPWR VPWR sky130_fd_sc_hd__decap_3
XTAP_TAPCELL_ROW_26_591 VGND VPWR sky130_fd_sc_hd__tapvpwrvgnd_1
XTAP_TAPCELL_ROW_100_1553 VGND VPWR sky130_fd_sc_hd__tapvpwrvgnd_1
XFILLER_0_72_205 VGND VGND VPWR VPWR sky130_fd_sc_hd__fill_1
XFILLER_0_5_505 VGND VGND VPWR VPWR sky130_fd_sc_hd__fill_2
XFILLER_0_26_611 VGND VGND VPWR VPWR sky130_fd_sc_hd__fill_2
XFILLER_0_26_622 VGND VGND VPWR VPWR sky130_fd_sc_hd__fill_2
XFILLER_0_31_33 VGND VGND VPWR VPWR sky130_fd_sc_hd__fill_2
XTAP_TAPCELL_ROW_100_1564 VGND VPWR sky130_fd_sc_hd__tapvpwrvgnd_1
XFILLER_0_72_249 VGND VGND VPWR VPWR sky130_fd_sc_hd__decap_3
XFILLER_0_53_441 VGND VGND VPWR VPWR sky130_fd_sc_hd__fill_2
XFILLER_0_25_110 VGND VGND VPWR VPWR sky130_fd_sc_hd__fill_2
X_4520_ _1153_ _1305_ VGND VGND VPWR VPWR _1306_ sky130_fd_sc_hd__nand2_1
XFILLER_0_40_102 VGND VGND VPWR VPWR sky130_fd_sc_hd__fill_1
XFILLER_0_26_699 VGND VGND VPWR VPWR sky130_fd_sc_hd__fill_1
XFILLER_0_31_99 VGND VGND VPWR VPWR sky130_fd_sc_hd__decap_3
XANTENNA__8050__S _3959_ VGND VGND VPWR VPWR sky130_fd_sc_hd__diode_2
X_4451_ registers\[24\]\[10\] registers\[25\]\[10\] registers\[26\]\[10\] registers\[27\]\[10\]
+ _1110_ _1112_ VGND VGND VPWR VPWR _1241_ sky130_fd_sc_hd__mux4_1
XFILLER_0_80_282 VGND VGND VPWR VPWR sky130_fd_sc_hd__fill_1
XANTENNA__5240__S1 _1799_ VGND VGND VPWR VPWR sky130_fd_sc_hd__diode_2
XFILLER_0_40_146 VGND VGND VPWR VPWR sky130_fd_sc_hd__fill_2
X_7170_ registers\[16\]\[28\] _3493_ _3477_ VGND VGND VPWR VPWR _3494_ sky130_fd_sc_hd__mux2_1
X_4382_ registers\[12\]\[6\] registers\[13\]\[6\] registers\[14\]\[6\] registers\[15\]\[6\]
+ _1126_ _1161_ VGND VGND VPWR VPWR _1176_ sky130_fd_sc_hd__mux4_1
X_6121_ _2742_ _2773_ VGND VGND VPWR VPWR _2833_ sky130_fd_sc_hd__or2_1
X_6052_ _2637_ _2692_ _2767_ _2472_ VGND VGND VPWR VPWR _2768_ sky130_fd_sc_hd__a22o_1
XPHY_EDGE_ROW_7_Right_7 VGND VGND VPWR VPWR sky130_fd_sc_hd__decap_3
X_5003_ _1764_ VGND VGND VPWR VPWR _1765_ sky130_fd_sc_hd__clkbuf_8
XANTENNA__4751__S0 _1390_ VGND VGND VPWR VPWR sky130_fd_sc_hd__diode_2
XANTENNA__8398__A1 _3491_ VGND VGND VPWR VPWR sky130_fd_sc_hd__diode_2
XANTENNA__4503__S0 _1167_ VGND VGND VPWR VPWR sky130_fd_sc_hd__diode_2
X_6954_ _3077_ registers\[14\]\[4\] _3361_ VGND VGND VPWR VPWR _3366_ sky130_fd_sc_hd__mux2_1
XFILLER_0_49_703 VGND VGND VPWR VPWR sky130_fd_sc_hd__decap_8
XFILLER_0_48_202 VGND VGND VPWR VPWR sky130_fd_sc_hd__decap_3
XANTENNA__4753__S _1346_ VGND VGND VPWR VPWR sky130_fd_sc_hd__diode_2
XFILLER_0_119_613 VGND VGND VPWR VPWR sky130_fd_sc_hd__decap_3
XFILLER_0_76_533 VGND VGND VPWR VPWR sky130_fd_sc_hd__fill_2
X_5905_ net83 _2611_ VGND VGND VPWR VPWR _2629_ sky130_fd_sc_hd__and2_1
X_6885_ _3077_ registers\[13\]\[4\] _3324_ VGND VGND VPWR VPWR _3329_ sky130_fd_sc_hd__mux2_1
XFILLER_0_91_503 VGND VGND VPWR VPWR sky130_fd_sc_hd__fill_1
X_8624_ clknet_leaf_61_clk _0745_ VGND VGND VPWR VPWR registers\[29\]\[16\] sky130_fd_sc_hd__dfxtp_1
XFILLER_0_48_257 VGND VGND VPWR VPWR sky130_fd_sc_hd__fill_1
XFILLER_0_119_657 VPWR VGND VPWR VGND sky130_ef_sc_hd__decap_12
X_5836_ net135 _2470_ VGND VGND VPWR VPWR _2564_ sky130_fd_sc_hd__and2_1
XFILLER_0_91_536 VGND VGND VPWR VPWR sky130_fd_sc_hd__fill_2
XFILLER_0_76_599 VGND VGND VPWR VPWR sky130_fd_sc_hd__fill_2
XFILLER_0_63_238 VGND VGND VPWR VPWR sky130_fd_sc_hd__fill_1
XTAP_TAPCELL_ROW_62_1069 VGND VPWR sky130_fd_sc_hd__tapvpwrvgnd_1
XFILLER_0_17_611 VGND VGND VPWR VPWR sky130_fd_sc_hd__fill_2
XFILLER_0_118_178 VGND VGND VPWR VPWR sky130_fd_sc_hd__fill_2
X_8555_ clknet_leaf_58_clk _0676_ VGND VGND VPWR VPWR registers\[19\]\[11\] sky130_fd_sc_hd__dfxtp_1
XFILLER_0_106_318 VGND VGND VPWR VPWR sky130_fd_sc_hd__fill_2
XFILLER_0_106_307 VGND VGND VPWR VPWR sky130_fd_sc_hd__fill_1
X_5767_ _2445_ _2322_ VGND VGND VPWR VPWR _2498_ sky130_fd_sc_hd__nand2_2
XFILLER_0_44_430 VGND VGND VPWR VPWR sky130_fd_sc_hd__fill_2
XFILLER_0_8_365 VGND VGND VPWR VPWR sky130_fd_sc_hd__fill_1
X_8486_ registers\[4\]\[4\] net42 _4189_ VGND VGND VPWR VPWR _4194_ sky130_fd_sc_hd__mux2_1
X_5698_ _1107_ _2430_ VGND VGND VPWR VPWR _2431_ sky130_fd_sc_hd__xnor2_1
XFILLER_0_44_452 VGND VGND VPWR VPWR sky130_fd_sc_hd__fill_2
X_4718_ _1492_ _1493_ _1346_ VGND VGND VPWR VPWR _1494_ sky130_fd_sc_hd__mux2_1
X_7506_ _3674_ VGND VGND VPWR VPWR _0176_ sky130_fd_sc_hd__clkbuf_1
X_4649_ registers\[8\]\[20\] registers\[9\]\[20\] registers\[10\]\[20\] registers\[11\]\[20\]
+ _1427_ _1428_ VGND VGND VPWR VPWR _1429_ sky130_fd_sc_hd__mux4_1
XFILLER_0_31_113 VGND VGND VPWR VPWR sky130_fd_sc_hd__fill_2
X_7437_ registers\[20\]\[23\] _3483_ _3634_ VGND VGND VPWR VPWR _3638_ sky130_fd_sc_hd__mux2_1
XANTENNA__5231__S1 _1720_ VGND VGND VPWR VPWR sky130_fd_sc_hd__diode_2
XFILLER_0_4_571 VGND VGND VPWR VPWR sky130_fd_sc_hd__fill_2
XFILLER_0_31_157 VGND VGND VPWR VPWR sky130_fd_sc_hd__fill_2
XANTENNA__8086__A0 _2978_ VGND VGND VPWR VPWR sky130_fd_sc_hd__diode_2
X_7368_ registers\[1\]\[23\] _3483_ _3597_ VGND VGND VPWR VPWR _3601_ sky130_fd_sc_hd__mux2_1
X_9107_ clknet_leaf_45_clk _0204_ VGND VGND VPWR VPWR registers\[22\]\[19\] sky130_fd_sc_hd__dfxtp_1
X_7299_ _3564_ VGND VGND VPWR VPWR _0079_ sky130_fd_sc_hd__clkbuf_1
XFILLER_0_6_7 VGND VGND VPWR VPWR sky130_fd_sc_hd__fill_2
XANTENNA__7304__S _3561_ VGND VGND VPWR VPWR sky130_fd_sc_hd__diode_2
X_6319_ net28 VGND VGND VPWR VPWR _3003_ sky130_fd_sc_hd__buf_2
XANTENNA__7833__A0 _3104_ VGND VGND VPWR VPWR sky130_fd_sc_hd__diode_2
X_9038_ clknet_leaf_53_clk _0135_ VGND VGND VPWR VPWR registers\[20\]\[14\] sky130_fd_sc_hd__dfxtp_1
XFILLER_0_99_658 VGND VGND VPWR VPWR sky130_fd_sc_hd__decap_3
XANTENNA__5298__S1 _1764_ VGND VGND VPWR VPWR sky130_fd_sc_hd__diode_2
XFILLER_0_79_393 VGND VGND VPWR VPWR sky130_fd_sc_hd__decap_3
XFILLER_0_67_522 VGND VGND VPWR VPWR sky130_fd_sc_hd__fill_2
XTAP_TAPCELL_ROW_43_815 VGND VPWR sky130_fd_sc_hd__tapvpwrvgnd_1
XFILLER_0_39_235 VGND VGND VPWR VPWR sky130_fd_sc_hd__decap_4
XFILLER_0_109_101 VGND VGND VPWR VPWR sky130_fd_sc_hd__fill_2
XFILLER_0_94_341 VGND VGND VPWR VPWR sky130_fd_sc_hd__fill_2
XFILLER_0_67_555 VGND VGND VPWR VPWR sky130_fd_sc_hd__fill_2
XFILLER_0_94_374 VGND VGND VPWR VPWR sky130_fd_sc_hd__fill_2
XFILLER_0_67_599 VGND VGND VPWR VPWR sky130_fd_sc_hd__decap_4
XFILLER_0_82_547 VGND VGND VPWR VPWR sky130_fd_sc_hd__fill_1
XTAP_TAPCELL_ROW_23_561 VGND VPWR sky130_fd_sc_hd__tapvpwrvgnd_1
XANTENNA__5375__B2 _2026_ VGND VGND VPWR VPWR sky130_fd_sc_hd__diode_2
XFILLER_0_35_441 VGND VGND VPWR VPWR sky130_fd_sc_hd__fill_2
XANTENNA__4583__C1 _1153_ VGND VGND VPWR VPWR sky130_fd_sc_hd__diode_2
XFILLER_0_50_400 VGND VGND VPWR VPWR sky130_fd_sc_hd__fill_1
XFILLER_0_105_384 VGND VGND VPWR VPWR sky130_fd_sc_hd__fill_1
XANTENNA__6627__A1 _2989_ VGND VGND VPWR VPWR sky130_fd_sc_hd__diode_2
XANTENNA__5523__A _2182_ VGND VGND VPWR VPWR sky130_fd_sc_hd__diode_2
XFILLER_0_93_28 VGND VGND VPWR VPWR sky130_fd_sc_hd__decap_4
XFILLER_0_89_113 VGND VGND VPWR VPWR sky130_fd_sc_hd__decap_4
XANTENNA__4733__S0 _1415_ VGND VGND VPWR VPWR sky130_fd_sc_hd__diode_2
XFILLER_0_117_57 VPWR VGND VPWR VGND sky130_ef_sc_hd__decap_12
XANTENNA__5289__S1 _1811_ VGND VGND VPWR VPWR sky130_fd_sc_hd__diode_2
XFILLER_0_98_691 VGND VGND VPWR VPWR sky130_fd_sc_hd__fill_2
XFILLER_0_58_533 VGND VGND VPWR VPWR sky130_fd_sc_hd__fill_2
XFILLER_0_85_363 VGND VGND VPWR VPWR sky130_fd_sc_hd__fill_2
XFILLER_0_85_341 VGND VGND VPWR VPWR sky130_fd_sc_hd__fill_1
XFILLER_0_58_566 VGND VGND VPWR VPWR sky130_fd_sc_hd__fill_1
XANTENNA__7884__S _3865_ VGND VGND VPWR VPWR sky130_fd_sc_hd__diode_2
XFILLER_0_42_32 VGND VGND VPWR VPWR sky130_fd_sc_hd__decap_4
X_6670_ _3213_ VGND VGND VPWR VPWR _3214_ sky130_fd_sc_hd__clkbuf_8
XFILLER_0_18_419 VGND VGND VPWR VPWR sky130_fd_sc_hd__fill_1
X_5621_ _2253_ _2311_ VGND VGND VPWR VPWR _2356_ sky130_fd_sc_hd__nand2_1
XFILLER_0_73_558 VGND VGND VPWR VPWR sky130_fd_sc_hd__fill_2
XFILLER_0_61_709 VGND VGND VPWR VPWR sky130_fd_sc_hd__fill_1
XFILLER_0_5_302 VGND VGND VPWR VPWR sky130_fd_sc_hd__fill_1
XFILLER_0_115_137 VGND VGND VPWR VPWR sky130_fd_sc_hd__fill_2
X_5552_ _1866_ _2215_ _1051_ VGND VGND VPWR VPWR _2288_ sky130_fd_sc_hd__o21ai_1
XFILLER_0_60_219 VGND VGND VPWR VPWR sky130_fd_sc_hd__decap_4
XFILLER_0_60_208 VGND VGND VPWR VPWR sky130_fd_sc_hd__fill_2
XFILLER_0_53_260 VGND VGND VPWR VPWR sky130_fd_sc_hd__fill_2
X_8340_ _3501_ _3135_ VGND VGND VPWR VPWR _4116_ sky130_fd_sc_hd__nor2_2
XFILLER_0_26_463 VGND VGND VPWR VPWR sky130_fd_sc_hd__fill_2
X_4503_ registers\[28\]\[13\] registers\[29\]\[13\] registers\[30\]\[13\] registers\[31\]\[13\]
+ _1167_ _1168_ VGND VGND VPWR VPWR _1290_ sky130_fd_sc_hd__mux4_1
XFILLER_0_84_7 VGND VGND VPWR VPWR sky130_fd_sc_hd__fill_1
XFILLER_0_81_591 VGND VGND VPWR VPWR sky130_fd_sc_hd__decap_6
X_8271_ _4079_ VGND VGND VPWR VPWR _0536_ sky130_fd_sc_hd__clkbuf_1
XANTENNA_clkbuf_leaf_83_clk_A clknet_4_10_0_clk VGND VGND VPWR VPWR sky130_fd_sc_hd__diode_2
X_5483_ _1049_ VGND VGND VPWR VPWR _2219_ sky130_fd_sc_hd__clkbuf_2
XFILLER_0_41_466 VPWR VGND VPWR VGND sky130_ef_sc_hd__decap_12
XTAP_TAPCELL_ROW_113_1733 VGND VPWR sky130_fd_sc_hd__tapvpwrvgnd_1
XTAP_TAPCELL_ROW_113_1722 VGND VPWR sky130_fd_sc_hd__tapvpwrvgnd_1
XFILLER_0_111_343 VGND VGND VPWR VPWR sky130_fd_sc_hd__decap_3
X_7222_ _3523_ VGND VGND VPWR VPWR _0043_ sky130_fd_sc_hd__clkbuf_1
X_4434_ registers\[20\]\[9\] registers\[21\]\[9\] registers\[22\]\[9\] registers\[23\]\[9\]
+ _1053_ _1054_ VGND VGND VPWR VPWR _1225_ sky130_fd_sc_hd__mux4_1
XFILLER_0_41_499 VGND VGND VPWR VPWR sky130_fd_sc_hd__fill_1
X_4365_ _1125_ VGND VGND VPWR VPWR _1160_ sky130_fd_sc_hd__clkbuf_8
X_7153_ _3482_ VGND VGND VPWR VPWR _0015_ sky130_fd_sc_hd__clkbuf_1
XFILLER_0_21_190 VGND VGND VPWR VPWR sky130_fd_sc_hd__fill_2
XANTENNA_clkbuf_leaf_98_clk_A clknet_4_9_0_clk VGND VGND VPWR VPWR sky130_fd_sc_hd__diode_2
XANTENNA__7124__S _3456_ VGND VGND VPWR VPWR sky130_fd_sc_hd__diode_2
XANTENNA__6618__A1 _2980_ VGND VGND VPWR VPWR sky130_fd_sc_hd__diode_2
X_6104_ net127 _2515_ VGND VGND VPWR VPWR _2817_ sky130_fd_sc_hd__and2_1
XFILLER_0_6_98 VGND VGND VPWR VPWR sky130_fd_sc_hd__decap_4
X_7084_ registers\[16\]\[0\] _3433_ _3435_ VGND VGND VPWR VPWR _3436_ sky130_fd_sc_hd__mux2_1
X_4296_ _1091_ _1092_ _1030_ VGND VGND VPWR VPWR _1093_ sky130_fd_sc_hd__mux2_1
X_6035_ net91 _2751_ VGND VGND VPWR VPWR _2752_ sky130_fd_sc_hd__xnor2_1
XANTENNA_clkbuf_leaf_21_clk_A clknet_4_1_0_clk VGND VGND VPWR VPWR sky130_fd_sc_hd__diode_2
XFILLER_0_83_61 VGND VGND VPWR VPWR sky130_fd_sc_hd__fill_2
XFILLER_0_83_94 VGND VGND VPWR VPWR sky130_fd_sc_hd__fill_2
XTAP_TAPCELL_ROW_1_267 VGND VPWR sky130_fd_sc_hd__tapvpwrvgnd_1
XANTENNA__6264__A net38 VGND VGND VPWR VPWR sky130_fd_sc_hd__diode_2
XANTENNA__6251__C1 _2560_ VGND VGND VPWR VPWR sky130_fd_sc_hd__diode_2
X_7986_ _3014_ registers\[28\]\[25\] _3923_ VGND VGND VPWR VPWR _3929_ sky130_fd_sc_hd__mux2_1
XTAP_TAPCELL_ROW_1_278 VGND VPWR sky130_fd_sc_hd__tapvpwrvgnd_1
XFILLER_0_119_421 VGND VGND VPWR VPWR sky130_fd_sc_hd__decap_8
XANTENNA_clkbuf_leaf_36_clk_A clknet_4_7_0_clk VGND VGND VPWR VPWR sky130_fd_sc_hd__diode_2
X_6937_ _3129_ registers\[13\]\[29\] _3346_ VGND VGND VPWR VPWR _3356_ sky130_fd_sc_hd__mux2_1
XANTENNA__7794__S _3792_ VGND VGND VPWR VPWR sky130_fd_sc_hd__diode_2
XFILLER_0_91_311 VGND VGND VPWR VPWR sky130_fd_sc_hd__fill_2
XFILLER_0_76_396 VGND VGND VPWR VPWR sky130_fd_sc_hd__decap_4
XFILLER_0_76_374 VGND VGND VPWR VPWR sky130_fd_sc_hd__fill_1
XFILLER_0_76_363 VGND VGND VPWR VPWR sky130_fd_sc_hd__fill_1
X_6868_ _3319_ VGND VGND VPWR VPWR _0917_ sky130_fd_sc_hd__clkbuf_1
XFILLER_0_9_630 VGND VGND VPWR VPWR sky130_fd_sc_hd__fill_1
XFILLER_0_107_627 VGND VGND VPWR VPWR sky130_fd_sc_hd__decap_6
X_5819_ _2208_ _2483_ _2514_ _2484_ VGND VGND VPWR VPWR _2547_ sky130_fd_sc_hd__o31a_1
XANTENNA__5357__A1 _2026_ VGND VGND VPWR VPWR sky130_fd_sc_hd__diode_2
X_8607_ clknet_leaf_98_clk _0728_ VGND VGND VPWR VPWR registers\[3\]\[31\] sky130_fd_sc_hd__dfxtp_1
XFILLER_0_106_137 VGND VGND VPWR VPWR sky130_fd_sc_hd__decap_3
X_6799_ registers\[11\]\[29\] _3022_ _3272_ VGND VGND VPWR VPWR _3282_ sky130_fd_sc_hd__mux2_1
X_8538_ registers\[4\]\[29\] net37 _4211_ VGND VGND VPWR VPWR _4221_ sky130_fd_sc_hd__mux2_1
XFILLER_0_17_452 VGND VGND VPWR VPWR sky130_fd_sc_hd__fill_2
XTAP_TAPCELL_ROW_20_520 VGND VPWR sky130_fd_sc_hd__tapvpwrvgnd_1
XFILLER_0_106_159 VGND VGND VPWR VPWR sky130_fd_sc_hd__fill_2
XFILLER_0_17_496 VGND VGND VPWR VPWR sky130_fd_sc_hd__decap_3
X_8469_ _4184_ VGND VGND VPWR VPWR _0629_ sky130_fd_sc_hd__clkbuf_1
XFILLER_0_114_192 VGND VGND VPWR VPWR sky130_fd_sc_hd__fill_1
XTAP_TAPCELL_ROW_75_1238 VGND VPWR sky130_fd_sc_hd__tapvpwrvgnd_1
XANTENNA__5204__S1 _1821_ VGND VGND VPWR VPWR sky130_fd_sc_hd__diode_2
XFILLER_0_32_477 VGND VGND VPWR VPWR sky130_fd_sc_hd__fill_2
XANTENNA__4963__S0 _1719_ VGND VGND VPWR VPWR sky130_fd_sc_hd__diode_2
XANTENNA_clkbuf_leaf_109_clk_A clknet_4_0_0_clk VGND VGND VPWR VPWR sky130_fd_sc_hd__diode_2
XTAP_TAPCELL_ROW_9_378 VGND VPWR sky130_fd_sc_hd__tapvpwrvgnd_1
XANTENNA__7969__S _3912_ VGND VGND VPWR VPWR sky130_fd_sc_hd__diode_2
XANTENNA__6873__S _3287_ VGND VGND VPWR VPWR sky130_fd_sc_hd__diode_2
XFILLER_0_99_477 VGND VGND VPWR VPWR sky130_fd_sc_hd__fill_2
XFILLER_0_87_606 VGND VGND VPWR VPWR sky130_fd_sc_hd__fill_2
XANTENNA__6174__A _2136_ VGND VGND VPWR VPWR sky130_fd_sc_hd__diode_2
XANTENNA_input11_A a3[2] VGND VGND VPWR VPWR sky130_fd_sc_hd__diode_2
XTAP_TAPCELL_ROW_28_620 VGND VPWR sky130_fd_sc_hd__tapvpwrvgnd_1
XTAP_TAPCELL_ROW_86_1378 VGND VPWR sky130_fd_sc_hd__tapvpwrvgnd_1
XTAP_TAPCELL_ROW_56_984 VGND VPWR sky130_fd_sc_hd__tapvpwrvgnd_1
XANTENNA__5140__S0 _1748_ VGND VGND VPWR VPWR sky130_fd_sc_hd__diode_2
XANTENNA__5596__A1 _1899_ VGND VGND VPWR VPWR sky130_fd_sc_hd__diode_2
XFILLER_0_82_300 VGND VGND VPWR VPWR sky130_fd_sc_hd__decap_4
XANTENNA__8534__A1 net35 VGND VGND VPWR VPWR sky130_fd_sc_hd__diode_2
XFILLER_0_27_216 VGND VGND VPWR VPWR sky130_fd_sc_hd__fill_2
XFILLER_0_94_193 VGND VGND VPWR VPWR sky130_fd_sc_hd__decap_3
XFILLER_0_82_344 VGND VGND VPWR VPWR sky130_fd_sc_hd__decap_4
XFILLER_0_12_13 VGND VGND VPWR VPWR sky130_fd_sc_hd__fill_2
XANTENNA__7209__S _3514_ VGND VGND VPWR VPWR sky130_fd_sc_hd__diode_2
XANTENNA__5518__A _2168_ VGND VGND VPWR VPWR sky130_fd_sc_hd__diode_2
XFILLER_0_82_399 VGND VGND VPWR VPWR sky130_fd_sc_hd__fill_2
XFILLER_0_2_305 VGND VGND VPWR VPWR sky130_fd_sc_hd__fill_1
XANTENNA__4308__C1 net8 VGND VGND VPWR VPWR sky130_fd_sc_hd__diode_2
Xoutput119 net119 VGND VGND VPWR VPWR rd2[15] sky130_fd_sc_hd__buf_1
Xoutput108 net108 VGND VGND VPWR VPWR rd1[5] sky130_fd_sc_hd__buf_1
XFILLER_0_11_617 VGND VGND VPWR VPWR sky130_fd_sc_hd__fill_2
XANTENNA__7273__A1 _3455_ VGND VGND VPWR VPWR sky130_fd_sc_hd__diode_2
Xoutput90 net90 VGND VGND VPWR VPWR rd1[18] sky130_fd_sc_hd__buf_1
XANTENNA__6783__S _3272_ VGND VGND VPWR VPWR sky130_fd_sc_hd__diode_2
XANTENNA__6084__A _2362_ VGND VGND VPWR VPWR sky130_fd_sc_hd__diode_2
XFILLER_0_78_628 VGND VGND VPWR VPWR sky130_fd_sc_hd__fill_1
XANTENNA__5399__S _2031_ VGND VGND VPWR VPWR sky130_fd_sc_hd__diode_2
X_7840_ _3110_ registers\[26\]\[20\] _3851_ VGND VGND VPWR VPWR _3852_ sky130_fd_sc_hd__mux2_1
X_4983_ registers\[16\]\[6\] registers\[17\]\[6\] registers\[18\]\[6\] registers\[19\]\[6\]
+ _1742_ _1743_ VGND VGND VPWR VPWR _1745_ sky130_fd_sc_hd__mux4_1
X_7771_ _3792_ VGND VGND VPWR VPWR _3815_ sky130_fd_sc_hd__clkbuf_8
X_9510_ clknet_leaf_32_clk _0607_ VGND VGND VPWR VPWR registers\[8\]\[6\] sky130_fd_sc_hd__dfxtp_1
XANTENNA__8503__S _4200_ VGND VGND VPWR VPWR sky130_fd_sc_hd__diode_2
X_6722_ _3241_ VGND VGND VPWR VPWR _0849_ sky130_fd_sc_hd__clkbuf_1
XFILLER_0_73_344 VGND VGND VPWR VPWR sky130_fd_sc_hd__fill_2
XFILLER_0_73_322 VGND VGND VPWR VPWR sky130_fd_sc_hd__decap_4
XANTENNA__5339__A1 _2019_ VGND VGND VPWR VPWR sky130_fd_sc_hd__diode_2
X_9441_ clknet_leaf_110_clk _0538_ VGND VGND VPWR VPWR registers\[31\]\[1\] sky130_fd_sc_hd__dfxtp_1
X_6653_ _3203_ VGND VGND VPWR VPWR _0818_ sky130_fd_sc_hd__clkbuf_1
XFILLER_0_116_446 VGND VGND VPWR VPWR sky130_fd_sc_hd__fill_1
XANTENNA__4332__A _1127_ VGND VGND VPWR VPWR sky130_fd_sc_hd__diode_2
X_5604_ _2337_ _2338_ VGND VGND VPWR VPWR _2339_ sky130_fd_sc_hd__nand2_1
XFILLER_0_73_388 VGND VGND VPWR VPWR sky130_fd_sc_hd__fill_2
XANTENNA__5434__S1 _1997_ VGND VGND VPWR VPWR sky130_fd_sc_hd__diode_2
XFILLER_0_104_619 VGND VGND VPWR VPWR sky130_fd_sc_hd__fill_1
X_9372_ clknet_leaf_88_clk _0469_ VGND VGND VPWR VPWR registers\[30\]\[28\] sky130_fd_sc_hd__dfxtp_1
XFILLER_0_5_154 VGND VGND VPWR VPWR sky130_fd_sc_hd__fill_1
XFILLER_0_5_143 VGND VGND VPWR VPWR sky130_fd_sc_hd__decap_4
X_6584_ registers\[7\]\[26\] _3016_ _3159_ VGND VGND VPWR VPWR _3166_ sky130_fd_sc_hd__mux2_1
XANTENNA__6958__S _3361_ VGND VGND VPWR VPWR sky130_fd_sc_hd__diode_2
XFILLER_0_103_118 VGND VGND VPWR VPWR sky130_fd_sc_hd__fill_2
X_5535_ net14 _2198_ VGND VGND VPWR VPWR _2271_ sky130_fd_sc_hd__nor2_2
XFILLER_0_41_230 VGND VGND VPWR VPWR sky130_fd_sc_hd__fill_2
X_8323_ _4107_ VGND VGND VPWR VPWR _0560_ sky130_fd_sc_hd__clkbuf_1
XFILLER_0_14_466 VGND VGND VPWR VPWR sky130_fd_sc_hd__fill_2
X_5466_ _2201_ VGND VGND VPWR VPWR _2202_ sky130_fd_sc_hd__inv_2
XFILLER_0_41_285 VGND VGND VPWR VPWR sky130_fd_sc_hd__fill_2
XFILLER_0_41_274 VGND VGND VPWR VPWR sky130_fd_sc_hd__fill_2
X_8254_ registers\[6\]\[23\] _3483_ _4067_ VGND VGND VPWR VPWR _4071_ sky130_fd_sc_hd__mux2_1
XFILLER_0_14_477 VGND VGND VPWR VPWR sky130_fd_sc_hd__fill_2
XFILLER_0_112_674 VGND VGND VPWR VPWR sky130_fd_sc_hd__decap_6
X_7205_ registers\[17\]\[10\] _3455_ _3514_ VGND VGND VPWR VPWR _3515_ sky130_fd_sc_hd__mux2_1
XFILLER_0_78_94 VGND VGND VPWR VPWR sky130_fd_sc_hd__fill_2
XFILLER_0_78_72 VGND VGND VPWR VPWR sky130_fd_sc_hd__decap_4
X_4417_ registers\[24\]\[8\] registers\[25\]\[8\] registers\[26\]\[8\] registers\[27\]\[8\]
+ _1196_ _1202_ VGND VGND VPWR VPWR _1209_ sky130_fd_sc_hd__mux4_1
X_8185_ _4034_ VGND VGND VPWR VPWR _0495_ sky130_fd_sc_hd__clkbuf_1
X_5397_ registers\[20\]\[28\] registers\[21\]\[28\] registers\[22\]\[28\] registers\[23\]\[28\]
+ _2097_ _2109_ VGND VGND VPWR VPWR _2137_ sky130_fd_sc_hd__mux4_1
XFILLER_0_1_393 VGND VGND VPWR VPWR sky130_fd_sc_hd__decap_3
X_7136_ registers\[16\]\[17\] _3470_ _3456_ VGND VGND VPWR VPWR _3471_ sky130_fd_sc_hd__mux2_1
X_4348_ _1135_ _1141_ _1143_ VGND VGND VPWR VPWR _1144_ sky130_fd_sc_hd__a21oi_1
XTAP_TAPCELL_ROW_6_337 VGND VPWR sky130_fd_sc_hd__tapvpwrvgnd_1
XANTENNA_input3_A a1[2] VGND VGND VPWR VPWR sky130_fd_sc_hd__diode_2
XANTENNA__7264__A1 _3447_ VGND VGND VPWR VPWR sky130_fd_sc_hd__diode_2
XTAP_TAPCELL_ROW_70_1168 VGND VPWR sky130_fd_sc_hd__tapvpwrvgnd_1
X_7067_ _3121_ registers\[15\]\[25\] _3420_ VGND VGND VPWR VPWR _3426_ sky130_fd_sc_hd__mux2_1
X_4279_ registers\[28\]\[2\] registers\[29\]\[2\] registers\[30\]\[2\] registers\[31\]\[2\]
+ _1039_ _1040_ VGND VGND VPWR VPWR _1077_ sky130_fd_sc_hd__mux4_1
X_6018_ _2272_ _2419_ _2560_ VGND VGND VPWR VPWR _2736_ sky130_fd_sc_hd__o21a_1
XANTENNA__5370__S0 _2097_ VGND VGND VPWR VPWR sky130_fd_sc_hd__diode_2
X_7969_ _2997_ registers\[28\]\[17\] _3912_ VGND VGND VPWR VPWR _3920_ sky130_fd_sc_hd__mux2_1
XTAP_TAPCELL_ROW_53_943 VGND VPWR sky130_fd_sc_hd__tapvpwrvgnd_1
XFILLER_0_64_300 VGND VGND VPWR VPWR sky130_fd_sc_hd__decap_8
XTAP_TAPCELL_ROW_53_954 VGND VPWR sky130_fd_sc_hd__tapvpwrvgnd_1
XANTENNA__7818__A _3828_ VGND VGND VPWR VPWR sky130_fd_sc_hd__diode_2
XFILLER_0_119_240 VPWR VGND VPWR VGND sky130_ef_sc_hd__decap_12
XFILLER_0_76_193 VGND VGND VPWR VPWR sky130_fd_sc_hd__decap_3
XFILLER_0_119_273 VGND VGND VPWR VPWR sky130_fd_sc_hd__fill_1
XANTENNA__7029__S _3398_ VGND VGND VPWR VPWR sky130_fd_sc_hd__diode_2
XANTENNA__5425__S1 _2127_ VGND VGND VPWR VPWR sky130_fd_sc_hd__diode_2
XFILLER_0_107_457 VGND VGND VPWR VPWR sky130_fd_sc_hd__fill_1
XANTENNA__4242__A _1031_ VGND VGND VPWR VPWR sky130_fd_sc_hd__diode_2
XFILLER_0_17_260 VGND VGND VPWR VPWR sky130_fd_sc_hd__fill_2
XANTENNA__4388__S _1148_ VGND VGND VPWR VPWR sky130_fd_sc_hd__diode_2
XANTENNA__7699__S _3768_ VGND VGND VPWR VPWR sky130_fd_sc_hd__diode_2
XTAP_TAPCELL_ROW_88_1407 VGND VPWR sky130_fd_sc_hd__tapvpwrvgnd_1
XANTENNA__5801__A net110 VGND VGND VPWR VPWR sky130_fd_sc_hd__diode_2
XFILLER_0_87_403 VGND VGND VPWR VPWR sky130_fd_sc_hd__fill_1
XANTENNA__5361__S0 _1996_ VGND VGND VPWR VPWR sky130_fd_sc_hd__diode_2
XFILLER_0_87_436 VGND VGND VPWR VPWR sky130_fd_sc_hd__decap_4
XFILLER_0_90_29 VGND VGND VPWR VPWR sky130_fd_sc_hd__decap_4
XFILLER_0_87_458 VGND VGND VPWR VPWR sky130_fd_sc_hd__decap_3
XANTENNA__5947__S _2460_ VGND VGND VPWR VPWR sky130_fd_sc_hd__diode_2
XFILLER_0_68_672 VGND VGND VPWR VPWR sky130_fd_sc_hd__decap_3
XFILLER_0_23_34 VGND VGND VPWR VPWR sky130_fd_sc_hd__fill_1
XFILLER_0_28_525 VGND VGND VPWR VPWR sky130_fd_sc_hd__fill_2
XANTENNA__8507__A1 net21 VGND VGND VPWR VPWR sky130_fd_sc_hd__diode_2
XFILLER_0_82_163 VGND VGND VPWR VPWR sky130_fd_sc_hd__fill_2
XFILLER_0_55_366 VGND VGND VPWR VPWR sky130_fd_sc_hd__fill_2
XANTENNA__5248__A _1773_ VGND VGND VPWR VPWR sky130_fd_sc_hd__diode_2
XTAP_TAPCELL_ROW_31_659 VGND VPWR sky130_fd_sc_hd__tapvpwrvgnd_1
XTAP_TAPCELL_ROW_99_1547 VGND VPWR sky130_fd_sc_hd__tapvpwrvgnd_1
XFILLER_0_99_49 VGND VGND VPWR VPWR sky130_fd_sc_hd__fill_2
XANTENNA__6778__S _3261_ VGND VGND VPWR VPWR sky130_fd_sc_hd__diode_2
XFILLER_0_23_230 VGND VGND VPWR VPWR sky130_fd_sc_hd__decap_3
XFILLER_0_113_449 VGND VGND VPWR VPWR sky130_fd_sc_hd__fill_2
XFILLER_0_106_490 VGND VGND VPWR VPWR sky130_fd_sc_hd__fill_2
XFILLER_0_51_561 VGND VGND VPWR VPWR sky130_fd_sc_hd__fill_1
X_5320_ _2064_ VGND VGND VPWR VPWR net96 sky130_fd_sc_hd__buf_2
XFILLER_0_23_252 VGND VGND VPWR VPWR sky130_fd_sc_hd__fill_2
XFILLER_0_11_425 VGND VGND VPWR VPWR sky130_fd_sc_hd__fill_1
XFILLER_0_23_285 VGND VGND VPWR VPWR sky130_fd_sc_hd__decap_4
X_5251_ registers\[28\]\[20\] registers\[29\]\[20\] registers\[30\]\[20\] registers\[31\]\[20\]
+ _1996_ _1997_ VGND VGND VPWR VPWR _1999_ sky130_fd_sc_hd__mux4_1
XFILLER_0_48_42 VGND VGND VPWR VPWR sky130_fd_sc_hd__fill_2
X_5182_ _1930_ _1931_ _1932_ _1933_ _1809_ _1701_ VGND VGND VPWR VPWR _1934_ sky130_fd_sc_hd__mux4_2
XANTENNA__8294__A _4080_ VGND VGND VPWR VPWR sky130_fd_sc_hd__diode_2
XFILLER_0_48_97 VGND VGND VPWR VPWR sky130_fd_sc_hd__fill_2
X_8941_ clknet_leaf_58_clk _0038_ VGND VGND VPWR VPWR registers\[17\]\[13\] sky130_fd_sc_hd__dfxtp_1
XFILLER_0_3_44 VGND VGND VPWR VPWR sky130_fd_sc_hd__fill_2
XFILLER_0_3_22 VGND VGND VPWR VPWR sky130_fd_sc_hd__fill_2
XFILLER_0_78_403 VGND VGND VPWR VPWR sky130_fd_sc_hd__fill_2
XANTENNA__5352__S0 _2020_ VGND VGND VPWR VPWR sky130_fd_sc_hd__diode_2
XTAP_TAPCELL_ROW_108_1665 VGND VPWR sky130_fd_sc_hd__tapvpwrvgnd_1
XANTENNA__4480__B2 _1025_ VGND VGND VPWR VPWR sky130_fd_sc_hd__diode_2
X_8872_ clknet_leaf_18_clk _0993_ VGND VGND VPWR VPWR registers\[15\]\[8\] sky130_fd_sc_hd__dfxtp_1
X_7823_ _3094_ registers\[26\]\[12\] _3840_ VGND VGND VPWR VPWR _3843_ sky130_fd_sc_hd__mux2_1
X_7754_ _3806_ VGND VGND VPWR VPWR _0292_ sky130_fd_sc_hd__clkbuf_1
XANTENNA__8233__S _4056_ VGND VGND VPWR VPWR sky130_fd_sc_hd__diode_2
XFILLER_0_65_108 VGND VGND VPWR VPWR sky130_fd_sc_hd__fill_2
X_4966_ registers\[20\]\[5\] registers\[21\]\[5\] registers\[22\]\[5\] registers\[23\]\[5\]
+ _1719_ _1720_ VGND VGND VPWR VPWR _1729_ sky130_fd_sc_hd__mux4_1
X_6705_ _3232_ VGND VGND VPWR VPWR _0841_ sky130_fd_sc_hd__clkbuf_1
XFILLER_0_74_620 VGND VGND VPWR VPWR sky130_fd_sc_hd__fill_2
XTAP_TAPCELL_ROW_50_913 VGND VPWR sky130_fd_sc_hd__tapvpwrvgnd_1
XFILLER_0_19_525 VGND VGND VPWR VPWR sky130_fd_sc_hd__fill_2
XFILLER_0_116_221 VGND VGND VPWR VPWR sky130_fd_sc_hd__fill_2
X_7685_ registers\[24\]\[11\] _3458_ _3768_ VGND VGND VPWR VPWR _3770_ sky130_fd_sc_hd__mux2_1
XFILLER_0_74_653 VGND VGND VPWR VPWR sky130_fd_sc_hd__fill_1
X_4897_ _1661_ _1662_ _1621_ VGND VGND VPWR VPWR _1663_ sky130_fd_sc_hd__mux2_1
XFILLER_0_34_506 VGND VGND VPWR VPWR sky130_fd_sc_hd__fill_1
X_6636_ _3194_ VGND VGND VPWR VPWR _0810_ sky130_fd_sc_hd__clkbuf_1
X_9424_ clknet_leaf_65_clk _0521_ VGND VGND VPWR VPWR registers\[6\]\[16\] sky130_fd_sc_hd__dfxtp_1
X_9355_ clknet_leaf_56_clk _0452_ VGND VGND VPWR VPWR registers\[30\]\[11\] sky130_fd_sc_hd__dfxtp_1
XFILLER_0_116_287 VGND VGND VPWR VPWR sky130_fd_sc_hd__fill_2
XANTENNA__4997__A _1706_ VGND VGND VPWR VPWR sky130_fd_sc_hd__diode_2
X_6567_ registers\[7\]\[18\] _2999_ _3148_ VGND VGND VPWR VPWR _3157_ sky130_fd_sc_hd__mux2_1
X_8306_ _4098_ VGND VGND VPWR VPWR _0552_ sky130_fd_sc_hd__clkbuf_1
X_5518_ _2168_ _2234_ VGND VGND VPWR VPWR _2254_ sky130_fd_sc_hd__nor2_1
XFILLER_0_30_701 VGND VGND VPWR VPWR sky130_fd_sc_hd__fill_2
X_9286_ clknet_leaf_32_clk _0383_ VGND VGND VPWR VPWR registers\[28\]\[6\] sky130_fd_sc_hd__dfxtp_1
XFILLER_0_14_296 VGND VGND VPWR VPWR sky130_fd_sc_hd__fill_2
X_6498_ _3115_ registers\[29\]\[22\] _3111_ VGND VGND VPWR VPWR _3116_ sky130_fd_sc_hd__mux2_1
X_8237_ registers\[6\]\[15\] _3466_ _4056_ VGND VGND VPWR VPWR _4062_ sky130_fd_sc_hd__mux2_1
X_5449_ registers\[20\]\[31\] registers\[21\]\[31\] registers\[22\]\[31\] registers\[23\]\[31\]
+ _2119_ _2120_ VGND VGND VPWR VPWR _2186_ sky130_fd_sc_hd__mux4_1
X_8168_ _4025_ VGND VGND VPWR VPWR _0487_ sky130_fd_sc_hd__clkbuf_1
X_7119_ _3459_ VGND VGND VPWR VPWR _0004_ sky130_fd_sc_hd__clkbuf_1
XFILLER_0_100_688 VGND VGND VPWR VPWR sky130_fd_sc_hd__fill_2
X_8099_ _2991_ registers\[30\]\[14\] _3984_ VGND VGND VPWR VPWR _3989_ sky130_fd_sc_hd__mux2_1
XANTENNA__7312__S _3561_ VGND VGND VPWR VPWR sky130_fd_sc_hd__diode_2
XFILLER_0_69_403 VPWR VGND VPWR VGND sky130_ef_sc_hd__decap_12
XANTENNA__5343__S0 _2027_ VGND VGND VPWR VPWR sky130_fd_sc_hd__diode_2
XTAP_TAPCELL_ROW_83_1337 VGND VPWR sky130_fd_sc_hd__tapvpwrvgnd_1
XFILLER_0_96_277 VGND VGND VPWR VPWR sky130_fd_sc_hd__fill_2
XFILLER_0_64_141 VGND VGND VPWR VPWR sky130_fd_sc_hd__fill_1
XANTENNA__7982__S _3923_ VGND VGND VPWR VPWR sky130_fd_sc_hd__diode_2
XFILLER_0_37_366 VGND VGND VPWR VPWR sky130_fd_sc_hd__fill_2
XFILLER_0_65_686 VPWR VGND VPWR VGND sky130_ef_sc_hd__decap_12
XANTENNA__5723__A1 net124 VGND VGND VPWR VPWR sky130_fd_sc_hd__diode_2
XFILLER_0_52_358 VGND VGND VPWR VPWR sky130_fd_sc_hd__decap_3
XFILLER_0_33_561 VGND VGND VPWR VPWR sky130_fd_sc_hd__fill_2
XFILLER_0_110_419 VGND VGND VPWR VPWR sky130_fd_sc_hd__fill_1
XFILLER_0_0_617 VGND VGND VPWR VPWR sky130_fd_sc_hd__decap_4
XANTENNA__5007__S _1768_ VGND VGND VPWR VPWR sky130_fd_sc_hd__diode_2
XTAP_TAPCELL_ROW_94_1477 VGND VPWR sky130_fd_sc_hd__tapvpwrvgnd_1
XFILLER_0_20_266 VGND VGND VPWR VPWR sky130_fd_sc_hd__fill_1
XANTENNA__8318__S _4103_ VGND VGND VPWR VPWR sky130_fd_sc_hd__diode_2
XANTENNA__7228__A1 _3479_ VGND VGND VPWR VPWR sky130_fd_sc_hd__diode_2
XFILLER_0_34_55 VGND VGND VPWR VPWR sky130_fd_sc_hd__fill_2
XTAP_TAPCELL_ROW_36_729 VGND VPWR sky130_fd_sc_hd__tapvpwrvgnd_1
XANTENNA__5677__S net135 VGND VGND VPWR VPWR sky130_fd_sc_hd__diode_2
XFILLER_0_75_417 VGND VGND VPWR VPWR sky130_fd_sc_hd__fill_2
XFILLER_0_47_108 VGND VGND VPWR VPWR sky130_fd_sc_hd__fill_2
X_4820_ registers\[24\]\[30\] registers\[25\]\[30\] registers\[26\]\[30\] registers\[27\]\[30\]
+ _1347_ _1348_ VGND VGND VPWR VPWR _1590_ sky130_fd_sc_hd__mux4_1
XFILLER_0_56_642 VGND VGND VPWR VPWR sky130_fd_sc_hd__fill_2
XFILLER_0_56_620 VGND VGND VPWR VPWR sky130_fd_sc_hd__fill_2
XANTENNA__5411__B1 _1960_ VGND VGND VPWR VPWR sky130_fd_sc_hd__diode_2
XTAP_TAPCELL_ROW_16_464 VGND VPWR sky130_fd_sc_hd__tapvpwrvgnd_1
XTAP_TAPCELL_ROW_103_1595 VGND VPWR sky130_fd_sc_hd__tapvpwrvgnd_1
XFILLER_0_55_130 VGND VGND VPWR VPWR sky130_fd_sc_hd__fill_2
XFILLER_0_16_506 VGND VGND VPWR VPWR sky130_fd_sc_hd__fill_1
X_4751_ registers\[12\]\[26\] registers\[13\]\[26\] registers\[14\]\[26\] registers\[15\]\[26\]
+ _1390_ _1391_ VGND VGND VPWR VPWR _1525_ sky130_fd_sc_hd__mux4_1
X_7470_ _3655_ VGND VGND VPWR VPWR _0159_ sky130_fd_sc_hd__clkbuf_1
XFILLER_0_83_472 VGND VGND VPWR VPWR sky130_fd_sc_hd__fill_2
XFILLER_0_55_185 VGND VGND VPWR VPWR sky130_fd_sc_hd__fill_2
XFILLER_0_50_65 VGND VGND VPWR VPWR sky130_fd_sc_hd__decap_4
X_4682_ registers\[4\]\[22\] registers\[5\]\[22\] registers\[6\]\[22\] registers\[7\]\[22\]
+ _1418_ _1419_ VGND VGND VPWR VPWR _1460_ sky130_fd_sc_hd__mux4_1
XFILLER_0_7_249 VGND VGND VPWR VPWR sky130_fd_sc_hd__decap_3
XFILLER_0_114_725 VGND VGND VPWR VPWR sky130_fd_sc_hd__decap_8
XANTENNA__5175__C1 _1778_ VGND VGND VPWR VPWR sky130_fd_sc_hd__diode_2
XFILLER_0_71_645 VGND VGND VPWR VPWR sky130_fd_sc_hd__fill_2
X_6421_ registers\[3\]\[30\] _3024_ _3029_ VGND VGND VPWR VPWR _3063_ sky130_fd_sc_hd__mux2_1
XFILLER_0_12_701 VPWR VGND VPWR VGND sky130_ef_sc_hd__decap_12
XFILLER_0_24_572 VPWR VGND VPWR VGND sky130_ef_sc_hd__decap_12
X_9140_ clknet_leaf_74_clk _0237_ VGND VGND VPWR VPWR registers\[23\]\[20\] sky130_fd_sc_hd__dfxtp_1
XFILLER_0_101_419 VGND VGND VPWR VPWR sky130_fd_sc_hd__fill_2
XFILLER_0_59_30 VGND VGND VPWR VPWR sky130_fd_sc_hd__fill_1
X_6352_ _3025_ VGND VGND VPWR VPWR _0695_ sky130_fd_sc_hd__clkbuf_1
X_9071_ clknet_leaf_46_clk _0168_ VGND VGND VPWR VPWR registers\[21\]\[15\] sky130_fd_sc_hd__dfxtp_1
X_6283_ registers\[19\]\[8\] _2978_ _2962_ VGND VGND VPWR VPWR _2979_ sky130_fd_sc_hd__mux2_1
XFILLER_0_59_85 VGND VGND VPWR VPWR sky130_fd_sc_hd__fill_1
X_5303_ _2048_ VGND VGND VPWR VPWR net95 sky130_fd_sc_hd__inv_2
XANTENNA__4376__S1 _1168_ VGND VGND VPWR VPWR sky130_fd_sc_hd__diode_2
X_8022_ _3936_ VGND VGND VPWR VPWR _3948_ sky130_fd_sc_hd__buf_4
X_5234_ registers\[28\]\[19\] registers\[29\]\[19\] registers\[30\]\[19\] registers\[31\]\[19\]
+ _1719_ _1720_ VGND VGND VPWR VPWR _1983_ sky130_fd_sc_hd__mux4_1
XANTENNA__7219__A1 _3470_ VGND VGND VPWR VPWR sky130_fd_sc_hd__diode_2
X_5165_ registers\[24\]\[15\] registers\[25\]\[15\] registers\[26\]\[15\] registers\[27\]\[15\]
+ _1806_ _1759_ VGND VGND VPWR VPWR _1918_ sky130_fd_sc_hd__mux4_1
XANTENNA__4756__S _1140_ VGND VGND VPWR VPWR sky130_fd_sc_hd__diode_2
XFILLER_0_75_40 VGND VGND VPWR VPWR sky130_fd_sc_hd__fill_2
X_5096_ registers\[28\]\[11\] registers\[29\]\[11\] registers\[30\]\[11\] registers\[31\]\[11\]
+ _1763_ _1765_ VGND VGND VPWR VPWR _1853_ sky130_fd_sc_hd__mux4_1
XANTENNA__5325__S0 _2020_ VGND VGND VPWR VPWR sky130_fd_sc_hd__diode_2
XANTENNA__6971__S _3372_ VGND VGND VPWR VPWR sky130_fd_sc_hd__diode_2
X_8924_ clknet_leaf_103_clk _0021_ VGND VGND VPWR VPWR registers\[16\]\[28\] sky130_fd_sc_hd__dfxtp_1
X_8855_ clknet_leaf_70_clk _0976_ VGND VGND VPWR VPWR registers\[14\]\[23\] sky130_fd_sc_hd__dfxtp_1
XFILLER_0_93_203 VGND VGND VPWR VPWR sky130_fd_sc_hd__fill_2
X_7806_ _3077_ registers\[26\]\[4\] _3829_ VGND VGND VPWR VPWR _3834_ sky130_fd_sc_hd__mux2_1
XFILLER_0_93_225 VGND VGND VPWR VPWR sky130_fd_sc_hd__decap_3
X_5998_ net89 _2716_ VGND VGND VPWR VPWR _2717_ sky130_fd_sc_hd__xnor2_1
X_8786_ clknet_leaf_68_clk _0907_ VGND VGND VPWR VPWR registers\[12\]\[18\] sky130_fd_sc_hd__dfxtp_1
XFILLER_0_47_631 VGND VGND VPWR VPWR sky130_fd_sc_hd__fill_2
X_4949_ _1709_ _1712_ _1687_ VGND VGND VPWR VPWR _1713_ sky130_fd_sc_hd__mux2_1
XFILLER_0_93_258 VGND VGND VPWR VPWR sky130_fd_sc_hd__fill_1
X_7737_ _3797_ VGND VGND VPWR VPWR _0284_ sky130_fd_sc_hd__clkbuf_1
XFILLER_0_47_664 VGND VGND VPWR VPWR sky130_fd_sc_hd__decap_4
XFILLER_0_47_653 VGND VGND VPWR VPWR sky130_fd_sc_hd__fill_2
X_7668_ registers\[24\]\[3\] _3441_ _3757_ VGND VGND VPWR VPWR _3761_ sky130_fd_sc_hd__mux2_1
XFILLER_0_61_100 VGND VGND VPWR VPWR sky130_fd_sc_hd__fill_2
XFILLER_0_46_163 VGND VGND VPWR VPWR sky130_fd_sc_hd__fill_2
XFILLER_0_105_725 VGND VGND VPWR VPWR sky130_fd_sc_hd__decap_3
X_6619_ _3185_ VGND VGND VPWR VPWR _0802_ sky130_fd_sc_hd__clkbuf_1
XFILLER_0_62_645 VGND VGND VPWR VPWR sky130_fd_sc_hd__fill_2
XFILLER_0_61_133 VGND VGND VPWR VPWR sky130_fd_sc_hd__decap_3
X_9407_ clknet_leaf_10_clk _0504_ VGND VGND VPWR VPWR registers\[9\]\[31\] sky130_fd_sc_hd__dfxtp_1
X_7599_ _3075_ registers\[23\]\[3\] _3720_ VGND VGND VPWR VPWR _3724_ sky130_fd_sc_hd__mux2_1
XFILLER_0_61_166 VGND VGND VPWR VPWR sky130_fd_sc_hd__fill_2
XANTENNA__4520__A _1153_ VGND VGND VPWR VPWR sky130_fd_sc_hd__diode_2
X_9338_ clknet_leaf_90_clk _0435_ VGND VGND VPWR VPWR registers\[2\]\[26\] sky130_fd_sc_hd__dfxtp_1
X_9269_ clknet_leaf_79_clk _0366_ VGND VGND VPWR VPWR registers\[27\]\[21\] sky130_fd_sc_hd__dfxtp_1
XANTENNA__4367__S1 _1161_ VGND VGND VPWR VPWR sky130_fd_sc_hd__diode_2
XFILLER_0_100_485 VGND VGND VPWR VPWR sky130_fd_sc_hd__fill_2
XANTENNA__5018__A1_N _1741_ VGND VGND VPWR VPWR sky130_fd_sc_hd__diode_2
XANTENNA__6447__A net44 VGND VGND VPWR VPWR sky130_fd_sc_hd__diode_2
XANTENNA__7042__S _3409_ VGND VGND VPWR VPWR sky130_fd_sc_hd__diode_2
XANTENNA__8138__S _4009_ VGND VGND VPWR VPWR sky130_fd_sc_hd__diode_2
XANTENNA__6969__A0 _3092_ VGND VGND VPWR VPWR sky130_fd_sc_hd__diode_2
XANTENNA__5316__S0 _1883_ VGND VGND VPWR VPWR sky130_fd_sc_hd__diode_2
XANTENNA__4444__A1 _1131_ VGND VGND VPWR VPWR sky130_fd_sc_hd__diode_2
XANTENNA__6881__S _3324_ VGND VGND VPWR VPWR sky130_fd_sc_hd__diode_2
XFILLER_0_97_542 VGND VGND VPWR VPWR sky130_fd_sc_hd__decap_8
XFILLER_0_97_586 VGND VGND VPWR VPWR sky130_fd_sc_hd__decap_4
XFILLER_0_97_575 VGND VGND VPWR VPWR sky130_fd_sc_hd__decap_4
XFILLER_0_69_299 VGND VGND VPWR VPWR sky130_fd_sc_hd__decap_6
XFILLER_0_84_269 VGND VGND VPWR VPWR sky130_fd_sc_hd__fill_2
XTAP_TAPCELL_ROW_13_423 VGND VPWR sky130_fd_sc_hd__tapvpwrvgnd_1
XFILLER_0_37_141 VGND VGND VPWR VPWR sky130_fd_sc_hd__fill_2
XTAP_TAPCELL_ROW_13_434 VGND VPWR sky130_fd_sc_hd__tapvpwrvgnd_1
XANTENNA__7697__A1 _3470_ VGND VGND VPWR VPWR sky130_fd_sc_hd__diode_2
XFILLER_0_108_585 VGND VGND VPWR VPWR sky130_fd_sc_hd__decap_3
XFILLER_0_108_563 VGND VGND VPWR VPWR sky130_fd_sc_hd__fill_1
XTAP_TAPCELL_ROW_96_1506 VGND VPWR sky130_fd_sc_hd__tapvpwrvgnd_1
XTAP_TAPCELL_ROW_41_798 VGND VPWR sky130_fd_sc_hd__tapvpwrvgnd_1
XTAP_TAPCELL_ROW_41_787 VGND VPWR sky130_fd_sc_hd__tapvpwrvgnd_1
XFILLER_0_20_24 VGND VGND VPWR VPWR sky130_fd_sc_hd__fill_2
XFILLER_0_20_13 VGND VGND VPWR VPWR sky130_fd_sc_hd__decap_4
XFILLER_0_105_7 VGND VGND VPWR VPWR sky130_fd_sc_hd__fill_1
XANTENNA__7217__S _3514_ VGND VGND VPWR VPWR sky130_fd_sc_hd__diode_2
XFILLER_0_20_68 VGND VGND VPWR VPWR sky130_fd_sc_hd__fill_2
XFILLER_0_0_403 VGND VGND VPWR VPWR sky130_fd_sc_hd__fill_2
XFILLER_0_20_79 VGND VGND VPWR VPWR sky130_fd_sc_hd__decap_3
XFILLER_0_33_391 VGND VGND VPWR VPWR sky130_fd_sc_hd__fill_1
XANTENNA__7449__A1 _3495_ VGND VGND VPWR VPWR sky130_fd_sc_hd__diode_2
XFILLER_0_0_414 VGND VGND VPWR VPWR sky130_fd_sc_hd__fill_2
XFILLER_0_0_436 VPWR VGND VPWR VGND sky130_ef_sc_hd__decap_12
XANTENNA__8048__S _3959_ VGND VGND VPWR VPWR sky130_fd_sc_hd__diode_2
XANTENNA__5307__S0 _1883_ VGND VGND VPWR VPWR sky130_fd_sc_hd__diode_2
XANTENNA__7887__S _3876_ VGND VGND VPWR VPWR sky130_fd_sc_hd__diode_2
X_6970_ _3374_ VGND VGND VPWR VPWR _0964_ sky130_fd_sc_hd__clkbuf_1
XANTENNA__6791__S _3272_ VGND VGND VPWR VPWR sky130_fd_sc_hd__diode_2
XFILLER_0_88_542 VGND VGND VPWR VPWR sky130_fd_sc_hd__decap_3
XFILLER_0_88_531 VGND VGND VPWR VPWR sky130_fd_sc_hd__fill_1
X_5921_ net117 _2622_ _2643_ VGND VGND VPWR VPWR _2644_ sky130_fd_sc_hd__or3_1
XTAP_TAPCELL_ROW_49_898 VGND VPWR sky130_fd_sc_hd__tapvpwrvgnd_1
XTAP_TAPCELL_ROW_105_1624 VGND VPWR sky130_fd_sc_hd__tapvpwrvgnd_1
XANTENNA__4530__S1 _1199_ VGND VGND VPWR VPWR sky130_fd_sc_hd__diode_2
XFILLER_0_76_726 VGND VGND VPWR VPWR sky130_fd_sc_hd__fill_2
X_5852_ _2465_ VGND VGND VPWR VPWR _2579_ sky130_fd_sc_hd__inv_2
XFILLER_0_75_225 VGND VGND VPWR VPWR sky130_fd_sc_hd__decap_4
XFILLER_0_61_20 VGND VGND VPWR VPWR sky130_fd_sc_hd__fill_1
X_8640_ clknet_leaf_4_clk _0761_ VGND VGND VPWR VPWR registers\[7\]\[0\] sky130_fd_sc_hd__dfxtp_1
X_5783_ _2498_ _2509_ _2512_ _2420_ VGND VGND VPWR VPWR _2513_ sky130_fd_sc_hd__o211a_1
XFILLER_0_91_729 VGND VGND VPWR VPWR sky130_fd_sc_hd__fill_1
XFILLER_0_75_258 VGND VGND VPWR VPWR sky130_fd_sc_hd__decap_4
XFILLER_0_61_64 VGND VGND VPWR VPWR sky130_fd_sc_hd__fill_2
XFILLER_0_8_514 VGND VGND VPWR VPWR sky130_fd_sc_hd__fill_2
X_4803_ registers\[24\]\[29\] registers\[25\]\[29\] registers\[26\]\[29\] registers\[27\]\[29\]
+ _1555_ _1556_ VGND VGND VPWR VPWR _1574_ sky130_fd_sc_hd__mux4_1
X_8571_ clknet_leaf_102_clk _0692_ VGND VGND VPWR VPWR registers\[19\]\[27\] sky130_fd_sc_hd__dfxtp_1
XFILLER_0_29_642 VGND VGND VPWR VPWR sky130_fd_sc_hd__fill_1
XANTENNA__4294__S0 _1060_ VGND VGND VPWR VPWR sky130_fd_sc_hd__diode_2
XANTENNA__8511__S _4200_ VGND VGND VPWR VPWR sky130_fd_sc_hd__diode_2
XFILLER_0_61_97 VGND VGND VPWR VPWR sky130_fd_sc_hd__fill_1
XFILLER_0_44_601 VGND VGND VPWR VPWR sky130_fd_sc_hd__fill_2
XFILLER_0_9_10 VGND VGND VPWR VPWR sky130_fd_sc_hd__fill_2
X_4734_ registers\[8\]\[25\] registers\[9\]\[25\] registers\[10\]\[25\] registers\[11\]\[25\]
+ _1415_ _1416_ VGND VGND VPWR VPWR _1509_ sky130_fd_sc_hd__mux4_1
X_7522_ _3682_ VGND VGND VPWR VPWR _0184_ sky130_fd_sc_hd__clkbuf_1
XFILLER_0_44_645 VGND VGND VPWR VPWR sky130_fd_sc_hd__decap_4
XFILLER_0_43_122 VGND VGND VPWR VPWR sky130_fd_sc_hd__fill_1
XFILLER_0_114_533 VGND VGND VPWR VPWR sky130_fd_sc_hd__fill_2
XANTENNA__7127__S _3456_ VGND VGND VPWR VPWR sky130_fd_sc_hd__diode_2
XFILLER_0_71_486 VGND VGND VPWR VPWR sky130_fd_sc_hd__fill_2
X_4665_ registers\[20\]\[21\] registers\[21\]\[21\] registers\[22\]\[21\] registers\[23\]\[21\]
+ _1427_ _1428_ VGND VGND VPWR VPWR _1444_ sky130_fd_sc_hd__mux4_1
X_7453_ registers\[20\]\[31\] _3499_ _3611_ VGND VGND VPWR VPWR _3646_ sky130_fd_sc_hd__mux2_1
XANTENNA__4340__A _1125_ VGND VGND VPWR VPWR sky130_fd_sc_hd__diode_2
X_4596_ _1376_ _1377_ _1344_ VGND VGND VPWR VPWR _1378_ sky130_fd_sc_hd__mux2_1
X_6404_ _3054_ VGND VGND VPWR VPWR _0718_ sky130_fd_sc_hd__clkbuf_1
XFILLER_0_24_391 VGND VGND VPWR VPWR sky130_fd_sc_hd__fill_2
X_7384_ registers\[1\]\[31\] _3499_ _3574_ VGND VGND VPWR VPWR _3609_ sky130_fd_sc_hd__mux2_1
XTAP_TAPCELL_ROW_116_1764 VGND VPWR sky130_fd_sc_hd__tapvpwrvgnd_1
X_9123_ clknet_leaf_23_clk _0220_ VGND VGND VPWR VPWR registers\[23\]\[3\] sky130_fd_sc_hd__dfxtp_1
X_6335_ net33 VGND VGND VPWR VPWR _3014_ sky130_fd_sc_hd__buf_2
XFILLER_0_12_553 VGND VGND VPWR VPWR sky130_fd_sc_hd__fill_2
X_9054_ clknet_leaf_96_clk _0151_ VGND VGND VPWR VPWR registers\[20\]\[30\] sky130_fd_sc_hd__dfxtp_1
X_8005_ _3939_ VGND VGND VPWR VPWR _0410_ sky130_fd_sc_hd__clkbuf_1
X_6266_ _2967_ VGND VGND VPWR VPWR _0667_ sky130_fd_sc_hd__clkbuf_1
XANTENNA__6267__A net41 VGND VGND VPWR VPWR sky130_fd_sc_hd__diode_2
X_5217_ _1963_ _1966_ _1754_ VGND VGND VPWR VPWR _1967_ sky130_fd_sc_hd__mux2_1
X_6197_ net100 _2882_ VGND VGND VPWR VPWR _2905_ sky130_fd_sc_hd__or2_1
XANTENNA__4674__A1 _1389_ VGND VGND VPWR VPWR sky130_fd_sc_hd__diode_2
X_5148_ registers\[28\]\[14\] registers\[29\]\[14\] registers\[30\]\[14\] registers\[31\]\[14\]
+ _1748_ _1749_ VGND VGND VPWR VPWR _1902_ sky130_fd_sc_hd__mux4_1
XFILLER_0_98_306 VGND VGND VPWR VPWR sky130_fd_sc_hd__fill_2
X_5079_ registers\[16\]\[10\] registers\[17\]\[10\] registers\[18\]\[10\] registers\[19\]\[10\]
+ _1757_ _1814_ VGND VGND VPWR VPWR _1837_ sky130_fd_sc_hd__mux4_1
X_8907_ clknet_leaf_59_clk _0004_ VGND VGND VPWR VPWR registers\[16\]\[11\] sky130_fd_sc_hd__dfxtp_1
XTAP_TAPCELL_ROW_67_1129 VGND VPWR sky130_fd_sc_hd__tapvpwrvgnd_1
XANTENNA__4521__S1 _1137_ VGND VGND VPWR VPWR sky130_fd_sc_hd__diode_2
XFILLER_0_94_501 VGND VGND VPWR VPWR sky130_fd_sc_hd__fill_1
XFILLER_0_79_564 VGND VGND VPWR VPWR sky130_fd_sc_hd__decap_4
X_8838_ clknet_leaf_35_clk _0959_ VGND VGND VPWR VPWR registers\[14\]\[6\] sky130_fd_sc_hd__dfxtp_1
XFILLER_0_94_545 VGND VGND VPWR VPWR sky130_fd_sc_hd__fill_2
XFILLER_0_39_439 VGND VGND VPWR VPWR sky130_fd_sc_hd__fill_2
XFILLER_0_94_567 VGND VGND VPWR VPWR sky130_fd_sc_hd__decap_4
XFILLER_0_82_729 VGND VGND VPWR VPWR sky130_fd_sc_hd__fill_1
XFILLER_0_66_269 VGND VGND VPWR VPWR sky130_fd_sc_hd__fill_1
X_8769_ clknet_leaf_7_clk _0890_ VGND VGND VPWR VPWR registers\[12\]\[1\] sky130_fd_sc_hd__dfxtp_1
XFILLER_0_94_589 VGND VGND VPWR VPWR sky130_fd_sc_hd__fill_2
XFILLER_0_47_483 VGND VGND VPWR VPWR sky130_fd_sc_hd__fill_2
XFILLER_0_19_163 VGND VGND VPWR VPWR sky130_fd_sc_hd__decap_3
XFILLER_0_34_100 VGND VGND VPWR VPWR sky130_fd_sc_hd__decap_4
XANTENNA__4285__S0 _1026_ VGND VGND VPWR VPWR sky130_fd_sc_hd__diode_2
XFILLER_0_35_601 VGND VGND VPWR VPWR sky130_fd_sc_hd__fill_2
XFILLER_0_117_360 VGND VGND VPWR VPWR sky130_fd_sc_hd__decap_4
XFILLER_0_62_442 VGND VGND VPWR VPWR sky130_fd_sc_hd__fill_2
XFILLER_0_105_533 VGND VGND VPWR VPWR sky130_fd_sc_hd__fill_2
XFILLER_0_62_486 VGND VGND VPWR VPWR sky130_fd_sc_hd__fill_2
XFILLER_0_34_155 VGND VGND VPWR VPWR sky130_fd_sc_hd__decap_3
XTAP_TAPCELL_ROW_78_1269 VGND VPWR sky130_fd_sc_hd__tapvpwrvgnd_1
XANTENNA__4250__A _1049_ VGND VGND VPWR VPWR sky130_fd_sc_hd__diode_2
XFILLER_0_62_497 VGND VGND VPWR VPWR sky130_fd_sc_hd__decap_6
XFILLER_0_50_637 VGND VGND VPWR VPWR sky130_fd_sc_hd__fill_2
XTAP_TAPCELL_ROW_91_1447 VGND VPWR sky130_fd_sc_hd__tapvpwrvgnd_1
XTAP_TAPCELL_ROW_91_1436 VGND VPWR sky130_fd_sc_hd__tapvpwrvgnd_1
XFILLER_0_30_361 VGND VGND VPWR VPWR sky130_fd_sc_hd__decap_3
XANTENNA_input41_A wd3[3] VGND VGND VPWR VPWR sky130_fd_sc_hd__diode_2
XFILLER_0_100_293 VGND VGND VPWR VPWR sky130_fd_sc_hd__decap_4
XFILLER_0_82_19 VGND VGND VPWR VPWR sky130_fd_sc_hd__fill_2
XFILLER_0_106_15 VPWR VGND VPWR VGND sky130_ef_sc_hd__decap_12
XFILLER_0_15_13 VGND VGND VPWR VPWR sky130_fd_sc_hd__fill_2
XANTENNA__4512__S1 _1199_ VGND VGND VPWR VPWR sky130_fd_sc_hd__diode_2
XFILLER_0_58_715 VGND VGND VPWR VPWR sky130_fd_sc_hd__fill_2
XTAP_TAPCELL_ROW_46_857 VGND VPWR sky130_fd_sc_hd__tapvpwrvgnd_1
XFILLER_0_15_24 VGND VGND VPWR VPWR sky130_fd_sc_hd__fill_1
XANTENNA__4425__A _1116_ VGND VGND VPWR VPWR sky130_fd_sc_hd__diode_2
XFILLER_0_57_225 VGND VGND VPWR VPWR sky130_fd_sc_hd__fill_2
XTAP_TAPCELL_ROW_26_592 VGND VPWR sky130_fd_sc_hd__tapvpwrvgnd_1
XANTENNA__5955__S _2295_ VGND VGND VPWR VPWR sky130_fd_sc_hd__diode_2
XFILLER_0_73_729 VGND VGND VPWR VPWR sky130_fd_sc_hd__fill_1
XANTENNA__4276__S0 _1039_ VGND VGND VPWR VPWR sky130_fd_sc_hd__diode_2
XFILLER_0_31_12 VGND VGND VPWR VPWR sky130_fd_sc_hd__fill_2
XFILLER_0_31_23 VGND VGND VPWR VPWR sky130_fd_sc_hd__decap_4
XFILLER_0_108_360 VGND VGND VPWR VPWR sky130_fd_sc_hd__fill_2
XTAP_TAPCELL_ROW_100_1565 VGND VPWR sky130_fd_sc_hd__tapvpwrvgnd_1
XTAP_TAPCELL_ROW_100_1554 VGND VPWR sky130_fd_sc_hd__tapvpwrvgnd_1
XANTENNA__6590__A1 _3022_ VGND VGND VPWR VPWR sky130_fd_sc_hd__diode_2
XFILLER_0_26_645 VGND VGND VPWR VPWR sky130_fd_sc_hd__fill_1
XFILLER_0_31_45 VGND VGND VPWR VPWR sky130_fd_sc_hd__fill_2
XFILLER_0_26_678 VGND VGND VPWR VPWR sky130_fd_sc_hd__fill_2
XANTENNA__5256__A _1768_ VGND VGND VPWR VPWR sky130_fd_sc_hd__diode_2
X_4450_ _1240_ VGND VGND VPWR VPWR net144 sky130_fd_sc_hd__clkbuf_2
XFILLER_0_53_497 VGND VGND VPWR VPWR sky130_fd_sc_hd__decap_4
XANTENNA__6342__A1 _3018_ VGND VGND VPWR VPWR sky130_fd_sc_hd__diode_2
XFILLER_0_111_514 VGND VGND VPWR VPWR sky130_fd_sc_hd__decap_3
X_4381_ _1171_ _1174_ _1122_ VGND VGND VPWR VPWR _1175_ sky130_fd_sc_hd__mux2_1
XFILLER_0_0_211 VGND VGND VPWR VPWR sky130_fd_sc_hd__fill_2
XFILLER_0_111_569 VGND VGND VPWR VPWR sky130_fd_sc_hd__fill_2
XFILLER_0_111_558 VGND VGND VPWR VPWR sky130_fd_sc_hd__fill_2
X_6120_ _2799_ _2831_ VGND VGND VPWR VPWR _2832_ sky130_fd_sc_hd__nand2_1
XFILLER_0_0_233 VGND VGND VPWR VPWR sky130_fd_sc_hd__fill_1
XFILLER_0_0_277 VGND VGND VPWR VPWR sky130_fd_sc_hd__decap_3
X_6051_ _2279_ _2766_ VGND VGND VPWR VPWR _2767_ sky130_fd_sc_hd__nor2_1
XFILLER_0_56_20 VGND VGND VPWR VPWR sky130_fd_sc_hd__fill_2
X_5002_ _1691_ VGND VGND VPWR VPWR _1764_ sky130_fd_sc_hd__buf_4
XANTENNA__4751__S1 _1391_ VGND VGND VPWR VPWR sky130_fd_sc_hd__diode_2
XANTENNA__7410__S _3623_ VGND VGND VPWR VPWR sky130_fd_sc_hd__diode_2
XANTENNA__4503__S1 _1168_ VGND VGND VPWR VPWR sky130_fd_sc_hd__diode_2
XFILLER_0_95_309 VGND VGND VPWR VPWR sky130_fd_sc_hd__decap_4
X_6953_ _3365_ VGND VGND VPWR VPWR _0956_ sky130_fd_sc_hd__clkbuf_1
X_5904_ net83 _2611_ _2597_ VGND VGND VPWR VPWR _2628_ sky130_fd_sc_hd__o21a_1
XANTENNA__4335__A net6 VGND VGND VPWR VPWR sky130_fd_sc_hd__diode_2
X_6884_ _3328_ VGND VGND VPWR VPWR _0924_ sky130_fd_sc_hd__clkbuf_1
XFILLER_0_48_236 VGND VGND VPWR VPWR sky130_fd_sc_hd__fill_2
X_5835_ _2353_ _2507_ _2562_ VGND VGND VPWR VPWR _2563_ sky130_fd_sc_hd__o21ai_1
X_8623_ clknet_leaf_47_clk _0744_ VGND VGND VPWR VPWR registers\[29\]\[15\] sky130_fd_sc_hd__dfxtp_1
XFILLER_0_119_669 VGND VGND VPWR VPWR sky130_fd_sc_hd__decap_3
XFILLER_0_76_589 VGND VGND VPWR VPWR sky130_fd_sc_hd__fill_2
XANTENNA__8241__S _4056_ VGND VGND VPWR VPWR sky130_fd_sc_hd__diode_2
XFILLER_0_64_729 VGND VGND VPWR VPWR sky130_fd_sc_hd__fill_1
XTAP_TAPCELL_ROW_62_1059 VGND VPWR sky130_fd_sc_hd__tapvpwrvgnd_1
XANTENNA__6030__B1 _2399_ VGND VGND VPWR VPWR sky130_fd_sc_hd__diode_2
XANTENNA__4267__S0 _1060_ VGND VGND VPWR VPWR sky130_fd_sc_hd__diode_2
X_8554_ clknet_leaf_37_clk _0675_ VGND VGND VPWR VPWR registers\[19\]\[10\] sky130_fd_sc_hd__dfxtp_1
XFILLER_0_91_559 VGND VGND VPWR VPWR sky130_fd_sc_hd__fill_1
X_5766_ _2344_ _2494_ _2496_ VGND VGND VPWR VPWR _2497_ sky130_fd_sc_hd__a21oi_1
XFILLER_0_16_122 VGND VGND VPWR VPWR sky130_fd_sc_hd__decap_6
X_5697_ _1049_ _1070_ _1089_ _2394_ VGND VGND VPWR VPWR _2430_ sky130_fd_sc_hd__a31o_1
X_8485_ _4193_ VGND VGND VPWR VPWR _0636_ sky130_fd_sc_hd__clkbuf_1
X_4717_ registers\[0\]\[24\] registers\[1\]\[24\] registers\[2\]\[24\] registers\[3\]\[24\]
+ _1433_ _1434_ VGND VGND VPWR VPWR _1493_ sky130_fd_sc_hd__mux4_1
XFILLER_0_16_166 VPWR VGND VPWR VGND sky130_ef_sc_hd__decap_12
XFILLER_0_32_615 VGND VGND VPWR VPWR sky130_fd_sc_hd__fill_2
X_7505_ _3117_ registers\[21\]\[23\] _3670_ VGND VGND VPWR VPWR _3674_ sky130_fd_sc_hd__mux2_1
XFILLER_0_16_188 VGND VGND VPWR VPWR sky130_fd_sc_hd__fill_2
XFILLER_0_32_648 VGND VGND VPWR VPWR sky130_fd_sc_hd__fill_2
X_7436_ _3637_ VGND VGND VPWR VPWR _0143_ sky130_fd_sc_hd__clkbuf_1
X_4648_ _1321_ VGND VGND VPWR VPWR _1428_ sky130_fd_sc_hd__buf_4
XFILLER_0_114_374 VGND VGND VPWR VPWR sky130_fd_sc_hd__fill_2
XFILLER_0_102_514 VGND VGND VPWR VPWR sky130_fd_sc_hd__fill_2
XANTENNA__6696__S _3225_ VGND VGND VPWR VPWR sky130_fd_sc_hd__diode_2
X_4579_ _1131_ VGND VGND VPWR VPWR _1362_ sky130_fd_sc_hd__clkbuf_8
X_9106_ clknet_leaf_72_clk _0203_ VGND VGND VPWR VPWR registers\[22\]\[18\] sky130_fd_sc_hd__dfxtp_1
X_7367_ _3600_ VGND VGND VPWR VPWR _0111_ sky130_fd_sc_hd__clkbuf_1
X_6318_ _3002_ VGND VGND VPWR VPWR _0684_ sky130_fd_sc_hd__clkbuf_1
X_7298_ registers\[18\]\[22\] _3481_ _3561_ VGND VGND VPWR VPWR _3564_ sky130_fd_sc_hd__mux2_1
X_9037_ clknet_leaf_58_clk _0134_ VGND VGND VPWR VPWR registers\[20\]\[13\] sky130_fd_sc_hd__dfxtp_1
X_6249_ _2353_ _2924_ _2953_ _2270_ VGND VGND VPWR VPWR _2954_ sky130_fd_sc_hd__o211a_1
XANTENNA__8416__S _4153_ VGND VGND VPWR VPWR sky130_fd_sc_hd__diode_2
XANTENNA__7320__S _3575_ VGND VGND VPWR VPWR sky130_fd_sc_hd__diode_2
XFILLER_0_79_361 VGND VGND VPWR VPWR sky130_fd_sc_hd__fill_2
XFILLER_0_79_350 VGND VGND VPWR VPWR sky130_fd_sc_hd__fill_2
XTAP_TAPCELL_ROW_43_816 VGND VPWR sky130_fd_sc_hd__tapvpwrvgnd_1
XANTENNA__8010__A1 _3443_ VGND VGND VPWR VPWR sky130_fd_sc_hd__diode_2
XFILLER_0_82_537 VGND VGND VPWR VPWR sky130_fd_sc_hd__fill_2
XFILLER_0_67_589 VGND VGND VPWR VPWR sky130_fd_sc_hd__fill_2
XANTENNA__6021__B1 _2394_ VGND VGND VPWR VPWR sky130_fd_sc_hd__diode_2
XFILLER_0_55_729 VGND VGND VPWR VPWR sky130_fd_sc_hd__fill_1
XANTENNA__4258__S0 _1053_ VGND VGND VPWR VPWR sky130_fd_sc_hd__diode_2
XANTENNA__6460__A _3068_ VGND VGND VPWR VPWR sky130_fd_sc_hd__diode_2
XTAP_TAPCELL_ROW_23_562 VGND VPWR sky130_fd_sc_hd__tapvpwrvgnd_1
XANTENNA__6572__A1 _3003_ VGND VGND VPWR VPWR sky130_fd_sc_hd__diode_2
XFILLER_0_62_261 VGND VGND VPWR VPWR sky130_fd_sc_hd__fill_1
XFILLER_0_23_604 VGND VGND VPWR VPWR sky130_fd_sc_hd__decap_3
XANTENNA__7990__S _3923_ VGND VGND VPWR VPWR sky130_fd_sc_hd__diode_2
XFILLER_0_105_330 VGND VGND VPWR VPWR sky130_fd_sc_hd__decap_3
XFILLER_0_35_497 VGND VGND VPWR VPWR sky130_fd_sc_hd__fill_2
XANTENNA__5523__B _2213_ VGND VGND VPWR VPWR sky130_fd_sc_hd__diode_2
XANTENNA__5015__S _1768_ VGND VGND VPWR VPWR sky130_fd_sc_hd__diode_2
XFILLER_0_93_18 VGND VGND VPWR VPWR sky130_fd_sc_hd__decap_3
XANTENNA__4733__S1 _1416_ VGND VGND VPWR VPWR sky130_fd_sc_hd__diode_2
XFILLER_0_117_69 VGND VGND VPWR VPWR sky130_fd_sc_hd__fill_2
XFILLER_0_89_136 VGND VGND VPWR VPWR sky130_fd_sc_hd__fill_2
XANTENNA__7230__S _3525_ VGND VGND VPWR VPWR sky130_fd_sc_hd__diode_2
XANTENNA__8326__S _4103_ VGND VGND VPWR VPWR sky130_fd_sc_hd__diode_2
XANTENNA__4854__S _1621_ VGND VGND VPWR VPWR sky130_fd_sc_hd__diode_2
XPHY_EDGE_ROW_11_Left_131 VGND VGND VPWR VPWR sky130_fd_sc_hd__decap_3
X_5620_ _1051_ _2302_ VGND VGND VPWR VPWR _2355_ sky130_fd_sc_hd__nand2_1
X_5551_ _1851_ _2214_ VGND VGND VPWR VPWR _2287_ sky130_fd_sc_hd__or2_1
XFILLER_0_14_615 VGND VGND VPWR VPWR sky130_fd_sc_hd__fill_1
X_4502_ _1287_ _1288_ _1117_ VGND VGND VPWR VPWR _1289_ sky130_fd_sc_hd__mux2_1
XFILLER_0_81_581 VGND VGND VPWR VPWR sky130_fd_sc_hd__decap_3
XFILLER_0_53_272 VGND VGND VPWR VPWR sky130_fd_sc_hd__fill_2
XFILLER_0_41_434 VPWR VGND VPWR VGND sky130_ef_sc_hd__decap_12
X_8270_ registers\[6\]\[31\] _3499_ _4044_ VGND VGND VPWR VPWR _4079_ sky130_fd_sc_hd__mux2_1
XFILLER_0_5_369 VGND VGND VPWR VPWR sky130_fd_sc_hd__fill_2
XFILLER_0_14_637 VGND VGND VPWR VPWR sky130_fd_sc_hd__fill_2
XFILLER_0_14_648 VGND VGND VPWR VPWR sky130_fd_sc_hd__fill_2
X_5482_ _1959_ _2216_ _2217_ VGND VGND VPWR VPWR _2218_ sky130_fd_sc_hd__o21ai_1
XFILLER_0_77_7 VGND VGND VPWR VPWR sky130_fd_sc_hd__fill_2
X_7221_ registers\[17\]\[18\] _3472_ _3514_ VGND VGND VPWR VPWR _3523_ sky130_fd_sc_hd__mux2_1
XPHY_EDGE_ROW_20_Left_140 VGND VGND VPWR VPWR sky130_fd_sc_hd__decap_3
XTAP_TAPCELL_ROW_113_1723 VGND VPWR sky130_fd_sc_hd__tapvpwrvgnd_1
X_4433_ _1224_ VGND VGND VPWR VPWR net143 sky130_fd_sc_hd__clkbuf_2
XANTENNA__4421__S0 _1053_ VGND VGND VPWR VPWR sky130_fd_sc_hd__diode_2
XANTENNA__7405__S _3612_ VGND VGND VPWR VPWR sky130_fd_sc_hd__diode_2
XFILLER_0_41_478 VGND VGND VPWR VPWR sky130_fd_sc_hd__fill_2
XFILLER_0_6_33 VGND VGND VPWR VPWR sky130_fd_sc_hd__fill_2
XFILLER_0_6_11 VGND VGND VPWR VPWR sky130_fd_sc_hd__decap_4
XFILLER_0_13_169 VGND VGND VPWR VPWR sky130_fd_sc_hd__fill_2
XTAP_TAPCELL_ROW_113_1734 VGND VPWR sky130_fd_sc_hd__tapvpwrvgnd_1
XFILLER_0_111_366 VGND VGND VPWR VPWR sky130_fd_sc_hd__fill_1
X_4364_ _1135_ VGND VGND VPWR VPWR _1159_ sky130_fd_sc_hd__buf_6
X_7152_ registers\[16\]\[22\] _3481_ _3477_ VGND VGND VPWR VPWR _3482_ sky130_fd_sc_hd__mux2_1
XFILLER_0_6_66 VGND VGND VPWR VPWR sky130_fd_sc_hd__fill_1
XANTENNA_clkload13_A clknet_4_14_0_clk VGND VGND VPWR VPWR sky130_fd_sc_hd__diode_2
X_4295_ registers\[16\]\[3\] registers\[17\]\[3\] registers\[18\]\[3\] registers\[19\]\[3\]
+ _1060_ _1061_ VGND VGND VPWR VPWR _1092_ sky130_fd_sc_hd__mux4_1
X_7083_ _3434_ VGND VGND VPWR VPWR _3435_ sky130_fd_sc_hd__clkbuf_8
X_6103_ net127 _2815_ _2515_ _1484_ VGND VGND VPWR VPWR _2816_ sky130_fd_sc_hd__o211ai_2
X_6034_ net123 _2707_ _2749_ _2750_ VGND VGND VPWR VPWR _2751_ sky130_fd_sc_hd__a22o_1
XANTENNA__7579__A0 _3123_ VGND VGND VPWR VPWR sky130_fd_sc_hd__diode_2
X_7985_ _3928_ VGND VGND VPWR VPWR _0401_ sky130_fd_sc_hd__clkbuf_1
XFILLER_0_89_670 VGND VGND VPWR VPWR sky130_fd_sc_hd__fill_2
X_6936_ _3355_ VGND VGND VPWR VPWR _0949_ sky130_fd_sc_hd__clkbuf_1
XTAP_TAPCELL_ROW_1_268 VGND VPWR sky130_fd_sc_hd__tapvpwrvgnd_1
XFILLER_0_119_433 VPWR VGND VPWR VGND sky130_ef_sc_hd__decap_12
XFILLER_0_37_729 VGND VGND VPWR VPWR sky130_fd_sc_hd__fill_1
X_6867_ registers\[12\]\[28\] _3020_ _3310_ VGND VGND VPWR VPWR _3319_ sky130_fd_sc_hd__mux2_1
X_5818_ _2546_ VGND VGND VPWR VPWR net78 sky130_fd_sc_hd__clkbuf_1
X_8606_ clknet_leaf_13_clk _0727_ VGND VGND VPWR VPWR registers\[3\]\[30\] sky130_fd_sc_hd__dfxtp_1
X_6798_ _3281_ VGND VGND VPWR VPWR _0885_ sky130_fd_sc_hd__clkbuf_1
XFILLER_0_107_639 VGND VGND VPWR VPWR sky130_fd_sc_hd__fill_2
X_5749_ _2479_ _2480_ VGND VGND VPWR VPWR _2481_ sky130_fd_sc_hd__xor2_1
X_8537_ _4220_ VGND VGND VPWR VPWR _0661_ sky130_fd_sc_hd__clkbuf_1
XTAP_TAPCELL_ROW_20_521 VGND VPWR sky130_fd_sc_hd__tapvpwrvgnd_1
XFILLER_0_72_592 VGND VGND VPWR VPWR sky130_fd_sc_hd__fill_2
XFILLER_0_17_486 VGND VGND VPWR VPWR sky130_fd_sc_hd__decap_3
X_8468_ registers\[8\]\[28\] net36 _4175_ VGND VGND VPWR VPWR _4184_ sky130_fd_sc_hd__mux2_1
X_7419_ _3628_ VGND VGND VPWR VPWR _0135_ sky130_fd_sc_hd__clkbuf_1
XFILLER_0_102_333 VGND VGND VPWR VPWR sky130_fd_sc_hd__fill_1
XANTENNA__4412__S0 _1201_ VGND VGND VPWR VPWR sky130_fd_sc_hd__diode_2
XANTENNA__5624__A _2295_ VGND VGND VPWR VPWR sky130_fd_sc_hd__diode_2
XTAP_TAPCELL_ROW_75_1239 VGND VPWR sky130_fd_sc_hd__tapvpwrvgnd_1
XTAP_TAPCELL_ROW_75_1228 VGND VPWR sky130_fd_sc_hd__tapvpwrvgnd_1
X_8399_ _4147_ VGND VGND VPWR VPWR _0596_ sky130_fd_sc_hd__clkbuf_1
XFILLER_0_32_489 VGND VGND VPWR VPWR sky130_fd_sc_hd__decap_3
XFILLER_0_102_355 VGND VGND VPWR VPWR sky130_fd_sc_hd__decap_4
XANTENNA__4963__S1 _1720_ VGND VGND VPWR VPWR sky130_fd_sc_hd__diode_2
XTAP_TAPCELL_ROW_9_379 VGND VPWR sky130_fd_sc_hd__tapvpwrvgnd_1
XANTENNA__8146__S _4009_ VGND VGND VPWR VPWR sky130_fd_sc_hd__diode_2
XANTENNA__7050__S _3409_ VGND VGND VPWR VPWR sky130_fd_sc_hd__diode_2
XFILLER_0_99_489 VGND VGND VPWR VPWR sky130_fd_sc_hd__fill_1
XTAP_TAPCELL_ROW_28_621 VGND VPWR sky130_fd_sc_hd__tapvpwrvgnd_1
XTAP_TAPCELL_ROW_86_1379 VGND VPWR sky130_fd_sc_hd__tapvpwrvgnd_1
XFILLER_0_86_106 VGND VGND VPWR VPWR sky130_fd_sc_hd__decap_3
XANTENNA__5140__S1 _1749_ VGND VGND VPWR VPWR sky130_fd_sc_hd__diode_2
XFILLER_0_67_353 VGND VGND VPWR VPWR sky130_fd_sc_hd__decap_8
XTAP_TAPCELL_ROW_56_985 VGND VPWR sky130_fd_sc_hd__tapvpwrvgnd_1
XANTENNA__6793__A1 _3016_ VGND VGND VPWR VPWR sky130_fd_sc_hd__diode_2
XANTENNA__7990__A0 _3018_ VGND VGND VPWR VPWR sky130_fd_sc_hd__diode_2
XFILLER_0_95_673 VGND VGND VPWR VPWR sky130_fd_sc_hd__fill_2
XFILLER_0_55_526 VGND VGND VPWR VPWR sky130_fd_sc_hd__decap_4
XFILLER_0_12_25 VGND VGND VPWR VPWR sky130_fd_sc_hd__fill_1
XFILLER_0_113_609 VGND VGND VPWR VPWR sky130_fd_sc_hd__decap_4
XFILLER_0_51_732 VGND VGND VPWR VPWR sky130_fd_sc_hd__fill_1
Xoutput109 net109 VGND VGND VPWR VPWR rd1[6] sky130_fd_sc_hd__buf_1
XFILLER_0_10_106 VGND VGND VPWR VPWR sky130_fd_sc_hd__decap_4
Xoutput80 net80 VGND VGND VPWR VPWR alu_result[9] sky130_fd_sc_hd__buf_1
Xoutput91 net91 VGND VGND VPWR VPWR rd1[19] sky130_fd_sc_hd__buf_1
XANTENNA__8470__A1 net37 VGND VGND VPWR VPWR sky130_fd_sc_hd__diode_2
XFILLER_0_37_44 VGND VGND VPWR VPWR sky130_fd_sc_hd__fill_2
XANTENNA__8056__S _3959_ VGND VGND VPWR VPWR sky130_fd_sc_hd__diode_2
XANTENNA__8222__A1 _3451_ VGND VGND VPWR VPWR sky130_fd_sc_hd__diode_2
XANTENNA__7895__S _3876_ VGND VGND VPWR VPWR sky130_fd_sc_hd__diode_2
X_4982_ registers\[20\]\[6\] registers\[21\]\[6\] registers\[22\]\[6\] registers\[23\]\[6\]
+ _1742_ _1743_ VGND VGND VPWR VPWR _1744_ sky130_fd_sc_hd__mux4_1
XFILLER_0_58_342 VGND VGND VPWR VPWR sky130_fd_sc_hd__fill_2
X_7770_ _3814_ VGND VGND VPWR VPWR _0300_ sky130_fd_sc_hd__clkbuf_1
XFILLER_0_86_673 VPWR VGND VPWR VGND sky130_ef_sc_hd__decap_12
XFILLER_0_85_161 VGND VGND VPWR VPWR sky130_fd_sc_hd__fill_2
XFILLER_0_58_386 VGND VGND VPWR VPWR sky130_fd_sc_hd__fill_2
XFILLER_0_46_504 VGND VGND VPWR VPWR sky130_fd_sc_hd__fill_1
X_6721_ registers\[10\]\[24\] _3012_ _3236_ VGND VGND VPWR VPWR _3241_ sky130_fd_sc_hd__mux2_1
XFILLER_0_18_206 VGND VGND VPWR VPWR sky130_fd_sc_hd__fill_1
XFILLER_0_19_718 VGND VGND VPWR VPWR sky130_fd_sc_hd__decap_8
XFILLER_0_19_729 VGND VGND VPWR VPWR sky130_fd_sc_hd__fill_1
XFILLER_0_73_312 VGND VGND VPWR VPWR sky130_fd_sc_hd__decap_4
XANTENNA__4890__S0 _1628_ VGND VGND VPWR VPWR sky130_fd_sc_hd__diode_2
X_9440_ clknet_leaf_111_clk _0537_ VGND VGND VPWR VPWR registers\[31\]\[0\] sky130_fd_sc_hd__dfxtp_1
XFILLER_0_6_601 VGND VGND VPWR VPWR sky130_fd_sc_hd__decap_4
X_6652_ registers\[0\]\[25\] _3014_ _3197_ VGND VGND VPWR VPWR _3203_ sky130_fd_sc_hd__mux2_1
X_5603_ _2253_ _2291_ VGND VGND VPWR VPWR _2338_ sky130_fd_sc_hd__nand2_1
XANTENNA__4547__B1 _1025_ VGND VGND VPWR VPWR sky130_fd_sc_hd__diode_2
XFILLER_0_6_645 VGND VGND VPWR VPWR sky130_fd_sc_hd__fill_2
X_9371_ clknet_leaf_90_clk _0468_ VGND VGND VPWR VPWR registers\[30\]\[27\] sky130_fd_sc_hd__dfxtp_1
XFILLER_0_33_209 VGND VGND VPWR VPWR sky130_fd_sc_hd__fill_2
X_8322_ _3010_ registers\[31\]\[23\] _4103_ VGND VGND VPWR VPWR _4107_ sky130_fd_sc_hd__mux2_1
X_6583_ _3165_ VGND VGND VPWR VPWR _0786_ sky130_fd_sc_hd__clkbuf_1
XFILLER_0_26_250 VGND VGND VPWR VPWR sky130_fd_sc_hd__fill_2
X_5534_ _1090_ _1107_ VGND VGND VPWR VPWR _2270_ sky130_fd_sc_hd__nor2_2
X_5465_ net129 net130 net131 net132 VGND VGND VPWR VPWR _2201_ sky130_fd_sc_hd__nor4_1
X_8253_ _4070_ VGND VGND VPWR VPWR _0527_ sky130_fd_sc_hd__clkbuf_1
XFILLER_0_5_199 VGND VGND VPWR VPWR sky130_fd_sc_hd__decap_3
X_4416_ _1208_ VGND VGND VPWR VPWR net142 sky130_fd_sc_hd__inv_2
X_7204_ _3502_ VGND VGND VPWR VPWR _3514_ sky130_fd_sc_hd__clkbuf_8
X_8184_ registers\[9\]\[22\] _3481_ _4031_ VGND VGND VPWR VPWR _4034_ sky130_fd_sc_hd__mux2_1
XFILLER_0_41_297 VGND VGND VPWR VPWR sky130_fd_sc_hd__fill_2
XFILLER_0_1_361 VGND VGND VPWR VPWR sky130_fd_sc_hd__fill_2
X_7135_ net24 VGND VGND VPWR VPWR _3470_ sky130_fd_sc_hd__clkbuf_4
XFILLER_0_10_640 VGND VGND VPWR VPWR sky130_fd_sc_hd__fill_2
XFILLER_0_10_662 VGND VGND VPWR VPWR sky130_fd_sc_hd__fill_1
X_5396_ _2136_ VGND VGND VPWR VPWR net100 sky130_fd_sc_hd__inv_2
X_4347_ _1142_ VGND VGND VPWR VPWR _1143_ sky130_fd_sc_hd__clkbuf_8
XTAP_TAPCELL_ROW_6_338 VGND VPWR sky130_fd_sc_hd__tapvpwrvgnd_1
XFILLER_0_94_72 VGND VGND VPWR VPWR sky130_fd_sc_hd__decap_3
XTAP_TAPCELL_ROW_70_1169 VGND VPWR sky130_fd_sc_hd__tapvpwrvgnd_1
X_7066_ _3425_ VGND VGND VPWR VPWR _1009_ sky130_fd_sc_hd__clkbuf_1
X_4278_ _1074_ _1075_ _1030_ VGND VGND VPWR VPWR _1076_ sky130_fd_sc_hd__mux2_1
X_6017_ net138 _2734_ _1145_ VGND VGND VPWR VPWR _2735_ sky130_fd_sc_hd__o21a_1
XANTENNA__5370__S1 _2109_ VGND VGND VPWR VPWR sky130_fd_sc_hd__diode_2
XANTENNA__6224__B1 _2420_ VGND VGND VPWR VPWR sky130_fd_sc_hd__diode_2
X_7968_ _3919_ VGND VGND VPWR VPWR _0393_ sky130_fd_sc_hd__clkbuf_1
XFILLER_0_77_673 VGND VGND VPWR VPWR sky130_fd_sc_hd__fill_2
XFILLER_0_76_150 VGND VGND VPWR VPWR sky130_fd_sc_hd__fill_2
X_7899_ _3102_ registers\[27\]\[16\] _3876_ VGND VGND VPWR VPWR _3883_ sky130_fd_sc_hd__mux2_1
XTAP_TAPCELL_ROW_53_944 VGND VPWR sky130_fd_sc_hd__tapvpwrvgnd_1
X_6919_ _3110_ registers\[13\]\[20\] _3346_ VGND VGND VPWR VPWR _3347_ sky130_fd_sc_hd__mux2_1
XANTENNA__4881__S0 _1642_ VGND VGND VPWR VPWR sky130_fd_sc_hd__diode_2
XFILLER_0_9_483 VGND VGND VPWR VPWR sky130_fd_sc_hd__fill_1
XTAP_TAPCELL_ROW_33_690 VGND VPWR sky130_fd_sc_hd__tapvpwrvgnd_1
XFILLER_0_17_294 VGND VGND VPWR VPWR sky130_fd_sc_hd__fill_2
XFILLER_0_32_220 VGND VGND VPWR VPWR sky130_fd_sc_hd__fill_2
XFILLER_0_115_491 VGND VGND VPWR VPWR sky130_fd_sc_hd__fill_2
XFILLER_0_103_642 VGND VGND VPWR VPWR sky130_fd_sc_hd__fill_1
XFILLER_0_60_573 VGND VGND VPWR VPWR sky130_fd_sc_hd__fill_2
XANTENNA__4669__S _1386_ VGND VGND VPWR VPWR sky130_fd_sc_hd__diode_2
XFILLER_0_32_253 VGND VGND VPWR VPWR sky130_fd_sc_hd__decap_3
XFILLER_0_103_653 VGND VGND VPWR VPWR sky130_fd_sc_hd__fill_2
XANTENNA__6160__C1 _2420_ VGND VGND VPWR VPWR sky130_fd_sc_hd__diode_2
XFILLER_0_60_595 VPWR VGND VPWR VGND sky130_ef_sc_hd__decap_12
XANTENNA__5354__A _1758_ VGND VGND VPWR VPWR sky130_fd_sc_hd__diode_2
XANTENNA__8452__A1 net28 VGND VGND VPWR VPWR sky130_fd_sc_hd__diode_2
XTAP_TAPCELL_ROW_88_1408 VGND VPWR sky130_fd_sc_hd__tapvpwrvgnd_1
XANTENNA_clkbuf_leaf_82_clk_A clknet_4_10_0_clk VGND VGND VPWR VPWR sky130_fd_sc_hd__diode_2
XANTENNA__5361__S1 _1997_ VGND VGND VPWR VPWR sky130_fd_sc_hd__diode_2
XFILLER_0_99_286 VGND VGND VPWR VPWR sky130_fd_sc_hd__fill_2
XANTENNA__6215__B1 _2429_ VGND VGND VPWR VPWR sky130_fd_sc_hd__diode_2
XANTENNA__7963__A0 _2991_ VGND VGND VPWR VPWR sky130_fd_sc_hd__diode_2
XANTENNA__6766__A1 _2989_ VGND VGND VPWR VPWR sky130_fd_sc_hd__diode_2
XANTENNA_output110_A net110 VGND VGND VPWR VPWR sky130_fd_sc_hd__diode_2
XFILLER_0_114_26 VGND VGND VPWR VPWR sky130_fd_sc_hd__fill_2
XFILLER_0_67_161 VGND VGND VPWR VPWR sky130_fd_sc_hd__decap_6
XANTENNA__4433__A _1224_ VGND VGND VPWR VPWR sky130_fd_sc_hd__diode_2
XANTENNA_clkbuf_leaf_97_clk_A clknet_4_9_0_clk VGND VGND VPWR VPWR sky130_fd_sc_hd__diode_2
XFILLER_0_83_665 VGND VGND VPWR VPWR sky130_fd_sc_hd__decap_6
XFILLER_0_43_518 VGND VGND VPWR VPWR sky130_fd_sc_hd__fill_2
XTAP_TAPCELL_ROW_99_1548 VGND VPWR sky130_fd_sc_hd__tapvpwrvgnd_1
XFILLER_0_43_529 VGND VGND VPWR VPWR sky130_fd_sc_hd__decap_3
XFILLER_0_24_721 VGND VGND VPWR VPWR sky130_fd_sc_hd__decap_3
XANTENNA_clkbuf_leaf_20_clk_A clknet_4_1_0_clk VGND VGND VPWR VPWR sky130_fd_sc_hd__diode_2
XFILLER_0_2_136 VGND VGND VPWR VPWR sky130_fd_sc_hd__decap_4
XANTENNA__5264__A _2011_ VGND VGND VPWR VPWR sky130_fd_sc_hd__diode_2
X_5250_ registers\[24\]\[20\] registers\[25\]\[20\] registers\[26\]\[20\] registers\[27\]\[20\]
+ _1996_ _1997_ VGND VGND VPWR VPWR _1998_ sky130_fd_sc_hd__mux4_1
XANTENNA_clkbuf_leaf_35_clk_A clknet_4_7_0_clk VGND VGND VPWR VPWR sky130_fd_sc_hd__diode_2
X_5181_ registers\[20\]\[16\] registers\[21\]\[16\] registers\[22\]\[16\] registers\[23\]\[16\]
+ _1763_ _1765_ VGND VGND VPWR VPWR _1933_ sky130_fd_sc_hd__mux4_1
XANTENNA__8443__A1 net23 VGND VGND VPWR VPWR sky130_fd_sc_hd__diode_2
X_8940_ clknet_leaf_42_clk _0037_ VGND VGND VPWR VPWR registers\[17\]\[12\] sky130_fd_sc_hd__dfxtp_1
XFILLER_0_64_20 VGND VGND VPWR VPWR sky130_fd_sc_hd__fill_2
XANTENNA__6454__A0 _3085_ VGND VGND VPWR VPWR sky130_fd_sc_hd__diode_2
XFILLER_0_3_34 VGND VGND VPWR VPWR sky130_fd_sc_hd__decap_4
XANTENNA__4608__A _1323_ VGND VGND VPWR VPWR sky130_fd_sc_hd__diode_2
XANTENNA__5352__S1 _2021_ VGND VGND VPWR VPWR sky130_fd_sc_hd__diode_2
XTAP_TAPCELL_ROW_108_1666 VGND VPWR sky130_fd_sc_hd__tapvpwrvgnd_1
X_8871_ clknet_leaf_27_clk _0992_ VGND VGND VPWR VPWR registers\[15\]\[7\] sky130_fd_sc_hd__dfxtp_1
X_7822_ _3842_ VGND VGND VPWR VPWR _0324_ sky130_fd_sc_hd__clkbuf_1
XANTENNA__6757__A1 _2980_ VGND VGND VPWR VPWR sky130_fd_sc_hd__diode_2
X_7753_ _3092_ registers\[25\]\[11\] _3804_ VGND VGND VPWR VPWR _3806_ sky130_fd_sc_hd__mux2_1
X_4965_ registers\[16\]\[5\] registers\[17\]\[5\] registers\[18\]\[5\] registers\[19\]\[5\]
+ _1719_ _1720_ VGND VGND VPWR VPWR _1728_ sky130_fd_sc_hd__mux4_1
XFILLER_0_74_632 VGND VGND VPWR VPWR sky130_fd_sc_hd__fill_2
X_6704_ registers\[10\]\[16\] _2995_ _3225_ VGND VGND VPWR VPWR _3232_ sky130_fd_sc_hd__mux2_1
XFILLER_0_73_120 VGND VGND VPWR VPWR sky130_fd_sc_hd__fill_2
XFILLER_0_58_194 VGND VGND VPWR VPWR sky130_fd_sc_hd__fill_2
XTAP_TAPCELL_ROW_50_914 VGND VPWR sky130_fd_sc_hd__tapvpwrvgnd_1
XTAP_TAPCELL_ROW_50_903 VGND VPWR sky130_fd_sc_hd__tapvpwrvgnd_1
X_7684_ _3769_ VGND VGND VPWR VPWR _0259_ sky130_fd_sc_hd__clkbuf_1
X_9423_ clknet_leaf_48_clk _0520_ VGND VGND VPWR VPWR registers\[6\]\[15\] sky130_fd_sc_hd__dfxtp_1
XFILLER_0_80_85 VGND VGND VPWR VPWR sky130_fd_sc_hd__fill_1
XFILLER_0_74_676 VGND VGND VPWR VPWR sky130_fd_sc_hd__decap_3
XANTENNA_clkbuf_leaf_108_clk_A clknet_4_0_0_clk VGND VGND VPWR VPWR sky130_fd_sc_hd__diode_2
X_4896_ registers\[16\]\[2\] registers\[17\]\[2\] registers\[18\]\[2\] registers\[19\]\[2\]
+ _1617_ _1618_ VGND VGND VPWR VPWR _1662_ sky130_fd_sc_hd__mux4_1
XANTENNA__6969__S _3372_ VGND VGND VPWR VPWR sky130_fd_sc_hd__diode_2
X_6635_ registers\[0\]\[17\] _2997_ _3186_ VGND VGND VPWR VPWR _3194_ sky130_fd_sc_hd__mux2_1
XFILLER_0_15_710 VPWR VGND VPWR VGND sky130_ef_sc_hd__decap_12
X_9354_ clknet_leaf_39_clk _0451_ VGND VGND VPWR VPWR registers\[30\]\[10\] sky130_fd_sc_hd__dfxtp_1
XFILLER_0_104_417 VGND VGND VPWR VPWR sky130_fd_sc_hd__fill_1
X_6566_ _3156_ VGND VGND VPWR VPWR _0778_ sky130_fd_sc_hd__clkbuf_1
XFILLER_0_15_732 VGND VGND VPWR VPWR sky130_fd_sc_hd__fill_1
XFILLER_0_27_592 VGND VGND VPWR VPWR sky130_fd_sc_hd__decap_8
X_9285_ clknet_leaf_33_clk _0382_ VGND VGND VPWR VPWR registers\[28\]\[5\] sky130_fd_sc_hd__dfxtp_1
XANTENNA__4489__S _1122_ VGND VGND VPWR VPWR sky130_fd_sc_hd__diode_2
X_8305_ _2993_ registers\[31\]\[15\] _4092_ VGND VGND VPWR VPWR _4098_ sky130_fd_sc_hd__mux2_1
X_5517_ _2219_ VGND VGND VPWR VPWR _2253_ sky130_fd_sc_hd__buf_2
XFILLER_0_42_573 VGND VGND VPWR VPWR sky130_fd_sc_hd__fill_2
XFILLER_0_112_461 VGND VGND VPWR VPWR sky130_fd_sc_hd__fill_2
X_8236_ _4061_ VGND VGND VPWR VPWR _0519_ sky130_fd_sc_hd__clkbuf_1
X_6497_ net30 VGND VGND VPWR VPWR _3115_ sky130_fd_sc_hd__clkbuf_2
XANTENNA__5040__S0 _1798_ VGND VGND VPWR VPWR sky130_fd_sc_hd__diode_2
XFILLER_0_2_670 VGND VGND VPWR VPWR sky130_fd_sc_hd__decap_8
X_5448_ registers\[16\]\[31\] registers\[17\]\[31\] registers\[18\]\[31\] registers\[19\]\[31\]
+ _2119_ _2120_ VGND VGND VPWR VPWR _2185_ sky130_fd_sc_hd__mux4_1
X_8167_ registers\[9\]\[14\] _3464_ _4020_ VGND VGND VPWR VPWR _4025_ sky130_fd_sc_hd__mux2_1
XFILLER_0_100_645 VGND VGND VPWR VPWR sky130_fd_sc_hd__fill_2
X_5379_ _2109_ VGND VGND VPWR VPWR _2120_ sky130_fd_sc_hd__clkbuf_4
X_7118_ registers\[16\]\[11\] _3458_ _3456_ VGND VGND VPWR VPWR _3459_ sky130_fd_sc_hd__mux2_1
X_8098_ _3988_ VGND VGND VPWR VPWR _0454_ sky130_fd_sc_hd__clkbuf_1
XANTENNA__6445__A0 _3079_ VGND VGND VPWR VPWR sky130_fd_sc_hd__diode_2
X_7049_ _3416_ VGND VGND VPWR VPWR _1001_ sky130_fd_sc_hd__clkbuf_1
XANTENNA__5113__S _1695_ VGND VGND VPWR VPWR sky130_fd_sc_hd__diode_2
XANTENNA__5343__S1 _2028_ VGND VGND VPWR VPWR sky130_fd_sc_hd__diode_2
XPHY_EDGE_ROW_29_Right_29 VGND VGND VPWR VPWR sky130_fd_sc_hd__decap_3
XFILLER_0_69_415 VPWR VGND VPWR VGND sky130_ef_sc_hd__decap_12
XANTENNA__8424__S _4153_ VGND VGND VPWR VPWR sky130_fd_sc_hd__diode_2
XFILLER_0_84_407 VGND VGND VPWR VPWR sky130_fd_sc_hd__fill_2
XTAP_TAPCELL_ROW_83_1338 VGND VPWR sky130_fd_sc_hd__tapvpwrvgnd_1
XFILLER_0_108_701 VGND VGND VPWR VPWR sky130_fd_sc_hd__decap_6
XANTENNA__4253__A net8 VGND VGND VPWR VPWR sky130_fd_sc_hd__diode_2
XFILLER_0_65_665 VGND VGND VPWR VPWR sky130_fd_sc_hd__fill_1
XFILLER_0_65_698 VPWR VGND VPWR VGND sky130_ef_sc_hd__decap_12
XANTENNA__6879__S _3324_ VGND VGND VPWR VPWR sky130_fd_sc_hd__diode_2
XPHY_EDGE_ROW_38_Right_38 VGND VGND VPWR VPWR sky130_fd_sc_hd__decap_3
XANTENNA__7173__A1 _3495_ VGND VGND VPWR VPWR sky130_fd_sc_hd__diode_2
XFILLER_0_107_288 VGND VGND VPWR VPWR sky130_fd_sc_hd__decap_6
XFILLER_0_80_668 VGND VGND VPWR VPWR sky130_fd_sc_hd__decap_3
XFILLER_0_64_197 VGND VGND VPWR VPWR sky130_fd_sc_hd__fill_2
XANTENNA__8122__A0 _3014_ VGND VGND VPWR VPWR sky130_fd_sc_hd__diode_2
XFILLER_0_20_201 VGND VGND VPWR VPWR sky130_fd_sc_hd__fill_2
XANTENNA__5031__S0 _1705_ VGND VGND VPWR VPWR sky130_fd_sc_hd__diode_2
XTAP_TAPCELL_ROW_94_1478 VGND VPWR sky130_fd_sc_hd__tapvpwrvgnd_1
XANTENNA__5487__A1 _1995_ VGND VGND VPWR VPWR sky130_fd_sc_hd__diode_2
XANTENNA__7503__S _3670_ VGND VGND VPWR VPWR sky130_fd_sc_hd__diode_2
XPHY_EDGE_ROW_47_Right_47 VGND VGND VPWR VPWR sky130_fd_sc_hd__decap_3
XANTENNA__6739__A1 _2958_ VGND VGND VPWR VPWR sky130_fd_sc_hd__diode_2
XANTENNA__7936__A0 _2964_ VGND VGND VPWR VPWR sky130_fd_sc_hd__diode_2
XANTENNA__8334__S _4103_ VGND VGND VPWR VPWR sky130_fd_sc_hd__diode_2
XANTENNA__5098__S0 _1763_ VGND VGND VPWR VPWR sky130_fd_sc_hd__diode_2
XFILLER_0_87_278 VGND VGND VPWR VPWR sky130_fd_sc_hd__fill_2
XFILLER_0_118_509 VGND VGND VPWR VPWR sky130_fd_sc_hd__fill_1
XFILLER_0_68_481 VGND VGND VPWR VPWR sky130_fd_sc_hd__fill_2
XANTENNA__5411__A1 _2019_ VGND VGND VPWR VPWR sky130_fd_sc_hd__diode_2
XTAP_TAPCELL_ROW_16_465 VGND VPWR sky130_fd_sc_hd__tapvpwrvgnd_1
XTAP_TAPCELL_ROW_103_1596 VGND VPWR sky130_fd_sc_hd__tapvpwrvgnd_1
XPHY_EDGE_ROW_56_Right_56 VGND VGND VPWR VPWR sky130_fd_sc_hd__decap_3
X_4750_ _1520_ _1523_ _1379_ VGND VGND VPWR VPWR _1524_ sky130_fd_sc_hd__mux2_1
XFILLER_0_71_635 VGND VGND VPWR VPWR sky130_fd_sc_hd__fill_1
X_4681_ _1455_ _1456_ _1457_ _1458_ _1362_ _1159_ VGND VGND VPWR VPWR _1459_ sky130_fd_sc_hd__mux4_1
XANTENNA__6789__S _3272_ VGND VGND VPWR VPWR sky130_fd_sc_hd__diode_2
XANTENNA__7164__A1 _3489_ VGND VGND VPWR VPWR sky130_fd_sc_hd__diode_2
XFILLER_0_43_337 VGND VGND VPWR VPWR sky130_fd_sc_hd__fill_2
X_6420_ _3062_ VGND VGND VPWR VPWR _0726_ sky130_fd_sc_hd__clkbuf_1
X_6351_ registers\[19\]\[30\] _3024_ _2961_ VGND VGND VPWR VPWR _3025_ sky130_fd_sc_hd__mux2_1
XFILLER_0_12_713 VPWR VGND VPWR VGND sky130_ef_sc_hd__decap_12
X_5302_ _1677_ _2039_ _2043_ _2047_ VGND VGND VPWR VPWR _2048_ sky130_fd_sc_hd__a2bb2o_2
XFILLER_0_24_584 VGND VGND VPWR VPWR sky130_fd_sc_hd__decap_4
X_9070_ clknet_leaf_54_clk _0167_ VGND VGND VPWR VPWR registers\[21\]\[14\] sky130_fd_sc_hd__dfxtp_1
X_6282_ net46 VGND VGND VPWR VPWR _2978_ sky130_fd_sc_hd__buf_2
XANTENNA__8509__S _4200_ VGND VGND VPWR VPWR sky130_fd_sc_hd__diode_2
X_8021_ _3947_ VGND VGND VPWR VPWR _0418_ sky130_fd_sc_hd__clkbuf_1
XPHY_EDGE_ROW_65_Right_65 VGND VGND VPWR VPWR sky130_fd_sc_hd__decap_3
X_5233_ _1980_ _1981_ _1695_ VGND VGND VPWR VPWR _1982_ sky130_fd_sc_hd__mux2_1
X_5164_ registers\[28\]\[15\] registers\[29\]\[15\] registers\[30\]\[15\] registers\[31\]\[15\]
+ _1806_ _1759_ VGND VGND VPWR VPWR _1917_ sky130_fd_sc_hd__mux4_1
XANTENNA__8416__A1 net41 VGND VGND VPWR VPWR sky130_fd_sc_hd__diode_2
XFILLER_0_75_52 VGND VGND VPWR VPWR sky130_fd_sc_hd__fill_2
X_5095_ registers\[24\]\[11\] registers\[25\]\[11\] registers\[26\]\[11\] registers\[27\]\[11\]
+ _1758_ _1760_ VGND VGND VPWR VPWR _1852_ sky130_fd_sc_hd__mux4_1
XANTENNA__4338__A _1124_ VGND VGND VPWR VPWR sky130_fd_sc_hd__diode_2
XANTENNA__5325__S1 _2021_ VGND VGND VPWR VPWR sky130_fd_sc_hd__diode_2
XPHY_EDGE_ROW_3_Left_123 VGND VGND VPWR VPWR sky130_fd_sc_hd__decap_3
XANTENNA__6256__C net48 VGND VGND VPWR VPWR sky130_fd_sc_hd__diode_2
X_8923_ clknet_leaf_102_clk _0020_ VGND VGND VPWR VPWR registers\[16\]\[27\] sky130_fd_sc_hd__dfxtp_1
XFILLER_0_91_51 VGND VGND VPWR VPWR sky130_fd_sc_hd__decap_3
XTAP_TAPCELL_ROW_69_1160 VGND VPWR sky130_fd_sc_hd__tapvpwrvgnd_1
X_8854_ clknet_leaf_95_clk _0975_ VGND VGND VPWR VPWR registers\[14\]\[22\] sky130_fd_sc_hd__dfxtp_1
XANTENNA__5089__S0 _1742_ VGND VGND VPWR VPWR sky130_fd_sc_hd__diode_2
X_7805_ _3833_ VGND VGND VPWR VPWR _0316_ sky130_fd_sc_hd__clkbuf_1
XFILLER_0_93_215 VGND VGND VPWR VPWR sky130_fd_sc_hd__fill_2
X_8785_ clknet_leaf_50_clk _0906_ VGND VGND VPWR VPWR registers\[12\]\[17\] sky130_fd_sc_hd__dfxtp_1
XANTENNA__5169__A _1746_ VGND VGND VPWR VPWR sky130_fd_sc_hd__diode_2
XPHY_EDGE_ROW_74_Right_74 VGND VGND VPWR VPWR sky130_fd_sc_hd__decap_3
X_5997_ net121 _2715_ VGND VGND VPWR VPWR _2716_ sky130_fd_sc_hd__xnor2_1
XANTENNA__4836__S0 _1555_ VGND VGND VPWR VPWR sky130_fd_sc_hd__diode_2
X_4948_ _1710_ _1711_ _1627_ VGND VGND VPWR VPWR _1712_ sky130_fd_sc_hd__mux2_1
XFILLER_0_93_248 VGND VGND VPWR VPWR sky130_fd_sc_hd__fill_2
XFILLER_0_74_440 VGND VGND VPWR VPWR sky130_fd_sc_hd__decap_8
X_7736_ _3075_ registers\[25\]\[3\] _3793_ VGND VGND VPWR VPWR _3797_ sky130_fd_sc_hd__mux2_1
XANTENNA__7155__A1 _3483_ VGND VGND VPWR VPWR sky130_fd_sc_hd__diode_2
X_4879_ _1644_ _1645_ _1621_ VGND VGND VPWR VPWR _1646_ sky130_fd_sc_hd__mux2_1
X_7667_ _3760_ VGND VGND VPWR VPWR _0251_ sky130_fd_sc_hd__clkbuf_1
X_6618_ registers\[0\]\[9\] _2980_ _3175_ VGND VGND VPWR VPWR _3185_ sky130_fd_sc_hd__mux2_1
X_9406_ clknet_leaf_12_clk _0503_ VGND VGND VPWR VPWR registers\[9\]\[30\] sky130_fd_sc_hd__dfxtp_1
XPHY_EDGE_ROW_49_Left_169 VGND VGND VPWR VPWR sky130_fd_sc_hd__decap_3
XFILLER_0_61_156 VGND VGND VPWR VPWR sky130_fd_sc_hd__fill_1
X_7598_ _3723_ VGND VGND VPWR VPWR _0219_ sky130_fd_sc_hd__clkbuf_1
X_6549_ _3147_ VGND VGND VPWR VPWR _0770_ sky130_fd_sc_hd__clkbuf_1
XFILLER_0_42_370 VGND VGND VPWR VPWR sky130_fd_sc_hd__decap_4
X_9337_ clknet_leaf_87_clk _0434_ VGND VGND VPWR VPWR registers\[2\]\[25\] sky130_fd_sc_hd__dfxtp_1
XPHY_EDGE_ROW_83_Right_83 VGND VGND VPWR VPWR sky130_fd_sc_hd__decap_3
X_9268_ clknet_leaf_77_clk _0365_ VGND VGND VPWR VPWR registers\[27\]\[20\] sky130_fd_sc_hd__dfxtp_1
XFILLER_0_30_554 VGND VGND VPWR VPWR sky130_fd_sc_hd__fill_2
X_8219_ _4052_ VGND VGND VPWR VPWR _0511_ sky130_fd_sc_hd__clkbuf_1
XFILLER_0_100_442 VGND VGND VPWR VPWR sky130_fd_sc_hd__decap_3
X_9199_ clknet_leaf_66_clk _0296_ VGND VGND VPWR VPWR registers\[25\]\[15\] sky130_fd_sc_hd__dfxtp_1
XPHY_EDGE_ROW_58_Left_178 VGND VGND VPWR VPWR sky130_fd_sc_hd__decap_3
XANTENNA__5316__S1 _1774_ VGND VGND VPWR VPWR sky130_fd_sc_hd__diode_2
XANTENNA__6463__A net18 VGND VGND VPWR VPWR sky130_fd_sc_hd__diode_2
XANTENNA__8154__S _4009_ VGND VGND VPWR VPWR sky130_fd_sc_hd__diode_2
XPHY_EDGE_ROW_92_Right_92 VGND VGND VPWR VPWR sky130_fd_sc_hd__decap_3
XFILLER_0_69_278 VGND VGND VPWR VPWR sky130_fd_sc_hd__fill_2
XFILLER_0_57_418 VGND VGND VPWR VPWR sky130_fd_sc_hd__fill_2
XFILLER_0_84_237 VGND VGND VPWR VPWR sky130_fd_sc_hd__fill_2
XANTENNA__4827__S0 _1433_ VGND VGND VPWR VPWR sky130_fd_sc_hd__diode_2
XFILLER_0_38_643 VGND VGND VPWR VPWR sky130_fd_sc_hd__fill_1
XTAP_TAPCELL_ROW_13_424 VGND VPWR sky130_fd_sc_hd__tapvpwrvgnd_1
XPHY_EDGE_ROW_67_Left_187 VGND VGND VPWR VPWR sky130_fd_sc_hd__decap_3
XANTENNA__7146__A1 _3476_ VGND VGND VPWR VPWR sky130_fd_sc_hd__diode_2
XTAP_TAPCELL_ROW_96_1507 VGND VPWR sky130_fd_sc_hd__tapvpwrvgnd_1
XANTENNA__5157__B1 _1655_ VGND VGND VPWR VPWR sky130_fd_sc_hd__diode_2
XFILLER_0_80_421 VGND VGND VPWR VPWR sky130_fd_sc_hd__fill_2
XTAP_TAPCELL_ROW_41_788 VGND VPWR sky130_fd_sc_hd__tapvpwrvgnd_1
XFILLER_0_25_337 VGND VGND VPWR VPWR sky130_fd_sc_hd__fill_1
XFILLER_0_25_359 VGND VGND VPWR VPWR sky130_fd_sc_hd__fill_2
XFILLER_0_108_597 VGND VGND VPWR VPWR sky130_fd_sc_hd__fill_2
XANTENNA__5252__S0 _1996_ VGND VGND VPWR VPWR sky130_fd_sc_hd__diode_2
XFILLER_0_111_729 VGND VGND VPWR VPWR sky130_fd_sc_hd__fill_2
XFILLER_0_80_498 VGND VGND VPWR VPWR sky130_fd_sc_hd__fill_2
XANTENNA__5004__S0 _1763_ VGND VGND VPWR VPWR sky130_fd_sc_hd__diode_2
XANTENNA__4857__S _1621_ VGND VGND VPWR VPWR sky130_fd_sc_hd__diode_2
XFILLER_0_21_576 VGND VGND VPWR VPWR sky130_fd_sc_hd__fill_2
XPHY_EDGE_ROW_76_Left_196 VGND VGND VPWR VPWR sky130_fd_sc_hd__decap_3
XFILLER_0_29_67 VGND VGND VPWR VPWR sky130_fd_sc_hd__fill_2
XFILLER_0_45_11 VGND VGND VPWR VPWR sky130_fd_sc_hd__fill_1
XANTENNA__5307__S1 _1774_ VGND VGND VPWR VPWR sky130_fd_sc_hd__diode_2
X_5920_ _1286_ _2394_ VGND VGND VPWR VPWR _2643_ sky130_fd_sc_hd__nor2_1
XTAP_TAPCELL_ROW_49_899 VGND VPWR sky130_fd_sc_hd__tapvpwrvgnd_1
XANTENNA__8064__S _3936_ VGND VGND VPWR VPWR sky130_fd_sc_hd__diode_2
XFILLER_0_45_88 VGND VGND VPWR VPWR sky130_fd_sc_hd__fill_2
XTAP_TAPCELL_ROW_105_1625 VGND VPWR sky130_fd_sc_hd__tapvpwrvgnd_1
XFILLER_0_48_418 VGND VGND VPWR VPWR sky130_fd_sc_hd__fill_2
XFILLER_0_48_407 VGND VGND VPWR VPWR sky130_fd_sc_hd__decap_4
XFILLER_0_0_13 VPWR VGND VPWR VGND sky130_ef_sc_hd__decap_12
X_5851_ _2549_ _2557_ _2576_ VGND VGND VPWR VPWR _2578_ sky130_fd_sc_hd__o21ai_1
XFILLER_0_0_57 VPWR VGND VPWR VGND sky130_ef_sc_hd__decap_12
XFILLER_0_29_621 VGND VGND VPWR VPWR sky130_fd_sc_hd__decap_3
XFILLER_0_118_339 VGND VGND VPWR VPWR sky130_fd_sc_hd__decap_4
X_5782_ net138 _2510_ _2511_ _2317_ VGND VGND VPWR VPWR _2512_ sky130_fd_sc_hd__a211o_1
XPHY_EDGE_ROW_100_Right_100 VGND VGND VPWR VPWR sky130_fd_sc_hd__decap_3
XFILLER_0_91_708 VGND VGND VPWR VPWR sky130_fd_sc_hd__decap_3
XFILLER_0_61_76 VGND VGND VPWR VPWR sky130_fd_sc_hd__fill_2
XFILLER_0_8_537 VGND VGND VPWR VPWR sky130_fd_sc_hd__fill_2
X_4802_ registers\[28\]\[29\] registers\[29\]\[29\] registers\[30\]\[29\] registers\[31\]\[29\]
+ _1555_ _1556_ VGND VGND VPWR VPWR _1573_ sky130_fd_sc_hd__mux4_1
X_8570_ clknet_leaf_77_clk _0691_ VGND VGND VPWR VPWR registers\[19\]\[26\] sky130_fd_sc_hd__dfxtp_1
XFILLER_0_28_131 VGND VGND VPWR VPWR sky130_fd_sc_hd__fill_2
XANTENNA__4294__S1 _1061_ VGND VGND VPWR VPWR sky130_fd_sc_hd__diode_2
XTAP_TAPCELL_ROW_64_1090 VGND VPWR sky130_fd_sc_hd__tapvpwrvgnd_1
XFILLER_0_56_462 VGND VGND VPWR VPWR sky130_fd_sc_hd__fill_2
XFILLER_0_8_559 VGND VGND VPWR VPWR sky130_fd_sc_hd__fill_2
X_4733_ registers\[12\]\[25\] registers\[13\]\[25\] registers\[14\]\[25\] registers\[15\]\[25\]
+ _1415_ _1416_ VGND VGND VPWR VPWR _1508_ sky130_fd_sc_hd__mux4_1
XANTENNA__8334__A0 _3022_ VGND VGND VPWR VPWR sky130_fd_sc_hd__diode_2
X_7521_ _3133_ registers\[21\]\[31\] _3647_ VGND VGND VPWR VPWR _3682_ sky130_fd_sc_hd__mux2_1
XFILLER_0_29_676 VGND VGND VPWR VPWR sky130_fd_sc_hd__fill_2
XFILLER_0_29_698 VGND VGND VPWR VPWR sky130_fd_sc_hd__fill_2
XFILLER_0_114_512 VGND VGND VPWR VPWR sky130_fd_sc_hd__fill_2
XFILLER_0_114_501 VGND VGND VPWR VPWR sky130_fd_sc_hd__fill_2
X_7452_ _3645_ VGND VGND VPWR VPWR _0151_ sky130_fd_sc_hd__clkbuf_1
XFILLER_0_16_337 VGND VGND VPWR VPWR sky130_fd_sc_hd__fill_2
XANTENNA__5243__S0 _1690_ VGND VGND VPWR VPWR sky130_fd_sc_hd__diode_2
XFILLER_0_9_55 VGND VGND VPWR VPWR sky130_fd_sc_hd__fill_1
X_6403_ registers\[3\]\[21\] _3006_ _3052_ VGND VGND VPWR VPWR _3054_ sky130_fd_sc_hd__mux2_1
X_4664_ registers\[16\]\[21\] registers\[17\]\[21\] registers\[18\]\[21\] registers\[19\]\[21\]
+ _1427_ _1428_ VGND VGND VPWR VPWR _1443_ sky130_fd_sc_hd__mux4_1
X_4595_ registers\[24\]\[18\] registers\[25\]\[18\] registers\[26\]\[18\] registers\[27\]\[18\]
+ _1338_ _1339_ VGND VGND VPWR VPWR _1377_ sky130_fd_sc_hd__mux4_1
X_7383_ _3608_ VGND VGND VPWR VPWR _0119_ sky130_fd_sc_hd__clkbuf_1
XTAP_TAPCELL_ROW_116_1765 VGND VPWR sky130_fd_sc_hd__tapvpwrvgnd_1
XFILLER_0_101_93 VGND VGND VPWR VPWR sky130_fd_sc_hd__decap_4
X_6334_ _3013_ VGND VGND VPWR VPWR _0689_ sky130_fd_sc_hd__clkbuf_1
X_9122_ clknet_leaf_1_clk _0219_ VGND VGND VPWR VPWR registers\[23\]\[2\] sky130_fd_sc_hd__dfxtp_1
XANTENNA__8239__S _4056_ VGND VGND VPWR VPWR sky130_fd_sc_hd__diode_2
X_9053_ clknet_leaf_103_clk _0150_ VGND VGND VPWR VPWR registers\[20\]\[29\] sky130_fd_sc_hd__dfxtp_1
XANTENNA__4767__S _1379_ VGND VGND VPWR VPWR sky130_fd_sc_hd__diode_2
X_6265_ registers\[19\]\[2\] _2966_ _2962_ VGND VGND VPWR VPWR _2967_ sky130_fd_sc_hd__mux2_1
X_5216_ _1964_ _1965_ _1746_ VGND VGND VPWR VPWR _1966_ sky130_fd_sc_hd__mux2_1
X_8004_ registers\[2\]\[1\] _3437_ _3937_ VGND VGND VPWR VPWR _3939_ sky130_fd_sc_hd__mux2_1
XANTENNA__5452__A _2076_ VGND VGND VPWR VPWR sky130_fd_sc_hd__diode_2
XANTENNA__4349__A1_N _1109_ VGND VGND VPWR VPWR sky130_fd_sc_hd__diode_2
X_6196_ net100 _2882_ _2884_ VGND VGND VPWR VPWR _2904_ sky130_fd_sc_hd__a21o_1
X_5147_ registers\[16\]\[14\] registers\[17\]\[14\] registers\[18\]\[14\] registers\[19\]\[14\]
+ _1810_ _1811_ VGND VGND VPWR VPWR _1901_ sky130_fd_sc_hd__mux4_1
X_5078_ registers\[20\]\[10\] registers\[21\]\[10\] registers\[22\]\[10\] registers\[23\]\[10\]
+ _1757_ _1814_ VGND VGND VPWR VPWR _1836_ sky130_fd_sc_hd__mux4_1
XFILLER_0_98_329 VGND VGND VPWR VPWR sky130_fd_sc_hd__fill_2
X_8906_ clknet_leaf_37_clk _0003_ VGND VGND VPWR VPWR registers\[16\]\[10\] sky130_fd_sc_hd__dfxtp_1
XFILLER_0_79_554 VGND VGND VPWR VPWR sky130_fd_sc_hd__fill_2
X_8837_ clknet_leaf_27_clk _0958_ VGND VGND VPWR VPWR registers\[14\]\[5\] sky130_fd_sc_hd__dfxtp_1
XANTENNA__7376__A1 _3491_ VGND VGND VPWR VPWR sky130_fd_sc_hd__diode_2
X_8768_ clknet_leaf_2_clk _0889_ VGND VGND VPWR VPWR registers\[12\]\[0\] sky130_fd_sc_hd__dfxtp_1
X_7719_ _3787_ VGND VGND VPWR VPWR _0276_ sky130_fd_sc_hd__clkbuf_1
XFILLER_0_35_613 VGND VGND VPWR VPWR sky130_fd_sc_hd__decap_3
XANTENNA__4285__S1 _1027_ VGND VGND VPWR VPWR sky130_fd_sc_hd__diode_2
XANTENNA__5627__A _2317_ VGND VGND VPWR VPWR sky130_fd_sc_hd__diode_2
XFILLER_0_105_501 VGND VGND VPWR VPWR sky130_fd_sc_hd__decap_3
XFILLER_0_74_281 VGND VGND VPWR VPWR sky130_fd_sc_hd__decap_4
X_8699_ clknet_leaf_101_clk _0820_ VGND VGND VPWR VPWR registers\[0\]\[27\] sky130_fd_sc_hd__dfxtp_1
XFILLER_0_117_383 VGND VGND VPWR VPWR sky130_fd_sc_hd__fill_2
XANTENNA__6887__A0 _3079_ VGND VGND VPWR VPWR sky130_fd_sc_hd__diode_2
XANTENNA__5234__S0 _1719_ VGND VGND VPWR VPWR sky130_fd_sc_hd__diode_2
XFILLER_0_34_145 VGND VGND VPWR VPWR sky130_fd_sc_hd__fill_2
XFILLER_0_22_318 VGND VGND VPWR VPWR sky130_fd_sc_hd__fill_2
XTAP_TAPCELL_ROW_91_1437 VGND VPWR sky130_fd_sc_hd__tapvpwrvgnd_1
XTAP_TAPCELL_ROW_91_1448 VGND VPWR sky130_fd_sc_hd__tapvpwrvgnd_1
XANTENNA__7300__A1 _3483_ VGND VGND VPWR VPWR sky130_fd_sc_hd__diode_2
XFILLER_0_30_384 VGND VGND VPWR VPWR sky130_fd_sc_hd__fill_2
XANTENNA__7988__S _3923_ VGND VGND VPWR VPWR sky130_fd_sc_hd__diode_2
XANTENNA_input34_A wd3[26] VGND VGND VPWR VPWR sky130_fd_sc_hd__diode_2
XFILLER_0_106_27 VGND VGND VPWR VPWR sky130_fd_sc_hd__fill_1
XANTENNA__5075__C1 _1702_ VGND VGND VPWR VPWR sky130_fd_sc_hd__diode_2
XFILLER_0_97_362 VGND VGND VPWR VPWR sky130_fd_sc_hd__fill_1
XTAP_TAPCELL_ROW_46_858 VGND VPWR sky130_fd_sc_hd__tapvpwrvgnd_1
XFILLER_0_58_727 VGND VGND VPWR VPWR sky130_fd_sc_hd__decap_3
XANTENNA__5917__A2 _2587_ VGND VGND VPWR VPWR sky130_fd_sc_hd__diode_2
XFILLER_0_72_218 VGND VGND VPWR VPWR sky130_fd_sc_hd__fill_2
XFILLER_0_38_451 VGND VGND VPWR VPWR sky130_fd_sc_hd__fill_2
XTAP_TAPCELL_ROW_26_593 VGND VPWR sky130_fd_sc_hd__tapvpwrvgnd_1
XANTENNA__4276__S1 _1040_ VGND VGND VPWR VPWR sky130_fd_sc_hd__diode_2
XANTENNA__5537__A net139 VGND VGND VPWR VPWR sky130_fd_sc_hd__diode_2
XTAP_TAPCELL_ROW_100_1555 VGND VPWR sky130_fd_sc_hd__tapvpwrvgnd_1
XFILLER_0_38_484 VGND VGND VPWR VPWR sky130_fd_sc_hd__fill_2
XANTENNA__7228__S _3525_ VGND VGND VPWR VPWR sky130_fd_sc_hd__diode_2
XFILLER_0_31_57 VGND VGND VPWR VPWR sky130_fd_sc_hd__fill_2
XFILLER_0_31_68 VGND VGND VPWR VPWR sky130_fd_sc_hd__fill_1
XANTENNA__8316__A0 _3003_ VGND VGND VPWR VPWR sky130_fd_sc_hd__diode_2
XANTENNA__5225__S0 _1758_ VGND VGND VPWR VPWR sky130_fd_sc_hd__diode_2
XFILLER_0_111_537 VGND VGND VPWR VPWR sky130_fd_sc_hd__fill_2
X_4380_ _1172_ _1173_ _1117_ VGND VGND VPWR VPWR _1174_ sky130_fd_sc_hd__mux2_1
XPHY_EDGE_ROW_84_Left_204 VGND VGND VPWR VPWR sky130_fd_sc_hd__decap_3
XFILLER_0_21_373 VGND VGND VPWR VPWR sky130_fd_sc_hd__fill_2
XANTENNA__5272__A _1754_ VGND VGND VPWR VPWR sky130_fd_sc_hd__diode_2
X_6050_ net139 _2271_ VGND VGND VPWR VPWR _2766_ sky130_fd_sc_hd__nand2_2
X_5001_ _1762_ VGND VGND VPWR VPWR _1763_ sky130_fd_sc_hd__buf_6
XFILLER_0_56_54 VGND VGND VPWR VPWR sky130_fd_sc_hd__fill_2
XANTENNA__5605__A1 _1882_ VGND VGND VPWR VPWR sky130_fd_sc_hd__diode_2
XPHY_EDGE_ROW_93_Left_213 VGND VGND VPWR VPWR sky130_fd_sc_hd__decap_3
XFILLER_0_76_502 VGND VGND VPWR VPWR sky130_fd_sc_hd__fill_2
X_6952_ _3075_ registers\[14\]\[3\] _3361_ VGND VGND VPWR VPWR _3365_ sky130_fd_sc_hd__mux2_1
XFILLER_0_76_524 VGND VGND VPWR VPWR sky130_fd_sc_hd__fill_1
X_5903_ _2551_ _2576_ _2599_ _2612_ VGND VGND VPWR VPWR _2627_ sky130_fd_sc_hd__and4b_1
X_6883_ _3075_ registers\[13\]\[3\] _3324_ VGND VGND VPWR VPWR _3328_ sky130_fd_sc_hd__mux2_1
X_8622_ clknet_leaf_54_clk _0743_ VGND VGND VPWR VPWR registers\[29\]\[14\] sky130_fd_sc_hd__dfxtp_1
X_5834_ _2266_ _2561_ VGND VGND VPWR VPWR _2562_ sky130_fd_sc_hd__or2_1
XFILLER_0_76_557 VGND VGND VPWR VPWR sky130_fd_sc_hd__fill_2
XFILLER_0_76_546 VGND VGND VPWR VPWR sky130_fd_sc_hd__fill_2
XFILLER_0_8_301 VGND VGND VPWR VPWR sky130_fd_sc_hd__fill_2
XANTENNA__8522__S _4211_ VGND VGND VPWR VPWR sky130_fd_sc_hd__diode_2
XFILLER_0_118_125 VGND VGND VPWR VPWR sky130_fd_sc_hd__fill_2
XANTENNA__4267__S1 _1061_ VGND VGND VPWR VPWR sky130_fd_sc_hd__diode_2
XFILLER_0_8_345 VGND VGND VPWR VPWR sky130_fd_sc_hd__fill_1
X_5765_ _1090_ _2495_ VGND VGND VPWR VPWR _2496_ sky130_fd_sc_hd__and2_1
X_8553_ clknet_leaf_12_clk _0674_ VGND VGND VPWR VPWR registers\[19\]\[9\] sky130_fd_sc_hd__dfxtp_1
XFILLER_0_16_101 VGND VGND VPWR VPWR sky130_fd_sc_hd__fill_2
XANTENNA__6042__S _2344_ VGND VGND VPWR VPWR sky130_fd_sc_hd__diode_2
X_5696_ _2328_ VGND VGND VPWR VPWR _2429_ sky130_fd_sc_hd__clkbuf_4
X_8484_ registers\[4\]\[3\] net41 _4189_ VGND VGND VPWR VPWR _4193_ sky130_fd_sc_hd__mux2_1
X_4716_ registers\[4\]\[24\] registers\[5\]\[24\] registers\[6\]\[24\] registers\[7\]\[24\]
+ _1433_ _1434_ VGND VGND VPWR VPWR _1492_ sky130_fd_sc_hd__mux4_1
XFILLER_0_16_145 VGND VGND VPWR VPWR sky130_fd_sc_hd__fill_1
XFILLER_0_16_156 VGND VGND VPWR VPWR sky130_fd_sc_hd__decap_4
X_7504_ _3673_ VGND VGND VPWR VPWR _0175_ sky130_fd_sc_hd__clkbuf_1
XFILLER_0_114_331 VGND VGND VPWR VPWR sky130_fd_sc_hd__fill_2
XFILLER_0_112_81 VGND VGND VPWR VPWR sky130_fd_sc_hd__fill_1
XANTENNA__6977__S _3372_ VGND VGND VPWR VPWR sky130_fd_sc_hd__diode_2
X_4647_ _1320_ VGND VGND VPWR VPWR _1427_ sky130_fd_sc_hd__buf_4
XFILLER_0_16_178 VGND VGND VPWR VPWR sky130_fd_sc_hd__decap_4
X_7435_ registers\[20\]\[22\] _3481_ _3634_ VGND VGND VPWR VPWR _3637_ sky130_fd_sc_hd__mux2_1
XFILLER_0_32_638 VGND VGND VPWR VPWR sky130_fd_sc_hd__fill_2
XANTENNA__5881__S _2344_ VGND VGND VPWR VPWR sky130_fd_sc_hd__diode_2
XFILLER_0_102_526 VGND VGND VPWR VPWR sky130_fd_sc_hd__fill_2
XANTENNA__5541__B1 _2276_ VGND VGND VPWR VPWR sky130_fd_sc_hd__diode_2
XFILLER_0_4_584 VGND VGND VPWR VPWR sky130_fd_sc_hd__fill_2
XFILLER_0_25_690 VGND VGND VPWR VPWR sky130_fd_sc_hd__fill_1
XFILLER_0_31_148 VGND VGND VPWR VPWR sky130_fd_sc_hd__decap_3
X_7366_ registers\[1\]\[22\] _3481_ _3597_ VGND VGND VPWR VPWR _3600_ sky130_fd_sc_hd__mux2_1
X_9105_ clknet_leaf_54_clk _0202_ VGND VGND VPWR VPWR registers\[22\]\[17\] sky130_fd_sc_hd__dfxtp_1
X_4578_ _1357_ _1358_ _1359_ _1360_ _1132_ _1135_ VGND VGND VPWR VPWR _1361_ sky130_fd_sc_hd__mux4_2
XFILLER_0_97_83 VGND VGND VPWR VPWR sky130_fd_sc_hd__fill_2
X_6317_ registers\[19\]\[19\] _3001_ _2983_ VGND VGND VPWR VPWR _3002_ sky130_fd_sc_hd__mux2_1
X_7297_ _3563_ VGND VGND VPWR VPWR _0078_ sky130_fd_sc_hd__clkbuf_1
XFILLER_0_110_581 VGND VGND VPWR VPWR sky130_fd_sc_hd__decap_6
X_9036_ clknet_leaf_43_clk _0133_ VGND VGND VPWR VPWR registers\[20\]\[12\] sky130_fd_sc_hd__dfxtp_1
X_6248_ _2380_ _2383_ net124 VGND VGND VPWR VPWR _2953_ sky130_fd_sc_hd__a21o_1
X_6179_ _2245_ _2247_ net113 VGND VGND VPWR VPWR _2888_ sky130_fd_sc_hd__mux2_1
XFILLER_0_99_638 VGND VGND VPWR VPWR sky130_fd_sc_hd__fill_2
XFILLER_0_99_627 VGND VGND VPWR VPWR sky130_fd_sc_hd__fill_2
XFILLER_0_99_605 VGND VGND VPWR VPWR sky130_fd_sc_hd__decap_8
XANTENNA__7601__S _3720_ VGND VGND VPWR VPWR sky130_fd_sc_hd__diode_2
XFILLER_0_79_340 VGND VGND VPWR VPWR sky130_fd_sc_hd__fill_1
XFILLER_0_79_373 VGND VGND VPWR VPWR sky130_fd_sc_hd__fill_2
XTAP_TAPCELL_ROW_43_817 VGND VPWR sky130_fd_sc_hd__tapvpwrvgnd_1
XFILLER_0_39_204 VGND VGND VPWR VPWR sky130_fd_sc_hd__fill_1
XANTENNA__4258__S1 _1054_ VGND VGND VPWR VPWR sky130_fd_sc_hd__diode_2
XANTENNA__5455__S0 _2126_ VGND VGND VPWR VPWR sky130_fd_sc_hd__diode_2
XFILLER_0_75_590 VGND VGND VPWR VPWR sky130_fd_sc_hd__fill_2
XANTENNA__7048__S _3409_ VGND VGND VPWR VPWR sky130_fd_sc_hd__diode_2
XTAP_TAPCELL_ROW_23_552 VGND VPWR sky130_fd_sc_hd__tapvpwrvgnd_1
XTAP_TAPCELL_ROW_23_563 VGND VPWR sky130_fd_sc_hd__tapvpwrvgnd_1
XFILLER_0_118_681 VPWR VGND VPWR VGND sky130_ef_sc_hd__decap_12
XFILLER_0_90_560 VGND VGND VPWR VPWR sky130_fd_sc_hd__decap_6
XANTENNA__4583__A1 _1362_ VGND VGND VPWR VPWR sky130_fd_sc_hd__diode_2
XANTENNA__4261__A a2[0] VGND VGND VPWR VPWR sky130_fd_sc_hd__diode_2
XFILLER_0_105_353 VGND VGND VPWR VPWR sky130_fd_sc_hd__decap_8
XANTENNA__6887__S _3324_ VGND VGND VPWR VPWR sky130_fd_sc_hd__diode_2
XFILLER_0_50_468 VGND VGND VPWR VPWR sky130_fd_sc_hd__decap_6
XFILLER_0_16_690 VGND VGND VPWR VPWR sky130_fd_sc_hd__decap_3
XFILLER_0_105_397 VGND VGND VPWR VPWR sky130_fd_sc_hd__fill_1
XFILLER_0_30_192 VGND VGND VPWR VPWR sky130_fd_sc_hd__fill_2
XANTENNA__5835__A1 _2353_ VGND VGND VPWR VPWR sky130_fd_sc_hd__diode_2
XFILLER_0_117_15 VPWR VGND VPWR VGND sky130_ef_sc_hd__decap_12
XANTENNA__7511__S _3670_ VGND VGND VPWR VPWR sky130_fd_sc_hd__diode_2
XFILLER_0_89_126 VGND VGND VPWR VPWR sky130_fd_sc_hd__fill_1
XFILLER_0_58_524 VGND VGND VPWR VPWR sky130_fd_sc_hd__decap_8
XANTENNA__8342__S _4117_ VGND VGND VPWR VPWR sky130_fd_sc_hd__diode_2
XFILLER_0_42_56 VGND VGND VPWR VPWR sky130_fd_sc_hd__fill_2
XFILLER_0_42_45 VGND VGND VPWR VPWR sky130_fd_sc_hd__decap_3
Xclkbuf_leaf_70_clk clknet_4_11_0_clk VGND VGND VPWR VPWR clknet_leaf_70_clk sky130_fd_sc_hd__clkbuf_8
XANTENNA__5446__S0 _2119_ VGND VGND VPWR VPWR sky130_fd_sc_hd__diode_2
XFILLER_0_26_421 VGND VGND VPWR VPWR sky130_fd_sc_hd__fill_2
X_5550_ _2282_ _2285_ _1072_ VGND VGND VPWR VPWR _2286_ sky130_fd_sc_hd__mux2_1
XFILLER_0_5_337 VGND VGND VPWR VPWR sky130_fd_sc_hd__decap_4
XFILLER_0_14_605 VGND VGND VPWR VPWR sky130_fd_sc_hd__fill_1
X_4501_ registers\[16\]\[13\] registers\[17\]\[13\] registers\[18\]\[13\] registers\[19\]\[13\]
+ _1167_ _1168_ VGND VGND VPWR VPWR _1288_ sky130_fd_sc_hd__mux4_1
X_5481_ _1050_ VGND VGND VPWR VPWR _2217_ sky130_fd_sc_hd__buf_2
XANTENNA__6797__S _3272_ VGND VGND VPWR VPWR sky130_fd_sc_hd__diode_2
X_7220_ _3522_ VGND VGND VPWR VPWR _0042_ sky130_fd_sc_hd__clkbuf_1
X_4432_ _1073_ _1215_ _1223_ VGND VGND VPWR VPWR _1224_ sky130_fd_sc_hd__o21a_1
XTAP_TAPCELL_ROW_113_1724 VGND VPWR sky130_fd_sc_hd__tapvpwrvgnd_1
XANTENNA__4421__S1 _1054_ VGND VGND VPWR VPWR sky130_fd_sc_hd__diode_2
XFILLER_0_1_521 VGND VGND VPWR VPWR sky130_fd_sc_hd__decap_4
XFILLER_0_22_660 VGND VGND VPWR VPWR sky130_fd_sc_hd__fill_2
X_4363_ _1124_ _1157_ VGND VGND VPWR VPWR _1158_ sky130_fd_sc_hd__nand2_1
XANTENNA__5206__S _1746_ VGND VGND VPWR VPWR sky130_fd_sc_hd__diode_2
X_7151_ net30 VGND VGND VPWR VPWR _3481_ sky130_fd_sc_hd__buf_2
X_4294_ registers\[20\]\[3\] registers\[21\]\[3\] registers\[22\]\[3\] registers\[23\]\[3\]
+ _1060_ _1061_ VGND VGND VPWR VPWR _1091_ sky130_fd_sc_hd__mux4_1
X_6102_ net125 _2659_ net126 _2207_ VGND VGND VPWR VPWR _2815_ sky130_fd_sc_hd__or4b_2
X_7082_ _2959_ _3173_ VGND VGND VPWR VPWR _3434_ sky130_fd_sc_hd__nor2_4
XFILLER_0_6_89 VGND VGND VPWR VPWR sky130_fd_sc_hd__fill_2
XFILLER_0_67_86 VGND VGND VPWR VPWR sky130_fd_sc_hd__fill_2
XANTENNA__8517__S _4200_ VGND VGND VPWR VPWR sky130_fd_sc_hd__diode_2
X_6033_ _2207_ _2706_ _2707_ VGND VGND VPWR VPWR _2750_ sky130_fd_sc_hd__a21oi_2
XFILLER_0_83_74 VGND VGND VPWR VPWR sky130_fd_sc_hd__fill_2
XANTENNA__4346__A net8 VGND VGND VPWR VPWR sky130_fd_sc_hd__diode_2
X_7984_ _3012_ registers\[28\]\[24\] _3923_ VGND VGND VPWR VPWR _3928_ sky130_fd_sc_hd__mux2_1
XFILLER_0_95_107 VGND VGND VPWR VPWR sky130_fd_sc_hd__fill_2
XANTENNA__6251__A1 net138 VGND VGND VPWR VPWR sky130_fd_sc_hd__diode_2
X_6935_ _3127_ registers\[13\]\[28\] _3346_ VGND VGND VPWR VPWR _3355_ sky130_fd_sc_hd__mux2_1
XTAP_TAPCELL_ROW_1_269 VGND VPWR sky130_fd_sc_hd__tapvpwrvgnd_1
XFILLER_0_119_401 VGND VGND VPWR VPWR sky130_fd_sc_hd__fill_2
XANTENNA__8252__S _4067_ VGND VGND VPWR VPWR sky130_fd_sc_hd__diode_2
XFILLER_0_119_445 VGND VGND VPWR VPWR sky130_fd_sc_hd__decap_3
Xclkbuf_leaf_61_clk clknet_4_14_0_clk VGND VGND VPWR VPWR clknet_leaf_61_clk sky130_fd_sc_hd__clkbuf_8
X_6866_ _3318_ VGND VGND VPWR VPWR _0916_ sky130_fd_sc_hd__clkbuf_1
XFILLER_0_107_607 VGND VGND VPWR VPWR sky130_fd_sc_hd__fill_1
X_5817_ _2534_ _2542_ _2545_ VGND VGND VPWR VPWR _2546_ sky130_fd_sc_hd__or3b_1
XFILLER_0_64_549 VGND VGND VPWR VPWR sky130_fd_sc_hd__fill_2
XANTENNA__5177__A _1929_ VGND VGND VPWR VPWR sky130_fd_sc_hd__diode_2
X_6797_ registers\[11\]\[28\] _3020_ _3272_ VGND VGND VPWR VPWR _3281_ sky130_fd_sc_hd__mux2_1
X_8605_ clknet_leaf_108_clk _0726_ VGND VGND VPWR VPWR registers\[3\]\[29\] sky130_fd_sc_hd__dfxtp_1
XFILLER_0_106_128 VGND VGND VPWR VPWR sky130_fd_sc_hd__decap_4
X_5748_ _2434_ _2436_ _2433_ VGND VGND VPWR VPWR _2480_ sky130_fd_sc_hd__a21o_1
X_8536_ registers\[4\]\[28\] net36 _4211_ VGND VGND VPWR VPWR _4220_ sky130_fd_sc_hd__mux2_1
XFILLER_0_8_197 VGND VGND VPWR VPWR sky130_fd_sc_hd__fill_2
XTAP_TAPCELL_ROW_20_522 VGND VPWR sky130_fd_sc_hd__tapvpwrvgnd_1
XFILLER_0_115_673 VPWR VGND VPWR VGND sky130_ef_sc_hd__decap_12
X_5679_ _2266_ _2261_ VGND VGND VPWR VPWR _2413_ sky130_fd_sc_hd__or2_2
XANTENNA__5905__A net83 VGND VGND VPWR VPWR sky130_fd_sc_hd__diode_2
XFILLER_0_44_295 VGND VGND VPWR VPWR sky130_fd_sc_hd__fill_2
X_8467_ _4183_ VGND VGND VPWR VPWR _0628_ sky130_fd_sc_hd__clkbuf_1
X_7418_ registers\[20\]\[14\] _3464_ _3623_ VGND VGND VPWR VPWR _3628_ sky130_fd_sc_hd__mux2_1
XTAP_TAPCELL_ROW_75_1229 VGND VPWR sky130_fd_sc_hd__tapvpwrvgnd_1
X_8398_ registers\[5\]\[27\] _3491_ _4139_ VGND VGND VPWR VPWR _4147_ sky130_fd_sc_hd__mux2_1
X_7349_ registers\[1\]\[14\] _3464_ _3586_ VGND VGND VPWR VPWR _3591_ sky130_fd_sc_hd__mux2_1
XANTENNA__4412__S1 _1204_ VGND VGND VPWR VPWR sky130_fd_sc_hd__diode_2
XANTENNA__5116__S _1695_ VGND VGND VPWR VPWR sky130_fd_sc_hd__diode_2
XANTENNA__5624__B _1106_ VGND VGND VPWR VPWR sky130_fd_sc_hd__diode_2
XFILLER_0_12_192 VGND VGND VPWR VPWR sky130_fd_sc_hd__fill_2
X_9019_ clknet_leaf_106_clk _0116_ VGND VGND VPWR VPWR registers\[1\]\[27\] sky130_fd_sc_hd__dfxtp_1
XTAP_TAPCELL_ROW_28_622 VGND VPWR sky130_fd_sc_hd__tapvpwrvgnd_1
XFILLER_0_86_129 VGND VGND VPWR VPWR sky130_fd_sc_hd__decap_4
XFILLER_0_95_652 VGND VGND VPWR VPWR sky130_fd_sc_hd__fill_2
XFILLER_0_79_181 VGND VGND VPWR VPWR sky130_fd_sc_hd__fill_2
XTAP_TAPCELL_ROW_56_986 VGND VPWR sky130_fd_sc_hd__tapvpwrvgnd_1
Xclkbuf_leaf_52_clk clknet_4_13_0_clk VGND VGND VPWR VPWR clknet_leaf_52_clk sky130_fd_sc_hd__clkbuf_8
XFILLER_0_55_505 VGND VGND VPWR VPWR sky130_fd_sc_hd__fill_2
XFILLER_0_67_387 VGND VGND VPWR VPWR sky130_fd_sc_hd__fill_2
XFILLER_0_51_711 VGND VGND VPWR VPWR sky130_fd_sc_hd__decap_8
XFILLER_0_112_109 VGND VGND VPWR VPWR sky130_fd_sc_hd__fill_2
XFILLER_0_106_684 VGND VGND VPWR VPWR sky130_fd_sc_hd__fill_2
XANTENNA__4308__B2 _1034_ VGND VGND VPWR VPWR sky130_fd_sc_hd__diode_2
XFILLER_0_50_298 VGND VGND VPWR VPWR sky130_fd_sc_hd__fill_1
XANTENNA__5026__S _1634_ VGND VGND VPWR VPWR sky130_fd_sc_hd__diode_2
Xoutput70 net70 VGND VGND VPWR VPWR alu_result[29] sky130_fd_sc_hd__buf_1
Xoutput81 net81 VGND VGND VPWR VPWR rd1[0] sky130_fd_sc_hd__buf_1
Xoutput92 net92 VGND VGND VPWR VPWR rd1[1] sky130_fd_sc_hd__buf_1
XFILLER_0_78_619 VGND VGND VPWR VPWR sky130_fd_sc_hd__fill_2
XFILLER_0_77_129 VGND VGND VPWR VPWR sky130_fd_sc_hd__decap_6
X_4981_ _1679_ VGND VGND VPWR VPWR _1743_ sky130_fd_sc_hd__buf_4
XFILLER_0_86_652 VGND VGND VPWR VPWR sky130_fd_sc_hd__fill_2
XFILLER_0_53_55 VGND VGND VPWR VPWR sky130_fd_sc_hd__fill_1
XANTENNA__7477__A _3647_ VGND VGND VPWR VPWR sky130_fd_sc_hd__diode_2
XANTENNA__4244__B1 _1034_ VGND VGND VPWR VPWR sky130_fd_sc_hd__diode_2
XFILLER_0_86_685 VPWR VGND VPWR VGND sky130_ef_sc_hd__decap_12
Xclkbuf_leaf_43_clk clknet_4_6_0_clk VGND VGND VPWR VPWR clknet_leaf_43_clk sky130_fd_sc_hd__clkbuf_8
X_6720_ _3240_ VGND VGND VPWR VPWR _0848_ sky130_fd_sc_hd__clkbuf_1
XANTENNA__8072__S _3973_ VGND VGND VPWR VPWR sky130_fd_sc_hd__diode_2
XFILLER_0_58_398 VGND VGND VPWR VPWR sky130_fd_sc_hd__decap_8
XANTENNA__4890__S1 _1629_ VGND VGND VPWR VPWR sky130_fd_sc_hd__diode_2
XANTENNA_clkbuf_leaf_9_clk_A clknet_4_1_0_clk VGND VGND VPWR VPWR sky130_fd_sc_hd__diode_2
X_6651_ _3202_ VGND VGND VPWR VPWR _0817_ sky130_fd_sc_hd__clkbuf_1
XFILLER_0_116_415 VGND VGND VPWR VPWR sky130_fd_sc_hd__fill_2
X_5602_ _1051_ _2287_ VGND VGND VPWR VPWR _2337_ sky130_fd_sc_hd__nand2_1
XANTENNA__4547__A1 _1132_ VGND VGND VPWR VPWR sky130_fd_sc_hd__diode_2
X_6582_ registers\[7\]\[25\] _3014_ _3159_ VGND VGND VPWR VPWR _3165_ sky130_fd_sc_hd__mux2_1
X_9370_ clknet_leaf_77_clk _0467_ VGND VGND VPWR VPWR registers\[30\]\[26\] sky130_fd_sc_hd__dfxtp_1
X_5533_ _2266_ _2216_ _2268_ VGND VGND VPWR VPWR _2269_ sky130_fd_sc_hd__or3_2
XFILLER_0_54_582 VGND VGND VPWR VPWR sky130_fd_sc_hd__fill_2
X_8321_ _4106_ VGND VGND VPWR VPWR _0559_ sky130_fd_sc_hd__clkbuf_1
XANTENNA__7416__S _3623_ VGND VGND VPWR VPWR sky130_fd_sc_hd__diode_2
XFILLER_0_103_109 VGND VGND VPWR VPWR sky130_fd_sc_hd__fill_1
XFILLER_0_41_221 VGND VGND VPWR VPWR sky130_fd_sc_hd__decap_3
XFILLER_0_5_167 VGND VGND VPWR VPWR sky130_fd_sc_hd__fill_1
XFILLER_0_112_632 VPWR VGND VPWR VGND sky130_ef_sc_hd__decap_12
XFILLER_0_111_120 VGND VGND VPWR VPWR sky130_fd_sc_hd__decap_3
X_5464_ net139 _2199_ VGND VGND VPWR VPWR _2200_ sky130_fd_sc_hd__nand2_2
XFILLER_0_78_41 VGND VGND VPWR VPWR sky130_fd_sc_hd__decap_6
XFILLER_0_41_243 VGND VGND VPWR VPWR sky130_fd_sc_hd__decap_3
X_8252_ registers\[6\]\[22\] _3481_ _4067_ VGND VGND VPWR VPWR _4070_ sky130_fd_sc_hd__mux2_1
XFILLER_0_112_654 VGND VGND VPWR VPWR sky130_fd_sc_hd__fill_2
X_4415_ _1073_ _1191_ _1195_ _1207_ VGND VGND VPWR VPWR _1208_ sky130_fd_sc_hd__a2bb2o_4
X_7203_ _3513_ VGND VGND VPWR VPWR _0034_ sky130_fd_sc_hd__clkbuf_1
X_8183_ _4033_ VGND VGND VPWR VPWR _0494_ sky130_fd_sc_hd__clkbuf_1
X_5395_ _1977_ _2125_ _2135_ VGND VGND VPWR VPWR _2136_ sky130_fd_sc_hd__a21oi_4
X_7134_ _3469_ VGND VGND VPWR VPWR _0009_ sky130_fd_sc_hd__clkbuf_1
X_4346_ net8 VGND VGND VPWR VPWR _1142_ sky130_fd_sc_hd__buf_4
XTAP_TAPCELL_ROW_6_339 VGND VPWR sky130_fd_sc_hd__tapvpwrvgnd_1
X_7065_ _3119_ registers\[15\]\[24\] _3420_ VGND VGND VPWR VPWR _3425_ sky130_fd_sc_hd__mux2_1
XANTENNA__5460__A _2196_ VGND VGND VPWR VPWR sky130_fd_sc_hd__diode_2
X_4277_ registers\[16\]\[2\] registers\[17\]\[2\] registers\[18\]\[2\] registers\[19\]\[2\]
+ _1039_ _1040_ VGND VGND VPWR VPWR _1075_ sky130_fd_sc_hd__mux4_1
X_6016_ _2668_ _2733_ _2460_ VGND VGND VPWR VPWR _2734_ sky130_fd_sc_hd__mux2_1
XANTENNA__6990__S _3383_ VGND VGND VPWR VPWR sky130_fd_sc_hd__diode_2
XANTENNA__6224__A1 _2413_ VGND VGND VPWR VPWR sky130_fd_sc_hd__diode_2
X_7967_ _2995_ registers\[28\]\[16\] _3912_ VGND VGND VPWR VPWR _3919_ sky130_fd_sc_hd__mux2_1
Xclkbuf_leaf_34_clk clknet_4_5_0_clk VGND VGND VPWR VPWR clknet_leaf_34_clk sky130_fd_sc_hd__clkbuf_8
X_7898_ _3882_ VGND VGND VPWR VPWR _0360_ sky130_fd_sc_hd__clkbuf_1
XTAP_TAPCELL_ROW_53_945 VGND VPWR sky130_fd_sc_hd__tapvpwrvgnd_1
X_6918_ _3323_ VGND VGND VPWR VPWR _3346_ sky130_fd_sc_hd__buf_6
XFILLER_0_119_253 VPWR VGND VPWR VGND sky130_ef_sc_hd__decap_12
X_6849_ _3309_ VGND VGND VPWR VPWR _0908_ sky130_fd_sc_hd__clkbuf_1
XFILLER_0_9_440 VGND VGND VPWR VPWR sky130_fd_sc_hd__fill_2
XANTENNA__4881__S1 _1643_ VGND VGND VPWR VPWR sky130_fd_sc_hd__diode_2
XFILLER_0_92_666 VGND VGND VPWR VPWR sky130_fd_sc_hd__decap_6
XTAP_TAPCELL_ROW_33_691 VGND VPWR sky130_fd_sc_hd__tapvpwrvgnd_1
XFILLER_0_92_699 VGND VGND VPWR VPWR sky130_fd_sc_hd__fill_1
XANTENNA__7326__S _3575_ VGND VGND VPWR VPWR sky130_fd_sc_hd__diode_2
X_8519_ _4188_ VGND VGND VPWR VPWR _4211_ sky130_fd_sc_hd__clkbuf_8
X_9499_ clknet_leaf_106_clk _0596_ VGND VGND VPWR VPWR registers\[5\]\[27\] sky130_fd_sc_hd__dfxtp_1
XFILLER_0_60_585 VGND VGND VPWR VPWR sky130_fd_sc_hd__decap_3
XFILLER_0_102_186 VGND VGND VPWR VPWR sky130_fd_sc_hd__decap_3
XFILLER_0_2_3 VGND VGND VPWR VPWR sky130_fd_sc_hd__decap_6
XANTENNA__6466__A net19 VGND VGND VPWR VPWR sky130_fd_sc_hd__diode_2
XANTENNA__7061__S _3420_ VGND VGND VPWR VPWR sky130_fd_sc_hd__diode_2
XTAP_TAPCELL_ROW_88_1409 VGND VPWR sky130_fd_sc_hd__tapvpwrvgnd_1
XANTENNA__7996__S _3900_ VGND VGND VPWR VPWR sky130_fd_sc_hd__diode_2
XFILLER_0_59_118 VGND VGND VPWR VPWR sky130_fd_sc_hd__decap_4
Xclkbuf_leaf_25_clk clknet_4_4_0_clk VGND VGND VPWR VPWR clknet_leaf_25_clk sky130_fd_sc_hd__clkbuf_8
XANTENNA_output103_A net103 VGND VGND VPWR VPWR sky130_fd_sc_hd__diode_2
XANTENNA__6405__S _3052_ VGND VGND VPWR VPWR sky130_fd_sc_hd__diode_2
XFILLER_0_68_696 VGND VGND VPWR VPWR sky130_fd_sc_hd__fill_2
XFILLER_0_67_195 VGND VGND VPWR VPWR sky130_fd_sc_hd__fill_2
XFILLER_0_82_154 VGND VGND VPWR VPWR sky130_fd_sc_hd__fill_2
XFILLER_0_55_346 VGND VGND VPWR VPWR sky130_fd_sc_hd__fill_2
XTAP_TAPCELL_ROW_99_1549 VGND VPWR sky130_fd_sc_hd__tapvpwrvgnd_1
XFILLER_0_70_305 VGND VGND VPWR VPWR sky130_fd_sc_hd__fill_1
XFILLER_0_55_379 VGND VGND VPWR VPWR sky130_fd_sc_hd__fill_2
XANTENNA__7236__S _3525_ VGND VGND VPWR VPWR sky130_fd_sc_hd__diode_2
XFILLER_0_36_593 VGND VGND VPWR VPWR sky130_fd_sc_hd__fill_2
XANTENNA__8140__A1 _3437_ VGND VGND VPWR VPWR sky130_fd_sc_hd__diode_2
XTAP_TAPCELL_ROW_11_396 VGND VPWR sky130_fd_sc_hd__tapvpwrvgnd_1
XFILLER_0_11_405 VGND VGND VPWR VPWR sky130_fd_sc_hd__fill_2
XFILLER_0_23_276 VGND VGND VPWR VPWR sky130_fd_sc_hd__fill_2
XFILLER_0_48_22 VGND VGND VPWR VPWR sky130_fd_sc_hd__decap_4
XFILLER_0_48_11 VGND VGND VPWR VPWR sky130_fd_sc_hd__fill_2
X_5180_ registers\[16\]\[16\] registers\[17\]\[16\] registers\[18\]\[16\] registers\[19\]\[16\]
+ _1763_ _1765_ VGND VGND VPWR VPWR _1932_ sky130_fd_sc_hd__mux4_1
XFILLER_0_48_77 VGND VGND VPWR VPWR sky130_fd_sc_hd__fill_2
XANTENNA__5280__A _1820_ VGND VGND VPWR VPWR sky130_fd_sc_hd__diode_2
XFILLER_0_3_13 VGND VGND VPWR VPWR sky130_fd_sc_hd__decap_3
XFILLER_0_64_43 VGND VGND VPWR VPWR sky130_fd_sc_hd__fill_1
XFILLER_0_3_57 VPWR VGND VPWR VGND sky130_ef_sc_hd__decap_12
X_8870_ clknet_leaf_35_clk _0991_ VGND VGND VPWR VPWR registers\[15\]\[6\] sky130_fd_sc_hd__dfxtp_1
XFILLER_0_78_416 VGND VGND VPWR VPWR sky130_fd_sc_hd__fill_2
X_7821_ _3092_ registers\[26\]\[11\] _3840_ VGND VGND VPWR VPWR _3842_ sky130_fd_sc_hd__mux2_1
XTAP_TAPCELL_ROW_108_1667 VGND VPWR sky130_fd_sc_hd__tapvpwrvgnd_1
XFILLER_0_59_641 VGND VGND VPWR VPWR sky130_fd_sc_hd__fill_1
X_7752_ _3805_ VGND VGND VPWR VPWR _0291_ sky130_fd_sc_hd__clkbuf_1
X_4964_ registers\[28\]\[5\] registers\[29\]\[5\] registers\[30\]\[5\] registers\[31\]\[5\]
+ _1678_ _1679_ VGND VGND VPWR VPWR _1727_ sky130_fd_sc_hd__mux4_1
XFILLER_0_93_419 VGND VGND VPWR VPWR sky130_fd_sc_hd__fill_2
Xclkbuf_leaf_16_clk clknet_4_6_0_clk VGND VGND VPWR VPWR clknet_leaf_16_clk sky130_fd_sc_hd__clkbuf_8
XANTENNA__4624__A _1324_ VGND VGND VPWR VPWR sky130_fd_sc_hd__diode_2
XFILLER_0_86_471 VGND VGND VPWR VPWR sky130_fd_sc_hd__decap_4
XFILLER_0_80_75 VGND VGND VPWR VPWR sky130_fd_sc_hd__fill_2
XFILLER_0_80_64 VGND VGND VPWR VPWR sky130_fd_sc_hd__fill_2
X_6703_ _3231_ VGND VGND VPWR VPWR _0840_ sky130_fd_sc_hd__clkbuf_1
XTAP_TAPCELL_ROW_50_915 VGND VPWR sky130_fd_sc_hd__tapvpwrvgnd_1
XTAP_TAPCELL_ROW_50_904 VGND VPWR sky130_fd_sc_hd__tapvpwrvgnd_1
XFILLER_0_116_201 VGND VGND VPWR VPWR sky130_fd_sc_hd__fill_2
X_7683_ registers\[24\]\[10\] _3455_ _3768_ VGND VGND VPWR VPWR _3769_ sky130_fd_sc_hd__mux2_1
XFILLER_0_104_82 VGND VGND VPWR VPWR sky130_fd_sc_hd__fill_2
X_9422_ clknet_leaf_40_clk _0519_ VGND VGND VPWR VPWR registers\[6\]\[14\] sky130_fd_sc_hd__dfxtp_1
XANTENNA__8530__S _4211_ VGND VGND VPWR VPWR sky130_fd_sc_hd__diode_2
XANTENNA__7706__A1 _3479_ VGND VGND VPWR VPWR sky130_fd_sc_hd__diode_2
X_4895_ registers\[20\]\[2\] registers\[21\]\[2\] registers\[22\]\[2\] registers\[23\]\[2\]
+ _1642_ _1643_ VGND VGND VPWR VPWR _1661_ sky130_fd_sc_hd__mux4_1
X_6634_ _3193_ VGND VGND VPWR VPWR _0809_ sky130_fd_sc_hd__clkbuf_1
XFILLER_0_15_722 VGND VGND VPWR VPWR sky130_fd_sc_hd__fill_1
X_6565_ registers\[7\]\[17\] _2997_ _3148_ VGND VGND VPWR VPWR _3156_ sky130_fd_sc_hd__mux2_1
XFILLER_0_61_349 VGND VGND VPWR VPWR sky130_fd_sc_hd__decap_6
X_9353_ clknet_leaf_7_clk _0450_ VGND VGND VPWR VPWR registers\[30\]\[9\] sky130_fd_sc_hd__dfxtp_1
XFILLER_0_42_530 VGND VGND VPWR VPWR sky130_fd_sc_hd__fill_2
XANTENNA__7146__S _3477_ VGND VGND VPWR VPWR sky130_fd_sc_hd__diode_2
XTAP_TAPCELL_ROW_30_650 VGND VPWR sky130_fd_sc_hd__tapvpwrvgnd_1
X_8304_ _4097_ VGND VGND VPWR VPWR _0551_ sky130_fd_sc_hd__clkbuf_1
X_9284_ clknet_leaf_29_clk _0381_ VGND VGND VPWR VPWR registers\[28\]\[4\] sky130_fd_sc_hd__dfxtp_1
X_5516_ _1051_ _2251_ VGND VGND VPWR VPWR _2252_ sky130_fd_sc_hd__or2_1
X_6496_ _3114_ VGND VGND VPWR VPWR _0750_ sky130_fd_sc_hd__clkbuf_1
XFILLER_0_30_714 VGND VGND VPWR VPWR sky130_fd_sc_hd__fill_2
XFILLER_0_112_440 VGND VGND VPWR VPWR sky130_fd_sc_hd__fill_1
X_8235_ registers\[6\]\[14\] _3464_ _4056_ VGND VGND VPWR VPWR _4061_ sky130_fd_sc_hd__mux2_1
XANTENNA__4379__S0 _1167_ VGND VGND VPWR VPWR sky130_fd_sc_hd__diode_2
XANTENNA__6985__S _3372_ VGND VGND VPWR VPWR sky130_fd_sc_hd__diode_2
X_5447_ registers\[28\]\[31\] registers\[29\]\[31\] registers\[30\]\[31\] registers\[31\]\[31\]
+ _2119_ _2120_ VGND VGND VPWR VPWR _2184_ sky130_fd_sc_hd__mux4_1
XFILLER_0_112_473 VGND VGND VPWR VPWR sky130_fd_sc_hd__decap_3
XFILLER_0_100_613 VGND VGND VPWR VPWR sky130_fd_sc_hd__fill_2
XANTENNA__5040__S1 _1799_ VGND VGND VPWR VPWR sky130_fd_sc_hd__diode_2
XFILLER_0_100_668 VGND VGND VPWR VPWR sky130_fd_sc_hd__fill_2
X_8166_ _4024_ VGND VGND VPWR VPWR _0486_ sky130_fd_sc_hd__clkbuf_1
X_5378_ _2097_ VGND VGND VPWR VPWR _2119_ sky130_fd_sc_hd__buf_4
X_8097_ _2989_ registers\[30\]\[13\] _3984_ VGND VGND VPWR VPWR _3988_ sky130_fd_sc_hd__mux2_1
X_7117_ net18 VGND VGND VPWR VPWR _3458_ sky130_fd_sc_hd__buf_2
X_4329_ _1110_ VGND VGND VPWR VPWR _1125_ sky130_fd_sc_hd__buf_4
X_7048_ _3102_ registers\[15\]\[16\] _3409_ VGND VGND VPWR VPWR _3416_ sky130_fd_sc_hd__mux2_1
XPHY_EDGE_ROW_114_Right_114 VGND VGND VPWR VPWR sky130_fd_sc_hd__decap_3
XFILLER_0_69_427 VGND VGND VPWR VPWR sky130_fd_sc_hd__decap_3
XANTENNA__8198__A1 _3495_ VGND VGND VPWR VPWR sky130_fd_sc_hd__diode_2
X_8999_ clknet_leaf_26_clk _0096_ VGND VGND VPWR VPWR registers\[1\]\[7\] sky130_fd_sc_hd__dfxtp_1
XFILLER_0_69_449 VGND VGND VPWR VPWR sky130_fd_sc_hd__fill_2
XTAP_TAPCELL_ROW_38_750 VGND VPWR sky130_fd_sc_hd__tapvpwrvgnd_1
XFILLER_0_84_419 VGND VGND VPWR VPWR sky130_fd_sc_hd__fill_1
XTAP_TAPCELL_ROW_83_1339 VGND VPWR sky130_fd_sc_hd__tapvpwrvgnd_1
XANTENNA__4303__S0 _1026_ VGND VGND VPWR VPWR sky130_fd_sc_hd__diode_2
XANTENNA__4534__A _1319_ VGND VGND VPWR VPWR sky130_fd_sc_hd__diode_2
XANTENNA__4759__A1 _1438_ VGND VGND VPWR VPWR sky130_fd_sc_hd__diode_2
XFILLER_0_92_452 VGND VGND VPWR VPWR sky130_fd_sc_hd__fill_2
XFILLER_0_92_485 VGND VGND VPWR VPWR sky130_fd_sc_hd__fill_2
XFILLER_0_80_614 VGND VGND VPWR VPWR sky130_fd_sc_hd__fill_1
XFILLER_0_64_165 VGND VGND VPWR VPWR sky130_fd_sc_hd__fill_2
XFILLER_0_107_278 VGND VGND VPWR VPWR sky130_fd_sc_hd__fill_2
XFILLER_0_45_390 VGND VGND VPWR VPWR sky130_fd_sc_hd__fill_2
XFILLER_0_100_29 VGND VGND VPWR VPWR sky130_fd_sc_hd__fill_2
XFILLER_0_21_714 VGND VGND VPWR VPWR sky130_fd_sc_hd__fill_2
XANTENNA__6895__S _3324_ VGND VGND VPWR VPWR sky130_fd_sc_hd__diode_2
XFILLER_0_0_608 VGND VGND VPWR VPWR sky130_fd_sc_hd__fill_2
XANTENNA__5031__S1 _1706_ VGND VGND VPWR VPWR sky130_fd_sc_hd__diode_2
XANTENNA__5487__A2 _2216_ VGND VGND VPWR VPWR sky130_fd_sc_hd__diode_2
XTAP_TAPCELL_ROW_94_1479 VGND VPWR sky130_fd_sc_hd__tapvpwrvgnd_1
XFILLER_0_109_38 VGND VGND VPWR VPWR sky130_fd_sc_hd__fill_2
XANTENNA__4790__S0 _1550_ VGND VGND VPWR VPWR sky130_fd_sc_hd__diode_2
XFILLER_0_88_714 VGND VGND VPWR VPWR sky130_fd_sc_hd__decap_3
XANTENNA__4542__S0 _1320_ VGND VGND VPWR VPWR sky130_fd_sc_hd__diode_2
XANTENNA__5340__A1_N _1977_ VGND VGND VPWR VPWR sky130_fd_sc_hd__diode_2
XANTENNA__5098__S1 _1765_ VGND VGND VPWR VPWR sky130_fd_sc_hd__diode_2
XFILLER_0_68_493 VGND VGND VPWR VPWR sky130_fd_sc_hd__decap_3
XFILLER_0_56_633 VGND VGND VPWR VPWR sky130_fd_sc_hd__fill_2
XTAP_TAPCELL_ROW_16_466 VGND VPWR sky130_fd_sc_hd__tapvpwrvgnd_1
XFILLER_0_7_207 VGND VGND VPWR VPWR sky130_fd_sc_hd__fill_1
XANTENNA__8350__S _4117_ VGND VGND VPWR VPWR sky130_fd_sc_hd__diode_2
XTAP_TAPCELL_ROW_103_1597 VGND VPWR sky130_fd_sc_hd__tapvpwrvgnd_1
XFILLER_0_56_699 VGND VGND VPWR VPWR sky130_fd_sc_hd__fill_1
XFILLER_0_50_34 VGND VGND VPWR VPWR sky130_fd_sc_hd__fill_2
X_4680_ registers\[20\]\[22\] registers\[21\]\[22\] registers\[22\]\[22\] registers\[23\]\[22\]
+ _1433_ _1434_ VGND VGND VPWR VPWR _1458_ sky130_fd_sc_hd__mux4_1
XFILLER_0_83_496 VGND VGND VPWR VPWR sky130_fd_sc_hd__fill_2
XANTENNA__5175__B2 _1754_ VGND VGND VPWR VPWR sky130_fd_sc_hd__diode_2
XFILLER_0_50_89 VGND VGND VPWR VPWR sky130_fd_sc_hd__fill_1
XFILLER_0_43_349 VGND VGND VPWR VPWR sky130_fd_sc_hd__fill_2
XTAP_TAPCELL_ROW_58_1010 VGND VPWR sky130_fd_sc_hd__tapvpwrvgnd_1
X_6350_ net39 VGND VGND VPWR VPWR _3024_ sky130_fd_sc_hd__buf_2
XFILLER_0_51_382 VGND VGND VPWR VPWR sky130_fd_sc_hd__decap_8
X_5301_ _1701_ _2046_ _1702_ VGND VGND VPWR VPWR _2047_ sky130_fd_sc_hd__a21oi_1
XFILLER_0_3_468 VGND VGND VPWR VPWR sky130_fd_sc_hd__fill_2
XFILLER_0_12_725 VGND VGND VPWR VPWR sky130_fd_sc_hd__fill_2
X_6281_ _2977_ VGND VGND VPWR VPWR _0672_ sky130_fd_sc_hd__clkbuf_1
X_8020_ registers\[2\]\[9\] _3453_ _3937_ VGND VGND VPWR VPWR _3947_ sky130_fd_sc_hd__mux2_1
X_5232_ registers\[16\]\[19\] registers\[17\]\[19\] registers\[18\]\[19\] registers\[19\]\[19\]
+ _1719_ _1720_ VGND VGND VPWR VPWR _1981_ sky130_fd_sc_hd__mux4_1
XFILLER_0_52_7 VGND VGND VPWR VPWR sky130_fd_sc_hd__fill_2
Xclkbuf_leaf_5_clk clknet_4_1_0_clk VGND VGND VPWR VPWR clknet_leaf_5_clk sky130_fd_sc_hd__clkbuf_8
XANTENNA__6675__A1 _2966_ VGND VGND VPWR VPWR sky130_fd_sc_hd__diode_2
X_5163_ _1914_ _1915_ _1752_ VGND VGND VPWR VPWR _1916_ sky130_fd_sc_hd__mux2_1
XANTENNA__4781__S0 _1550_ VGND VGND VPWR VPWR sky130_fd_sc_hd__diode_2
XFILLER_0_75_97 VGND VGND VPWR VPWR sky130_fd_sc_hd__fill_2
X_5094_ _1851_ VGND VGND VPWR VPWR net82 sky130_fd_sc_hd__inv_2
X_8922_ clknet_leaf_78_clk _0019_ VGND VGND VPWR VPWR registers\[16\]\[26\] sky130_fd_sc_hd__dfxtp_1
XFILLER_0_91_41 VGND VGND VPWR VPWR sky130_fd_sc_hd__decap_4
XTAP_TAPCELL_ROW_69_1161 VGND VPWR sky130_fd_sc_hd__tapvpwrvgnd_1
XTAP_TAPCELL_ROW_69_1150 VGND VPWR sky130_fd_sc_hd__tapvpwrvgnd_1
X_8853_ clknet_leaf_82_clk _0974_ VGND VGND VPWR VPWR registers\[14\]\[21\] sky130_fd_sc_hd__dfxtp_1
XFILLER_0_94_728 VGND VGND VPWR VPWR sky130_fd_sc_hd__fill_2
XANTENNA__5089__S1 _1743_ VGND VGND VPWR VPWR sky130_fd_sc_hd__diode_2
XFILLER_0_78_279 VPWR VGND VPWR VGND sky130_ef_sc_hd__decap_12
XFILLER_0_78_268 VGND VGND VPWR VPWR sky130_fd_sc_hd__decap_3
XFILLER_0_78_257 VGND VGND VPWR VPWR sky130_fd_sc_hd__fill_2
X_7804_ _3075_ registers\[26\]\[3\] _3829_ VGND VGND VPWR VPWR _3833_ sky130_fd_sc_hd__mux2_1
XFILLER_0_66_419 VGND VGND VPWR VPWR sky130_fd_sc_hd__fill_1
XANTENNA__5938__B1 _2515_ VGND VGND VPWR VPWR sky130_fd_sc_hd__diode_2
XTAP_TAPCELL_ROW_35_720 VGND VPWR sky130_fd_sc_hd__tapvpwrvgnd_1
X_8784_ clknet_leaf_64_clk _0905_ VGND VGND VPWR VPWR registers\[12\]\[16\] sky130_fd_sc_hd__dfxtp_1
X_5996_ _2705_ _2205_ _2706_ _2707_ VGND VGND VPWR VPWR _2715_ sky130_fd_sc_hd__a31o_1
XANTENNA__4836__S1 _1556_ VGND VGND VPWR VPWR sky130_fd_sc_hd__diode_2
X_4947_ registers\[24\]\[4\] registers\[25\]\[4\] registers\[26\]\[4\] registers\[27\]\[4\]
+ _1705_ _1691_ VGND VGND VPWR VPWR _1711_ sky130_fd_sc_hd__mux4_1
XFILLER_0_74_452 VGND VGND VPWR VPWR sky130_fd_sc_hd__decap_6
XFILLER_0_74_430 VGND VGND VPWR VPWR sky130_fd_sc_hd__fill_1
X_7735_ _3796_ VGND VGND VPWR VPWR _0283_ sky130_fd_sc_hd__clkbuf_1
XANTENNA__8352__A1 _3445_ VGND VGND VPWR VPWR sky130_fd_sc_hd__diode_2
X_4878_ registers\[16\]\[1\] registers\[17\]\[1\] registers\[18\]\[1\] registers\[19\]\[1\]
+ _1642_ _1643_ VGND VGND VPWR VPWR _1645_ sky130_fd_sc_hd__mux4_1
X_7666_ registers\[24\]\[2\] _3439_ _3757_ VGND VGND VPWR VPWR _3760_ sky130_fd_sc_hd__mux2_1
XANTENNA__8260__S _4067_ VGND VGND VPWR VPWR sky130_fd_sc_hd__diode_2
XFILLER_0_117_587 VGND VGND VPWR VPWR sky130_fd_sc_hd__fill_1
XFILLER_0_117_565 VGND VGND VPWR VPWR sky130_fd_sc_hd__fill_2
XPHY_EDGE_ROW_104_Left_224 VGND VGND VPWR VPWR sky130_fd_sc_hd__decap_3
X_6617_ _3184_ VGND VGND VPWR VPWR _0801_ sky130_fd_sc_hd__clkbuf_1
X_9405_ clknet_leaf_105_clk _0502_ VGND VGND VPWR VPWR registers\[9\]\[29\] sky130_fd_sc_hd__dfxtp_1
X_9336_ clknet_leaf_88_clk _0433_ VGND VGND VPWR VPWR registers\[2\]\[24\] sky130_fd_sc_hd__dfxtp_1
X_7597_ _3073_ registers\[23\]\[2\] _3720_ VGND VGND VPWR VPWR _3723_ sky130_fd_sc_hd__mux2_1
X_6548_ registers\[7\]\[9\] _2980_ _3137_ VGND VGND VPWR VPWR _3147_ sky130_fd_sc_hd__mux2_1
XANTENNA_clkbuf_leaf_81_clk_A clknet_4_10_0_clk VGND VGND VPWR VPWR sky130_fd_sc_hd__diode_2
XFILLER_0_15_596 VGND VGND VPWR VPWR sky130_fd_sc_hd__decap_3
XFILLER_0_100_410 VGND VGND VPWR VPWR sky130_fd_sc_hd__fill_2
X_6479_ _3102_ registers\[29\]\[16\] _3090_ VGND VGND VPWR VPWR _3103_ sky130_fd_sc_hd__mux2_1
X_9267_ clknet_leaf_95_clk _0364_ VGND VGND VPWR VPWR registers\[27\]\[19\] sky130_fd_sc_hd__dfxtp_1
XFILLER_0_30_533 VGND VGND VPWR VPWR sky130_fd_sc_hd__fill_2
X_9198_ clknet_leaf_38_clk _0295_ VGND VGND VPWR VPWR registers\[25\]\[14\] sky130_fd_sc_hd__dfxtp_1
X_8218_ registers\[6\]\[6\] _3447_ _4045_ VGND VGND VPWR VPWR _4052_ sky130_fd_sc_hd__mux2_1
XFILLER_0_30_577 VGND VGND VPWR VPWR sky130_fd_sc_hd__fill_2
X_8149_ _4015_ VGND VGND VPWR VPWR _0478_ sky130_fd_sc_hd__clkbuf_1
XANTENNA_clkbuf_leaf_96_clk_A clknet_4_9_0_clk VGND VGND VPWR VPWR sky130_fd_sc_hd__diode_2
XANTENNA__4772__S0 _1404_ VGND VGND VPWR VPWR sky130_fd_sc_hd__diode_2
XPHY_EDGE_ROW_113_Left_233 VGND VGND VPWR VPWR sky130_fd_sc_hd__decap_3
XANTENNA__8435__S _4164_ VGND VGND VPWR VPWR sky130_fd_sc_hd__diode_2
XFILLER_0_69_246 VGND VGND VPWR VPWR sky130_fd_sc_hd__fill_2
XANTENNA__4264__A _1030_ VGND VGND VPWR VPWR sky130_fd_sc_hd__diode_2
XANTENNA__4827__S1 _1434_ VGND VGND VPWR VPWR sky130_fd_sc_hd__diode_2
XFILLER_0_38_600 VGND VGND VPWR VPWR sky130_fd_sc_hd__fill_1
XANTENNA_clkbuf_leaf_34_clk_A clknet_4_5_0_clk VGND VGND VPWR VPWR sky130_fd_sc_hd__diode_2
XFILLER_0_84_249 VGND VGND VPWR VPWR sky130_fd_sc_hd__fill_1
XFILLER_0_77_290 VGND VGND VPWR VPWR sky130_fd_sc_hd__fill_2
XFILLER_0_38_655 VGND VGND VPWR VPWR sky130_fd_sc_hd__fill_2
XFILLER_0_53_625 VGND VGND VPWR VPWR sky130_fd_sc_hd__fill_2
XTAP_TAPCELL_ROW_13_425 VGND VPWR sky130_fd_sc_hd__tapvpwrvgnd_1
XTAP_TAPCELL_ROW_96_1508 VGND VPWR sky130_fd_sc_hd__tapvpwrvgnd_1
XANTENNA__5157__A1 _1689_ VGND VGND VPWR VPWR sky130_fd_sc_hd__diode_2
XFILLER_0_92_271 VGND VGND VPWR VPWR sky130_fd_sc_hd__decap_4
XFILLER_0_53_658 VGND VGND VPWR VPWR sky130_fd_sc_hd__decap_6
XFILLER_0_52_135 VGND VGND VPWR VPWR sky130_fd_sc_hd__decap_3
XTAP_TAPCELL_ROW_41_789 VGND VPWR sky130_fd_sc_hd__tapvpwrvgnd_1
XFILLER_0_37_187 VGND VGND VPWR VPWR sky130_fd_sc_hd__fill_2
XFILLER_0_80_477 VGND VGND VPWR VPWR sky130_fd_sc_hd__fill_2
XANTENNA__5252__S1 _1997_ VGND VGND VPWR VPWR sky130_fd_sc_hd__diode_2
XFILLER_0_21_500 VGND VGND VPWR VPWR sky130_fd_sc_hd__fill_2
XANTENNA__6106__B1 net96 VGND VGND VPWR VPWR sky130_fd_sc_hd__diode_2
XANTENNA__5004__S1 _1765_ VGND VGND VPWR VPWR sky130_fd_sc_hd__diode_2
XFILLER_0_103_281 VGND VGND VPWR VPWR sky130_fd_sc_hd__fill_2
XFILLER_0_0_449 VGND VGND VPWR VPWR sky130_fd_sc_hd__fill_2
XFILLER_0_21_599 VGND VGND VPWR VPWR sky130_fd_sc_hd__fill_2
XFILLER_0_29_57 VGND VGND VPWR VPWR sky130_fd_sc_hd__decap_4
XANTENNA_clkbuf_leaf_107_clk_A clknet_4_2_0_clk VGND VGND VPWR VPWR sky130_fd_sc_hd__diode_2
XFILLER_0_45_45 VGND VGND VPWR VPWR sky130_fd_sc_hd__fill_1
XFILLER_0_45_78 VGND VGND VPWR VPWR sky130_fd_sc_hd__decap_4
XTAP_TAPCELL_ROW_105_1626 VGND VPWR sky130_fd_sc_hd__tapvpwrvgnd_1
XFILLER_0_88_577 VGND VGND VPWR VPWR sky130_fd_sc_hd__decap_4
XFILLER_0_0_25 VGND VGND VPWR VPWR sky130_fd_sc_hd__decap_3
X_5850_ _2549_ _2557_ _2576_ VGND VGND VPWR VPWR _2577_ sky130_fd_sc_hd__or3_1
X_5781_ _2297_ _2402_ _2400_ _2270_ VGND VGND VPWR VPWR _2511_ sky130_fd_sc_hd__a22o_1
XFILLER_0_0_69 VPWR VGND VPWR VGND sky130_ef_sc_hd__decap_12
X_4801_ _1570_ _1571_ _1513_ VGND VGND VPWR VPWR _1572_ sky130_fd_sc_hd__mux2_1
XANTENNA__8080__S _3973_ VGND VGND VPWR VPWR sky130_fd_sc_hd__diode_2
XFILLER_0_90_219 VGND VGND VPWR VPWR sky130_fd_sc_hd__fill_1
XTAP_TAPCELL_ROW_64_1091 VGND VPWR sky130_fd_sc_hd__tapvpwrvgnd_1
X_7520_ _3681_ VGND VGND VPWR VPWR _0183_ sky130_fd_sc_hd__clkbuf_1
X_4732_ _1503_ _1506_ _1379_ VGND VGND VPWR VPWR _1507_ sky130_fd_sc_hd__mux2_1
X_7451_ registers\[20\]\[30\] _3497_ _3611_ VGND VGND VPWR VPWR _3645_ sky130_fd_sc_hd__mux2_1
X_4663_ registers\[28\]\[21\] registers\[29\]\[21\] registers\[30\]\[21\] registers\[31\]\[21\]
+ _1427_ _1428_ VGND VGND VPWR VPWR _1442_ sky130_fd_sc_hd__mux4_1
XFILLER_0_71_477 VGND VGND VPWR VPWR sky130_fd_sc_hd__fill_2
XANTENNA__5243__S1 _1692_ VGND VGND VPWR VPWR sky130_fd_sc_hd__diode_2
X_6402_ _3053_ VGND VGND VPWR VPWR _0717_ sky130_fd_sc_hd__clkbuf_1
XFILLER_0_102_708 VGND VGND VPWR VPWR sky130_fd_sc_hd__fill_2
X_4594_ registers\[28\]\[18\] registers\[29\]\[18\] registers\[30\]\[18\] registers\[31\]\[18\]
+ _1338_ _1339_ VGND VGND VPWR VPWR _1376_ sky130_fd_sc_hd__mux4_1
X_7382_ registers\[1\]\[30\] _3497_ _3574_ VGND VGND VPWR VPWR _3608_ sky130_fd_sc_hd__mux2_1
XFILLER_0_12_511 VGND VGND VPWR VPWR sky130_fd_sc_hd__fill_2
XTAP_TAPCELL_ROW_116_1766 VGND VPWR sky130_fd_sc_hd__tapvpwrvgnd_1
XFILLER_0_101_229 VGND VGND VPWR VPWR sky130_fd_sc_hd__fill_2
XANTENNA_clkbuf_4_6_0_clk_A clknet_0_clk VGND VGND VPWR VPWR sky130_fd_sc_hd__diode_2
XANTENNA__6829__A _3287_ VGND VGND VPWR VPWR sky130_fd_sc_hd__diode_2
X_6333_ registers\[19\]\[24\] _3012_ _3004_ VGND VGND VPWR VPWR _3013_ sky130_fd_sc_hd__mux2_1
XFILLER_0_12_533 VGND VGND VPWR VPWR sky130_fd_sc_hd__fill_2
X_9121_ clknet_leaf_112_clk _0218_ VGND VGND VPWR VPWR registers\[23\]\[1\] sky130_fd_sc_hd__dfxtp_1
XANTENNA__7424__S _3623_ VGND VGND VPWR VPWR sky130_fd_sc_hd__diode_2
XANTENNA__5733__A _2344_ VGND VGND VPWR VPWR sky130_fd_sc_hd__diode_2
X_9052_ clknet_leaf_103_clk _0149_ VGND VGND VPWR VPWR registers\[20\]\[28\] sky130_fd_sc_hd__dfxtp_1
X_6264_ net38 VGND VGND VPWR VPWR _2966_ sky130_fd_sc_hd__buf_2
X_5215_ registers\[24\]\[18\] registers\[25\]\[18\] registers\[26\]\[18\] registers\[27\]\[18\]
+ _1820_ _1821_ VGND VGND VPWR VPWR _1965_ sky130_fd_sc_hd__mux4_1
X_8003_ _3938_ VGND VGND VPWR VPWR _0409_ sky130_fd_sc_hd__clkbuf_1
XFILLER_0_12_599 VGND VGND VPWR VPWR sky130_fd_sc_hd__fill_2
XANTENNA__4659__B1 _1438_ VGND VGND VPWR VPWR sky130_fd_sc_hd__diode_2
Xclkbuf_4_15_0_clk clknet_0_clk VGND VGND VPWR VPWR clknet_4_15_0_clk sky130_fd_sc_hd__clkbuf_8
X_6195_ _2828_ _2859_ _2902_ VGND VGND VPWR VPWR _2903_ sky130_fd_sc_hd__nand3_1
XANTENNA__4754__S0 _1323_ VGND VGND VPWR VPWR sky130_fd_sc_hd__diode_2
X_5146_ registers\[20\]\[14\] registers\[21\]\[14\] registers\[22\]\[14\] registers\[23\]\[14\]
+ _1748_ _1749_ VGND VGND VPWR VPWR _1900_ sky130_fd_sc_hd__mux4_1
X_5077_ _1835_ VGND VGND VPWR VPWR net112 sky130_fd_sc_hd__inv_2
XFILLER_0_79_533 VGND VGND VPWR VPWR sky130_fd_sc_hd__fill_2
X_8905_ clknet_leaf_11_clk _0002_ VGND VGND VPWR VPWR registers\[16\]\[9\] sky130_fd_sc_hd__dfxtp_1
X_8836_ clknet_leaf_29_clk _0957_ VGND VGND VPWR VPWR registers\[14\]\[4\] sky130_fd_sc_hd__dfxtp_1
XFILLER_0_94_525 VGND VGND VPWR VPWR sky130_fd_sc_hd__fill_2
XFILLER_0_109_307 VGND VGND VPWR VPWR sky130_fd_sc_hd__fill_2
XFILLER_0_82_709 VPWR VGND VPWR VGND sky130_ef_sc_hd__decap_12
X_5979_ _2553_ _2555_ _2627_ _2698_ VGND VGND VPWR VPWR _2699_ sky130_fd_sc_hd__nand4_1
X_8767_ clknet_leaf_99_clk _0888_ VGND VGND VPWR VPWR registers\[11\]\[31\] sky130_fd_sc_hd__dfxtp_1
X_7718_ registers\[24\]\[27\] _3491_ _3779_ VGND VGND VPWR VPWR _3787_ sky130_fd_sc_hd__mux2_1
XFILLER_0_19_176 VGND VGND VPWR VPWR sky130_fd_sc_hd__fill_2
X_8698_ clknet_leaf_90_clk _0819_ VGND VGND VPWR VPWR registers\[0\]\[26\] sky130_fd_sc_hd__dfxtp_1
XFILLER_0_105_524 VGND VGND VPWR VPWR sky130_fd_sc_hd__fill_2
XANTENNA__5234__S1 _1720_ VGND VGND VPWR VPWR sky130_fd_sc_hd__diode_2
XFILLER_0_7_593 VGND VGND VPWR VPWR sky130_fd_sc_hd__fill_2
X_7649_ _3125_ registers\[23\]\[27\] _3742_ VGND VGND VPWR VPWR _3750_ sky130_fd_sc_hd__mux2_1
XFILLER_0_34_168 VGND VGND VPWR VPWR sky130_fd_sc_hd__fill_2
XFILLER_0_105_546 VGND VGND VPWR VPWR sky130_fd_sc_hd__fill_1
X_9319_ clknet_leaf_25_clk _0416_ VGND VGND VPWR VPWR registers\[2\]\[7\] sky130_fd_sc_hd__dfxtp_1
XFILLER_0_30_341 VGND VGND VPWR VPWR sky130_fd_sc_hd__fill_2
XTAP_TAPCELL_ROW_91_1438 VGND VPWR sky130_fd_sc_hd__tapvpwrvgnd_1
XANTENNA__7334__S _3575_ VGND VGND VPWR VPWR sky130_fd_sc_hd__diode_2
XANTENNA__4745__S0 _1347_ VGND VGND VPWR VPWR sky130_fd_sc_hd__diode_2
XANTENNA_input27_A wd3[1] VGND VGND VPWR VPWR sky130_fd_sc_hd__diode_2
XANTENNA__8165__S _4020_ VGND VGND VPWR VPWR sky130_fd_sc_hd__diode_2
XANTENNA__6811__A1 _2964_ VGND VGND VPWR VPWR sky130_fd_sc_hd__diode_2
XFILLER_0_97_341 VGND VGND VPWR VPWR sky130_fd_sc_hd__fill_1
XANTENNA__5170__S0 _1742_ VGND VGND VPWR VPWR sky130_fd_sc_hd__diode_2
XTAP_TAPCELL_ROW_46_859 VGND VPWR sky130_fd_sc_hd__tapvpwrvgnd_1
XFILLER_0_85_525 VGND VGND VPWR VPWR sky130_fd_sc_hd__fill_2
XFILLER_0_85_558 VGND VGND VPWR VPWR sky130_fd_sc_hd__fill_2
XANTENNA__7509__S _3670_ VGND VGND VPWR VPWR sky130_fd_sc_hd__diode_2
XANTENNA__6413__S _3052_ VGND VGND VPWR VPWR sky130_fd_sc_hd__diode_2
XTAP_TAPCELL_ROW_26_594 VGND VPWR sky130_fd_sc_hd__tapvpwrvgnd_1
XTAP_TAPCELL_ROW_100_1556 VGND VPWR sky130_fd_sc_hd__tapvpwrvgnd_1
XFILLER_0_93_580 VPWR VGND VPWR VGND sky130_ef_sc_hd__decap_12
XFILLER_0_25_113 VGND VGND VPWR VPWR sky130_fd_sc_hd__fill_2
XANTENNA__5029__S _1631_ VGND VGND VPWR VPWR sky130_fd_sc_hd__diode_2
XFILLER_0_41_617 VGND VGND VPWR VPWR sky130_fd_sc_hd__fill_2
XFILLER_0_41_606 VGND VGND VPWR VPWR sky130_fd_sc_hd__fill_1
XFILLER_0_13_308 VGND VGND VPWR VPWR sky130_fd_sc_hd__fill_2
XANTENNA__5225__S1 _1760_ VGND VGND VPWR VPWR sky130_fd_sc_hd__diode_2
XFILLER_0_13_319 VGND VGND VPWR VPWR sky130_fd_sc_hd__fill_1
XFILLER_0_1_725 VGND VGND VPWR VPWR sky130_fd_sc_hd__decap_3
XANTENNA_output95_A net95 VGND VGND VPWR VPWR sky130_fd_sc_hd__diode_2
XFILLER_0_34_691 VGND VGND VPWR VPWR sky130_fd_sc_hd__fill_2
XANTENNA__7244__S _3525_ VGND VGND VPWR VPWR sky130_fd_sc_hd__diode_2
XFILLER_0_0_257 VGND VGND VPWR VPWR sky130_fd_sc_hd__fill_2
XFILLER_0_21_385 VGND VGND VPWR VPWR sky130_fd_sc_hd__decap_4
X_5000_ _1731_ VGND VGND VPWR VPWR _1762_ sky130_fd_sc_hd__clkbuf_8
XANTENNA__4736__S0 _1390_ VGND VGND VPWR VPWR sky130_fd_sc_hd__diode_2
XTAP_TAPCELL_ROW_111_1696 VGND VPWR sky130_fd_sc_hd__tapvpwrvgnd_1
XFILLER_0_56_77 VGND VGND VPWR VPWR sky130_fd_sc_hd__decap_4
XTAP_TAPCELL_ROW_66_1120 VGND VPWR sky130_fd_sc_hd__tapvpwrvgnd_1
XANTENNA__5161__S0 _1806_ VGND VGND VPWR VPWR sky130_fd_sc_hd__diode_2
XANTENNA__4813__B1 _1372_ VGND VGND VPWR VPWR sky130_fd_sc_hd__diode_2
X_6951_ _3364_ VGND VGND VPWR VPWR _0955_ sky130_fd_sc_hd__clkbuf_1
XFILLER_0_88_385 VGND VGND VPWR VPWR sky130_fd_sc_hd__decap_4
XFILLER_0_88_363 VGND VGND VPWR VPWR sky130_fd_sc_hd__fill_1
XFILLER_0_72_65 VGND VGND VPWR VPWR sky130_fd_sc_hd__fill_2
X_5902_ _2624_ _2625_ VGND VGND VPWR VPWR _2626_ sky130_fd_sc_hd__nor2_1
XFILLER_0_48_216 VGND VGND VPWR VPWR sky130_fd_sc_hd__fill_2
X_6882_ _3327_ VGND VGND VPWR VPWR _0923_ sky130_fd_sc_hd__clkbuf_1
X_8621_ clknet_leaf_55_clk _0742_ VGND VGND VPWR VPWR registers\[29\]\[13\] sky130_fd_sc_hd__dfxtp_1
X_5833_ _2290_ _2300_ _2217_ VGND VGND VPWR VPWR _2561_ sky130_fd_sc_hd__mux2_1
XFILLER_0_48_249 VGND VGND VPWR VPWR sky130_fd_sc_hd__decap_3
XFILLER_0_118_137 VGND VGND VPWR VPWR sky130_fd_sc_hd__decap_3
XANTENNA__5728__A _2344_ VGND VGND VPWR VPWR sky130_fd_sc_hd__diode_2
X_8552_ clknet_leaf_16_clk _0673_ VGND VGND VPWR VPWR registers\[19\]\[8\] sky130_fd_sc_hd__dfxtp_1
XFILLER_0_8_324 VGND VGND VPWR VPWR sky130_fd_sc_hd__decap_3
XFILLER_0_29_452 VGND VGND VPWR VPWR sky130_fd_sc_hd__fill_2
XFILLER_0_84_580 VGND VGND VPWR VPWR sky130_fd_sc_hd__decap_4
X_5764_ _2267_ _1660_ _2216_ _2274_ _1071_ VGND VGND VPWR VPWR _2495_ sky130_fd_sc_hd__a2111oi_2
XFILLER_0_16_113 VGND VGND VPWR VPWR sky130_fd_sc_hd__decap_6
X_7503_ _3115_ registers\[21\]\[22\] _3670_ VGND VGND VPWR VPWR _3673_ sky130_fd_sc_hd__mux2_1
X_5695_ _2408_ _2421_ _2422_ _2428_ VGND VGND VPWR VPWR net71 sky130_fd_sc_hd__o2bb2a_1
XFILLER_0_71_230 VGND VGND VPWR VPWR sky130_fd_sc_hd__fill_2
XFILLER_0_44_444 VGND VGND VPWR VPWR sky130_fd_sc_hd__fill_2
X_4715_ _1487_ _1490_ _1159_ VGND VGND VPWR VPWR _1491_ sky130_fd_sc_hd__mux2_1
X_8483_ _4192_ VGND VGND VPWR VPWR _0635_ sky130_fd_sc_hd__clkbuf_1
XFILLER_0_44_477 VGND VGND VPWR VPWR sky130_fd_sc_hd__fill_2
XANTENNA__6869__A1 _3022_ VGND VGND VPWR VPWR sky130_fd_sc_hd__diode_2
XFILLER_0_4_552 VGND VGND VPWR VPWR sky130_fd_sc_hd__decap_4
XFILLER_0_4_541 VGND VGND VPWR VPWR sky130_fd_sc_hd__fill_2
X_7434_ _3636_ VGND VGND VPWR VPWR _0142_ sky130_fd_sc_hd__clkbuf_1
X_4646_ _1422_ _1425_ _1379_ VGND VGND VPWR VPWR _1426_ sky130_fd_sc_hd__mux2_1
X_4577_ registers\[20\]\[17\] registers\[21\]\[17\] registers\[22\]\[17\] registers\[23\]\[17\]
+ _1160_ _1161_ VGND VGND VPWR VPWR _1360_ sky130_fd_sc_hd__mux4_1
XFILLER_0_4_563 VGND VGND VPWR VPWR sky130_fd_sc_hd__fill_2
X_7365_ _3599_ VGND VGND VPWR VPWR _0110_ sky130_fd_sc_hd__clkbuf_1
XFILLER_0_114_398 VGND VGND VPWR VPWR sky130_fd_sc_hd__fill_1
XFILLER_0_97_51 VGND VGND VPWR VPWR sky130_fd_sc_hd__decap_3
XTAP_TAPCELL_ROW_77_1260 VGND VPWR sky130_fd_sc_hd__tapvpwrvgnd_1
X_6316_ net26 VGND VGND VPWR VPWR _3001_ sky130_fd_sc_hd__buf_2
X_9104_ clknet_leaf_61_clk _0201_ VGND VGND VPWR VPWR registers\[22\]\[16\] sky130_fd_sc_hd__dfxtp_1
XFILLER_0_40_672 VGND VGND VPWR VPWR sky130_fd_sc_hd__fill_1
XANTENNA__7294__A1 _3476_ VGND VGND VPWR VPWR sky130_fd_sc_hd__diode_2
X_7296_ registers\[18\]\[21\] _3479_ _3561_ VGND VGND VPWR VPWR _3563_ sky130_fd_sc_hd__mux2_1
X_9035_ clknet_leaf_59_clk _0132_ VGND VGND VPWR VPWR registers\[20\]\[11\] sky130_fd_sc_hd__dfxtp_1
XFILLER_0_110_593 VGND VGND VPWR VPWR sky130_fd_sc_hd__fill_2
X_6247_ _2677_ VGND VGND VPWR VPWR _2952_ sky130_fd_sc_hd__inv_2
XANTENNA__4727__S0 _1415_ VGND VGND VPWR VPWR sky130_fd_sc_hd__diode_2
X_6178_ _2297_ _2810_ VGND VGND VPWR VPWR _2887_ sky130_fd_sc_hd__and2_1
X_5129_ registers\[20\]\[13\] registers\[21\]\[13\] registers\[22\]\[13\] registers\[23\]\[13\]
+ _1883_ _1774_ VGND VGND VPWR VPWR _1884_ sky130_fd_sc_hd__mux4_1
XFILLER_0_99_617 VGND VGND VPWR VPWR sky130_fd_sc_hd__fill_2
XANTENNA__5402__S _2031_ VGND VGND VPWR VPWR sky130_fd_sc_hd__diode_2
XANTENNA__5152__S0 _1719_ VGND VGND VPWR VPWR sky130_fd_sc_hd__diode_2
XFILLER_0_98_149 VGND VGND VPWR VPWR sky130_fd_sc_hd__fill_1
XFILLER_0_94_300 VGND VGND VPWR VPWR sky130_fd_sc_hd__fill_2
XFILLER_0_67_514 VGND VGND VPWR VPWR sky130_fd_sc_hd__fill_2
X_8819_ clknet_leaf_12_clk _0940_ VGND VGND VPWR VPWR registers\[13\]\[19\] sky130_fd_sc_hd__dfxtp_1
XTAP_TAPCELL_ROW_43_818 VGND VPWR sky130_fd_sc_hd__tapvpwrvgnd_1
XFILLER_0_94_388 VGND VGND VPWR VPWR sky130_fd_sc_hd__decap_6
XANTENNA__5638__A net113 VGND VGND VPWR VPWR sky130_fd_sc_hd__diode_2
XANTENNA__4568__C1 _1153_ VGND VGND VPWR VPWR sky130_fd_sc_hd__diode_2
XANTENNA__5455__S1 _2127_ VGND VGND VPWR VPWR sky130_fd_sc_hd__diode_2
XTAP_TAPCELL_ROW_23_553 VGND VPWR sky130_fd_sc_hd__tapvpwrvgnd_1
XTAP_TAPCELL_ROW_23_564 VGND VPWR sky130_fd_sc_hd__tapvpwrvgnd_1
XFILLER_0_35_422 VGND VGND VPWR VPWR sky130_fd_sc_hd__fill_2
XFILLER_0_118_693 VGND VGND VPWR VPWR sky130_fd_sc_hd__decap_6
XFILLER_0_50_425 VGND VGND VPWR VPWR sky130_fd_sc_hd__fill_2
XFILLER_0_50_403 VGND VGND VPWR VPWR sky130_fd_sc_hd__fill_2
XFILLER_0_16_680 VGND VGND VPWR VPWR sky130_fd_sc_hd__fill_1
XFILLER_0_22_105 VGND VGND VPWR VPWR sky130_fd_sc_hd__fill_2
XANTENNA__4688__S _1362_ VGND VGND VPWR VPWR sky130_fd_sc_hd__diode_2
XANTENNA__4966__S0 _1719_ VGND VGND VPWR VPWR sky130_fd_sc_hd__diode_2
XANTENNA__6469__A net20 VGND VGND VPWR VPWR sky130_fd_sc_hd__diode_2
XANTENNA__7285__A1 _3468_ VGND VGND VPWR VPWR sky130_fd_sc_hd__diode_2
XANTENNA__5391__S0 _2126_ VGND VGND VPWR VPWR sky130_fd_sc_hd__diode_2
XFILLER_0_117_27 VPWR VGND VPWR VGND sky130_ef_sc_hd__decap_12
XFILLER_0_89_105 VGND VGND VPWR VPWR sky130_fd_sc_hd__fill_2
XFILLER_0_98_661 VPWR VGND VPWR VGND sky130_ef_sc_hd__decap_12
XANTENNA__5599__A1 _1929_ VGND VGND VPWR VPWR sky130_fd_sc_hd__diode_2
XFILLER_0_97_160 VGND VGND VPWR VPWR sky130_fd_sc_hd__fill_2
XFILLER_0_85_311 VGND VGND VPWR VPWR sky130_fd_sc_hd__fill_2
XFILLER_0_97_182 VGND VGND VPWR VPWR sky130_fd_sc_hd__fill_1
XFILLER_0_42_24 VGND VGND VPWR VPWR sky130_fd_sc_hd__fill_2
XANTENNA__5446__S1 _2120_ VGND VGND VPWR VPWR sky130_fd_sc_hd__diode_2
XFILLER_0_109_660 VGND VGND VPWR VPWR sky130_fd_sc_hd__fill_2
XTAP_TAPCELL_ROW_61_1050 VGND VPWR sky130_fd_sc_hd__tapvpwrvgnd_1
XFILLER_0_26_400 VGND VGND VPWR VPWR sky130_fd_sc_hd__fill_1
XFILLER_0_108_170 VGND VGND VPWR VPWR sky130_fd_sc_hd__fill_2
XFILLER_0_26_455 VGND VGND VPWR VPWR sky130_fd_sc_hd__fill_2
X_4500_ registers\[20\]\[13\] registers\[21\]\[13\] registers\[22\]\[13\] registers\[23\]\[13\]
+ _1167_ _1168_ VGND VGND VPWR VPWR _1287_ sky130_fd_sc_hd__mux4_1
X_5480_ _2215_ VGND VGND VPWR VPWR _2216_ sky130_fd_sc_hd__clkbuf_4
XFILLER_0_81_572 VGND VGND VPWR VPWR sky130_fd_sc_hd__decap_3
XFILLER_0_81_561 VGND VGND VPWR VPWR sky130_fd_sc_hd__decap_8
XFILLER_0_101_3 VGND VGND VPWR VPWR sky130_fd_sc_hd__decap_4
X_4431_ _1217_ _1219_ _1222_ _1034_ net8 VGND VGND VPWR VPWR _1223_ sky130_fd_sc_hd__a221o_1
XANTENNA__4598__S _1379_ VGND VGND VPWR VPWR sky130_fd_sc_hd__diode_2
XFILLER_0_41_458 VGND VGND VPWR VPWR sky130_fd_sc_hd__fill_2
XANTENNA_1 clknet_0_clk VGND VGND VPWR VPWR sky130_fd_sc_hd__diode_2
XANTENNA__4957__S0 _1719_ VGND VGND VPWR VPWR sky130_fd_sc_hd__diode_2
XANTENNA__6379__A _3029_ VGND VGND VPWR VPWR sky130_fd_sc_hd__diode_2
XFILLER_0_22_672 VGND VGND VPWR VPWR sky130_fd_sc_hd__fill_2
XTAP_TAPCELL_ROW_113_1725 VGND VPWR sky130_fd_sc_hd__tapvpwrvgnd_1
X_4362_ _1155_ _1156_ _1132_ VGND VGND VPWR VPWR _1157_ sky130_fd_sc_hd__mux2_1
XFILLER_0_67_32 VGND VGND VPWR VPWR sky130_fd_sc_hd__fill_2
XFILLER_0_1_577 VGND VGND VPWR VPWR sky130_fd_sc_hd__fill_1
X_7150_ _3480_ VGND VGND VPWR VPWR _0014_ sky130_fd_sc_hd__clkbuf_1
XFILLER_0_21_160 VGND VGND VPWR VPWR sky130_fd_sc_hd__fill_2
X_6101_ _2721_ _2537_ _2813_ _2429_ VGND VGND VPWR VPWR _2814_ sky130_fd_sc_hd__a211o_1
X_4293_ _1090_ VGND VGND VPWR VPWR net135 sky130_fd_sc_hd__clkbuf_4
XFILLER_0_6_79 VGND VGND VPWR VPWR sky130_fd_sc_hd__decap_3
XANTENNA__4709__S0 _1418_ VGND VGND VPWR VPWR sky130_fd_sc_hd__diode_2
X_7081_ net16 VGND VGND VPWR VPWR _3433_ sky130_fd_sc_hd__buf_2
X_6032_ _1396_ _2205_ _2206_ _2706_ _1414_ VGND VGND VPWR VPWR _2749_ sky130_fd_sc_hd__a41o_1
XANTENNA__5382__S0 _2119_ VGND VGND VPWR VPWR sky130_fd_sc_hd__diode_2
XTAP_TAPCELL_ROW_72_1190 VGND VPWR sky130_fd_sc_hd__tapvpwrvgnd_1
XFILLER_0_83_53 VGND VGND VPWR VPWR sky130_fd_sc_hd__decap_3
XANTENNA__5222__S _1856_ VGND VGND VPWR VPWR sky130_fd_sc_hd__diode_2
X_7983_ _3927_ VGND VGND VPWR VPWR _0400_ sky130_fd_sc_hd__clkbuf_1
XFILLER_0_89_661 VGND VGND VPWR VPWR sky130_fd_sc_hd__fill_1
XFILLER_0_76_300 VGND VGND VPWR VPWR sky130_fd_sc_hd__fill_2
X_6934_ _3354_ VGND VGND VPWR VPWR _0948_ sky130_fd_sc_hd__clkbuf_1
XFILLER_0_49_558 VGND VGND VPWR VPWR sky130_fd_sc_hd__fill_2
XFILLER_0_9_600 VPWR VGND VPWR VGND sky130_ef_sc_hd__decap_12
XANTENNA__8528__A1 net32 VGND VGND VPWR VPWR sky130_fd_sc_hd__diode_2
XFILLER_0_76_355 VGND VGND VPWR VPWR sky130_fd_sc_hd__decap_3
XANTENNA__7200__A1 _3451_ VGND VGND VPWR VPWR sky130_fd_sc_hd__diode_2
XFILLER_0_49_569 VGND VGND VPWR VPWR sky130_fd_sc_hd__decap_3
X_8604_ clknet_leaf_109_clk _0725_ VGND VGND VPWR VPWR registers\[3\]\[28\] sky130_fd_sc_hd__dfxtp_1
XANTENNA__7149__S _3477_ VGND VGND VPWR VPWR sky130_fd_sc_hd__diode_2
X_6865_ registers\[12\]\[27\] _3018_ _3310_ VGND VGND VPWR VPWR _3318_ sky130_fd_sc_hd__mux2_1
XFILLER_0_119_468 VGND VGND VPWR VPWR sky130_fd_sc_hd__decap_4
XFILLER_0_119_457 VGND VGND VPWR VPWR sky130_fd_sc_hd__fill_1
X_5816_ _2279_ _2543_ _2544_ _2317_ VGND VGND VPWR VPWR _2545_ sky130_fd_sc_hd__a211o_1
XFILLER_0_9_677 VGND VGND VPWR VPWR sky130_fd_sc_hd__fill_1
X_6796_ _3280_ VGND VGND VPWR VPWR _0884_ sky130_fd_sc_hd__clkbuf_1
XFILLER_0_29_260 VGND VGND VPWR VPWR sky130_fd_sc_hd__decap_3
X_5747_ _2477_ _2478_ VGND VGND VPWR VPWR _2479_ sky130_fd_sc_hd__nor2_1
XFILLER_0_9_699 VGND VGND VPWR VPWR sky130_fd_sc_hd__fill_2
XTAP_TAPCELL_ROW_20_523 VGND VPWR sky130_fd_sc_hd__tapvpwrvgnd_1
X_8535_ _4219_ VGND VGND VPWR VPWR _0660_ sky130_fd_sc_hd__clkbuf_1
XANTENNA__6988__S _3383_ VGND VGND VPWR VPWR sky130_fd_sc_hd__diode_2
XFILLER_0_60_712 VGND VGND VPWR VPWR sky130_fd_sc_hd__fill_1
XFILLER_0_60_701 VGND VGND VPWR VPWR sky130_fd_sc_hd__fill_2
X_8466_ registers\[8\]\[27\] net35 _4175_ VGND VGND VPWR VPWR _4183_ sky130_fd_sc_hd__mux2_1
XFILLER_0_115_685 VPWR VGND VPWR VGND sky130_ef_sc_hd__decap_12
XFILLER_0_114_162 VGND VGND VPWR VPWR sky130_fd_sc_hd__decap_3
X_7417_ _3627_ VGND VGND VPWR VPWR _0134_ sky130_fd_sc_hd__clkbuf_1
X_5678_ _2249_ _2256_ _2266_ VGND VGND VPWR VPWR _2412_ sky130_fd_sc_hd__mux2_1
XFILLER_0_44_285 VGND VGND VPWR VPWR sky130_fd_sc_hd__decap_4
XFILLER_0_114_195 VGND VGND VPWR VPWR sky130_fd_sc_hd__fill_1
X_4629_ registers\[4\]\[19\] registers\[5\]\[19\] registers\[6\]\[19\] registers\[7\]\[19\]
+ _1347_ _1348_ VGND VGND VPWR VPWR _1410_ sky130_fd_sc_hd__mux4_1
XANTENNA__6289__A _2961_ VGND VGND VPWR VPWR sky130_fd_sc_hd__diode_2
XFILLER_0_4_393 VGND VGND VPWR VPWR sky130_fd_sc_hd__fill_2
X_8397_ _4146_ VGND VGND VPWR VPWR _0595_ sky130_fd_sc_hd__clkbuf_1
X_7348_ _3590_ VGND VGND VPWR VPWR _0102_ sky130_fd_sc_hd__clkbuf_1
X_7279_ registers\[18\]\[13\] _3462_ _3550_ VGND VGND VPWR VPWR _3554_ sky130_fd_sc_hd__mux2_1
XFILLER_0_4_7 VGND VGND VPWR VPWR sky130_fd_sc_hd__decap_4
X_9018_ clknet_leaf_90_clk _0115_ VGND VGND VPWR VPWR registers\[1\]\[26\] sky130_fd_sc_hd__dfxtp_1
XANTENNA__5373__S0 _2020_ VGND VGND VPWR VPWR sky130_fd_sc_hd__diode_2
XTAP_TAPCELL_ROW_28_623 VGND VPWR sky130_fd_sc_hd__tapvpwrvgnd_1
XANTENNA__8443__S _4164_ VGND VGND VPWR VPWR sky130_fd_sc_hd__diode_2
XFILLER_0_79_193 VGND VGND VPWR VPWR sky130_fd_sc_hd__fill_2
XTAP_TAPCELL_ROW_56_987 VGND VPWR sky130_fd_sc_hd__tapvpwrvgnd_1
XFILLER_0_94_141 VGND VGND VPWR VPWR sky130_fd_sc_hd__fill_1
XANTENNA__7059__S _3420_ VGND VGND VPWR VPWR sky130_fd_sc_hd__diode_2
XFILLER_0_94_185 VGND VGND VPWR VPWR sky130_fd_sc_hd__decap_3
XANTENNA__4272__A _1070_ VGND VGND VPWR VPWR sky130_fd_sc_hd__diode_2
XANTENNA__6898__S _3335_ VGND VGND VPWR VPWR sky130_fd_sc_hd__diode_2
XFILLER_0_82_358 VGND VGND VPWR VPWR sky130_fd_sc_hd__fill_2
XANTENNA_clkbuf_4_14_0_clk_A clknet_0_clk VGND VGND VPWR VPWR sky130_fd_sc_hd__diode_2
XFILLER_0_70_509 VGND VGND VPWR VPWR sky130_fd_sc_hd__decap_4
XFILLER_0_63_561 VGND VGND VPWR VPWR sky130_fd_sc_hd__fill_2
XFILLER_0_23_414 VGND VGND VPWR VPWR sky130_fd_sc_hd__decap_3
XFILLER_0_106_674 VGND VGND VPWR VPWR sky130_fd_sc_hd__decap_3
XFILLER_0_106_663 VGND VGND VPWR VPWR sky130_fd_sc_hd__fill_1
XFILLER_0_23_447 VGND VGND VPWR VPWR sky130_fd_sc_hd__fill_1
Xoutput60 net60 VGND VGND VPWR VPWR alu_result[1] sky130_fd_sc_hd__buf_1
Xoutput71 net71 VGND VGND VPWR VPWR alu_result[2] sky130_fd_sc_hd__buf_1
Xoutput93 net93 VGND VGND VPWR VPWR rd1[20] sky130_fd_sc_hd__buf_1
Xoutput82 net82 VGND VGND VPWR VPWR rd1[10] sky130_fd_sc_hd__buf_1
XANTENNA__5364__S0 _1996_ VGND VGND VPWR VPWR sky130_fd_sc_hd__diode_2
XFILLER_0_37_57 VGND VGND VPWR VPWR sky130_fd_sc_hd__fill_2
XANTENNA__6138__S net113 VGND VGND VPWR VPWR sky130_fd_sc_hd__diode_2
XFILLER_0_78_609 VGND VGND VPWR VPWR sky130_fd_sc_hd__fill_1
XFILLER_0_77_108 VGND VGND VPWR VPWR sky130_fd_sc_hd__fill_1
XFILLER_0_53_23 VGND VGND VPWR VPWR sky130_fd_sc_hd__decap_3
X_4980_ _1678_ VGND VGND VPWR VPWR _1742_ sky130_fd_sc_hd__buf_4
XFILLER_0_86_620 VGND VGND VPWR VPWR sky130_fd_sc_hd__fill_2
XANTENNA__4244__A1 net6 VGND VGND VPWR VPWR sky130_fd_sc_hd__diode_2
XANTENNA__5278__A _2019_ VGND VGND VPWR VPWR sky130_fd_sc_hd__diode_2
X_6650_ registers\[0\]\[24\] _3012_ _3197_ VGND VGND VPWR VPWR _3202_ sky130_fd_sc_hd__mux2_1
X_5601_ _2332_ _2335_ _1072_ VGND VGND VPWR VPWR _2336_ sky130_fd_sc_hd__mux2_1
X_6581_ _3164_ VGND VGND VPWR VPWR _0785_ sky130_fd_sc_hd__clkbuf_1
XFILLER_0_116_449 VGND VGND VPWR VPWR sky130_fd_sc_hd__fill_2
XFILLER_0_116_438 VGND VGND VPWR VPWR sky130_fd_sc_hd__fill_2
X_5532_ _2267_ net81 VGND VGND VPWR VPWR _2268_ sky130_fd_sc_hd__nand2_1
XFILLER_0_42_723 VGND VGND VPWR VPWR sky130_fd_sc_hd__fill_2
X_8320_ _3008_ registers\[31\]\[22\] _4103_ VGND VGND VPWR VPWR _4106_ sky130_fd_sc_hd__mux2_1
XFILLER_0_14_414 VGND VGND VPWR VPWR sky130_fd_sc_hd__fill_2
XFILLER_0_26_274 VGND VGND VPWR VPWR sky130_fd_sc_hd__fill_2
XFILLER_0_81_391 VGND VGND VPWR VPWR sky130_fd_sc_hd__fill_1
X_5463_ _2197_ _2198_ VGND VGND VPWR VPWR _2199_ sky130_fd_sc_hd__nor2_2
XANTENNA__5217__S _1754_ VGND VGND VPWR VPWR sky130_fd_sc_hd__diode_2
XFILLER_0_41_266 VGND VGND VPWR VPWR sky130_fd_sc_hd__fill_2
X_8251_ _4069_ VGND VGND VPWR VPWR _0526_ sky130_fd_sc_hd__clkbuf_1
XFILLER_0_111_154 VGND VGND VPWR VPWR sky130_fd_sc_hd__fill_1
X_4414_ _1135_ _1206_ _1142_ VGND VGND VPWR VPWR _1207_ sky130_fd_sc_hd__a21oi_1
XFILLER_0_78_53 VGND VGND VPWR VPWR sky130_fd_sc_hd__fill_2
X_7202_ registers\[17\]\[9\] _3453_ _3503_ VGND VGND VPWR VPWR _3513_ sky130_fd_sc_hd__mux2_1
X_8182_ registers\[9\]\[21\] _3479_ _4031_ VGND VGND VPWR VPWR _4033_ sky130_fd_sc_hd__mux2_1
X_5394_ _2129_ _2131_ _2134_ _2019_ _1960_ VGND VGND VPWR VPWR _2135_ sky130_fd_sc_hd__o221a_1
X_4345_ _1138_ _1139_ _1140_ VGND VGND VPWR VPWR _1141_ sky130_fd_sc_hd__mux2_1
X_7133_ registers\[16\]\[16\] _3468_ _3456_ VGND VGND VPWR VPWR _3469_ sky130_fd_sc_hd__mux2_1
XFILLER_0_1_385 VGND VGND VPWR VPWR sky130_fd_sc_hd__decap_4
XANTENNA__8528__S _4211_ VGND VGND VPWR VPWR sky130_fd_sc_hd__diode_2
XFILLER_0_111_198 VGND VGND VPWR VPWR sky130_fd_sc_hd__fill_2
X_7064_ _3424_ VGND VGND VPWR VPWR _1008_ sky130_fd_sc_hd__clkbuf_1
XANTENNA__5355__S0 _2097_ VGND VGND VPWR VPWR sky130_fd_sc_hd__diode_2
X_4276_ registers\[20\]\[2\] registers\[21\]\[2\] registers\[22\]\[2\] registers\[23\]\[2\]
+ _1039_ _1040_ VGND VGND VPWR VPWR _1074_ sky130_fd_sc_hd__mux4_1
X_6015_ _2688_ _2732_ _2352_ VGND VGND VPWR VPWR _2733_ sky130_fd_sc_hd__mux2_1
XFILLER_0_69_609 VGND VGND VPWR VPWR sky130_fd_sc_hd__decap_4
XFILLER_0_27_90 VGND VGND VPWR VPWR sky130_fd_sc_hd__fill_2
XFILLER_0_96_428 VGND VGND VPWR VPWR sky130_fd_sc_hd__fill_2
XANTENNA__4791__S _1386_ VGND VGND VPWR VPWR sky130_fd_sc_hd__diode_2
XFILLER_0_77_620 VGND VGND VPWR VPWR sky130_fd_sc_hd__fill_2
X_7966_ _3918_ VGND VGND VPWR VPWR _0392_ sky130_fd_sc_hd__clkbuf_1
XTAP_TAPCELL_ROW_85_1370 VGND VPWR sky130_fd_sc_hd__tapvpwrvgnd_1
XANTENNA__5983__A1 net87 VGND VGND VPWR VPWR sky130_fd_sc_hd__diode_2
X_7897_ _3100_ registers\[27\]\[15\] _3876_ VGND VGND VPWR VPWR _3882_ sky130_fd_sc_hd__mux2_1
X_6917_ _3345_ VGND VGND VPWR VPWR _0940_ sky130_fd_sc_hd__clkbuf_1
XTAP_TAPCELL_ROW_53_946 VGND VPWR sky130_fd_sc_hd__tapvpwrvgnd_1
XFILLER_0_119_221 VGND VGND VPWR VPWR sky130_fd_sc_hd__decap_3
XFILLER_0_76_185 VGND VGND VPWR VPWR sky130_fd_sc_hd__fill_2
X_6848_ registers\[12\]\[19\] _3001_ _3299_ VGND VGND VPWR VPWR _3309_ sky130_fd_sc_hd__mux2_1
XFILLER_0_49_388 VGND VGND VPWR VPWR sky130_fd_sc_hd__fill_2
XFILLER_0_119_276 VGND VGND VPWR VPWR sky130_fd_sc_hd__decap_4
XFILLER_0_119_265 VGND VGND VPWR VPWR sky130_fd_sc_hd__decap_8
XFILLER_0_107_405 VGND VGND VPWR VPWR sky130_fd_sc_hd__fill_2
XFILLER_0_92_645 VGND VGND VPWR VPWR sky130_fd_sc_hd__fill_2
XFILLER_0_91_122 VGND VGND VPWR VPWR sky130_fd_sc_hd__decap_3
X_9567_ clknet_leaf_99_clk _0664_ VGND VGND VPWR VPWR registers\[4\]\[31\] sky130_fd_sc_hd__dfxtp_1
XFILLER_0_9_463 VGND VGND VPWR VPWR sky130_fd_sc_hd__fill_2
XFILLER_0_107_449 VGND VGND VPWR VPWR sky130_fd_sc_hd__fill_2
XANTENNA__7607__S _3720_ VGND VGND VPWR VPWR sky130_fd_sc_hd__diode_2
X_8518_ _4210_ VGND VGND VPWR VPWR _0652_ sky130_fd_sc_hd__clkbuf_1
X_6779_ _3271_ VGND VGND VPWR VPWR _0876_ sky130_fd_sc_hd__clkbuf_1
XTAP_TAPCELL_ROW_33_692 VGND VPWR sky130_fd_sc_hd__tapvpwrvgnd_1
XFILLER_0_103_600 VGND VGND VPWR VPWR sky130_fd_sc_hd__decap_8
XFILLER_0_17_285 VGND VGND VPWR VPWR sky130_fd_sc_hd__fill_2
X_9498_ clknet_leaf_91_clk _0595_ VGND VGND VPWR VPWR registers\[5\]\[26\] sky130_fd_sc_hd__dfxtp_1
XFILLER_0_103_633 VGND VGND VPWR VPWR sky130_fd_sc_hd__fill_2
X_8449_ registers\[8\]\[19\] net26 _4164_ VGND VGND VPWR VPWR _4174_ sky130_fd_sc_hd__mux2_1
XFILLER_0_5_680 VGND VGND VPWR VPWR sky130_fd_sc_hd__decap_3
XFILLER_0_103_666 VGND VGND VPWR VPWR sky130_fd_sc_hd__decap_4
XFILLER_0_20_417 VGND VGND VPWR VPWR sky130_fd_sc_hd__decap_3
XANTENNA__5346__S0 _2027_ VGND VGND VPWR VPWR sky130_fd_sc_hd__diode_2
XANTENNA__7412__A1 _3458_ VGND VGND VPWR VPWR sky130_fd_sc_hd__diode_2
XFILLER_0_87_406 VGND VGND VPWR VPWR sky130_fd_sc_hd__decap_3
XANTENNA__8173__S _4020_ VGND VGND VPWR VPWR sky130_fd_sc_hd__diode_2
XFILLER_0_67_152 VGND VGND VPWR VPWR sky130_fd_sc_hd__decap_3
XFILLER_0_83_623 VGND VGND VPWR VPWR sky130_fd_sc_hd__fill_2
XANTENNA__5826__A _1780_ VGND VGND VPWR VPWR sky130_fd_sc_hd__diode_2
XANTENNA__6421__S _3029_ VGND VGND VPWR VPWR sky130_fd_sc_hd__diode_2
XANTENNA__7517__S _3670_ VGND VGND VPWR VPWR sky130_fd_sc_hd__diode_2
XFILLER_0_24_701 VGND VGND VPWR VPWR sky130_fd_sc_hd__decap_3
XFILLER_0_113_419 VGND VGND VPWR VPWR sky130_fd_sc_hd__fill_2
XFILLER_0_3_617 VGND VGND VPWR VPWR sky130_fd_sc_hd__fill_2
XFILLER_0_36_583 VGND VGND VPWR VPWR sky130_fd_sc_hd__fill_2
XTAP_TAPCELL_ROW_11_397 VGND VPWR sky130_fd_sc_hd__tapvpwrvgnd_1
XFILLER_0_23_244 VGND VGND VPWR VPWR sky130_fd_sc_hd__fill_2
XFILLER_0_11_428 VGND VGND VPWR VPWR sky130_fd_sc_hd__decap_4
XFILLER_0_11_439 VGND VGND VPWR VPWR sky130_fd_sc_hd__fill_1
XANTENNA__5561__A _2295_ VGND VGND VPWR VPWR sky130_fd_sc_hd__diode_2
XANTENNA__8348__S _4117_ VGND VGND VPWR VPWR sky130_fd_sc_hd__diode_2
XANTENNA__7252__S _3539_ VGND VGND VPWR VPWR sky130_fd_sc_hd__diode_2
XFILLER_0_64_33 VGND VGND VPWR VPWR sky130_fd_sc_hd__fill_2
XFILLER_0_3_69 VPWR VGND VPWR VGND sky130_ef_sc_hd__decap_12
X_7820_ _3841_ VGND VGND VPWR VPWR _0323_ sky130_fd_sc_hd__clkbuf_1
XTAP_TAPCELL_ROW_108_1657 VGND VPWR sky130_fd_sc_hd__tapvpwrvgnd_1
XANTENNA__7403__A1 _3449_ VGND VGND VPWR VPWR sky130_fd_sc_hd__diode_2
XTAP_TAPCELL_ROW_108_1668 VGND VPWR sky130_fd_sc_hd__tapvpwrvgnd_1
XFILLER_0_59_631 VGND VGND VPWR VPWR sky130_fd_sc_hd__fill_2
X_7751_ _3089_ registers\[25\]\[10\] _3804_ VGND VGND VPWR VPWR _3805_ sky130_fd_sc_hd__mux2_1
X_4963_ registers\[24\]\[5\] registers\[25\]\[5\] registers\[26\]\[5\] registers\[27\]\[5\]
+ _1719_ _1720_ VGND VGND VPWR VPWR _1726_ sky130_fd_sc_hd__mux4_1
XFILLER_0_58_141 VGND VGND VPWR VPWR sky130_fd_sc_hd__fill_1
X_6702_ registers\[10\]\[15\] _2993_ _3225_ VGND VGND VPWR VPWR _3231_ sky130_fd_sc_hd__mux2_1
X_7682_ _3756_ VGND VGND VPWR VPWR _3768_ sky130_fd_sc_hd__clkbuf_8
XTAP_TAPCELL_ROW_50_905 VGND VPWR sky130_fd_sc_hd__tapvpwrvgnd_1
X_9421_ clknet_leaf_48_clk _0518_ VGND VGND VPWR VPWR registers\[6\]\[13\] sky130_fd_sc_hd__dfxtp_1
XFILLER_0_74_645 VGND VGND VPWR VPWR sky130_fd_sc_hd__fill_2
XFILLER_0_73_133 VGND VGND VPWR VPWR sky130_fd_sc_hd__fill_2
X_6633_ registers\[0\]\[16\] _2995_ _3186_ VGND VGND VPWR VPWR _3193_ sky130_fd_sc_hd__mux2_1
X_4894_ _1660_ VGND VGND VPWR VPWR net92 sky130_fd_sc_hd__inv_2
XFILLER_0_6_400 VGND VGND VPWR VPWR sky130_fd_sc_hd__decap_3
XANTENNA__5736__A _1108_ VGND VGND VPWR VPWR sky130_fd_sc_hd__diode_2
XFILLER_0_27_561 VGND VGND VPWR VPWR sky130_fd_sc_hd__decap_4
X_6564_ _3155_ VGND VGND VPWR VPWR _0777_ sky130_fd_sc_hd__clkbuf_1
X_9352_ clknet_leaf_20_clk _0449_ VGND VGND VPWR VPWR registers\[30\]\[8\] sky130_fd_sc_hd__dfxtp_1
XFILLER_0_54_391 VGND VGND VPWR VPWR sky130_fd_sc_hd__fill_2
XTAP_TAPCELL_ROW_30_651 VGND VPWR sky130_fd_sc_hd__tapvpwrvgnd_1
X_8303_ _2991_ registers\[31\]\[14\] _4092_ VGND VGND VPWR VPWR _4097_ sky130_fd_sc_hd__mux2_1
X_5515_ _2152_ _2234_ VGND VGND VPWR VPWR _2251_ sky130_fd_sc_hd__nor2_1
X_9283_ clknet_leaf_20_clk _0380_ VGND VGND VPWR VPWR registers\[28\]\[3\] sky130_fd_sc_hd__dfxtp_1
XFILLER_0_42_564 VGND VGND VPWR VPWR sky130_fd_sc_hd__fill_1
X_6495_ _3113_ registers\[29\]\[21\] _3111_ VGND VGND VPWR VPWR _3114_ sky130_fd_sc_hd__mux2_1
XFILLER_0_112_430 VGND VGND VPWR VPWR sky130_fd_sc_hd__fill_2
X_8234_ _4060_ VGND VGND VPWR VPWR _0518_ sky130_fd_sc_hd__clkbuf_1
XFILLER_0_42_597 VGND VGND VPWR VPWR sky130_fd_sc_hd__decap_3
X_5446_ registers\[24\]\[31\] registers\[25\]\[31\] registers\[26\]\[31\] registers\[27\]\[31\]
+ _2119_ _2120_ VGND VGND VPWR VPWR _2183_ sky130_fd_sc_hd__mux4_1
XFILLER_0_100_625 VGND VGND VPWR VPWR sky130_fd_sc_hd__fill_1
XANTENNA__4379__S1 _1168_ VGND VGND VPWR VPWR sky130_fd_sc_hd__diode_2
X_8165_ registers\[9\]\[13\] _3462_ _4020_ VGND VGND VPWR VPWR _4024_ sky130_fd_sc_hd__mux2_1
XANTENNA__8258__S _4067_ VGND VGND VPWR VPWR sky130_fd_sc_hd__diode_2
X_5377_ _2118_ VGND VGND VPWR VPWR net99 sky130_fd_sc_hd__inv_2
X_7116_ _3457_ VGND VGND VPWR VPWR _0003_ sky130_fd_sc_hd__clkbuf_1
X_8096_ _3987_ VGND VGND VPWR VPWR _0453_ sky130_fd_sc_hd__clkbuf_1
X_4328_ _1122_ VGND VGND VPWR VPWR _1124_ sky130_fd_sc_hd__buf_6
X_7047_ _3415_ VGND VGND VPWR VPWR _1000_ sky130_fd_sc_hd__clkbuf_1
XANTENNA_input1_A a1[0] VGND VGND VPWR VPWR sky130_fd_sc_hd__diode_2
X_4259_ registers\[20\]\[1\] registers\[21\]\[1\] registers\[22\]\[1\] registers\[23\]\[1\]
+ _1053_ _1054_ VGND VGND VPWR VPWR _1058_ sky130_fd_sc_hd__mux4_1
XFILLER_0_97_704 VGND VGND VPWR VPWR sky130_fd_sc_hd__fill_2
X_8998_ clknet_leaf_37_clk _0095_ VGND VGND VPWR VPWR registers\[1\]\[6\] sky130_fd_sc_hd__dfxtp_1
XANTENNA__4815__A _1585_ VGND VGND VPWR VPWR sky130_fd_sc_hd__diode_2
XTAP_TAPCELL_ROW_38_751 VGND VPWR sky130_fd_sc_hd__tapvpwrvgnd_1
XANTENNA__5410__S _2081_ VGND VGND VPWR VPWR sky130_fd_sc_hd__diode_2
X_7949_ _3909_ VGND VGND VPWR VPWR _0384_ sky130_fd_sc_hd__clkbuf_1
XANTENNA__4303__S1 _1027_ VGND VGND VPWR VPWR sky130_fd_sc_hd__diode_2
XFILLER_0_65_634 VGND VGND VPWR VPWR sky130_fd_sc_hd__fill_2
XFILLER_0_65_656 VGND VGND VPWR VPWR sky130_fd_sc_hd__decap_3
XFILLER_0_92_475 VGND VGND VPWR VPWR sky130_fd_sc_hd__fill_1
XFILLER_0_92_464 VGND VGND VPWR VPWR sky130_fd_sc_hd__fill_2
XFILLER_0_80_604 VGND VGND VPWR VPWR sky130_fd_sc_hd__fill_2
XFILLER_0_52_306 VGND VGND VPWR VPWR sky130_fd_sc_hd__fill_2
XFILLER_0_64_188 VGND VGND VPWR VPWR sky130_fd_sc_hd__fill_2
XANTENNA__8022__A _3936_ VGND VGND VPWR VPWR sky130_fd_sc_hd__diode_2
XFILLER_0_45_380 VGND VGND VPWR VPWR sky130_fd_sc_hd__fill_1
XFILLER_0_33_542 VGND VGND VPWR VPWR sky130_fd_sc_hd__fill_2
XANTENNA__6133__A1 _2490_ VGND VGND VPWR VPWR sky130_fd_sc_hd__diode_2
XFILLER_0_103_474 VGND VGND VPWR VPWR sky130_fd_sc_hd__fill_1
XFILLER_0_18_26 VGND VGND VPWR VPWR sky130_fd_sc_hd__fill_2
XANTENNA_clkbuf_leaf_8_clk_A clknet_4_3_0_clk VGND VGND VPWR VPWR sky130_fd_sc_hd__diode_2
XANTENNA__7800__S _3829_ VGND VGND VPWR VPWR sky130_fd_sc_hd__diode_2
XANTENNA__4542__S1 _1321_ VGND VGND VPWR VPWR sky130_fd_sc_hd__diode_2
XANTENNA__7101__A net44 VGND VGND VPWR VPWR sky130_fd_sc_hd__diode_2
XFILLER_0_87_225 VGND VGND VPWR VPWR sky130_fd_sc_hd__fill_1
XANTENNA__4725__A _1500_ VGND VGND VPWR VPWR sky130_fd_sc_hd__diode_2
XFILLER_0_55_100 VGND VGND VPWR VPWR sky130_fd_sc_hd__fill_1
XTAP_TAPCELL_ROW_16_467 VGND VPWR sky130_fd_sc_hd__tapvpwrvgnd_1
XTAP_TAPCELL_ROW_103_1598 VGND VPWR sky130_fd_sc_hd__tapvpwrvgnd_1
XFILLER_0_71_615 VGND VGND VPWR VPWR sky130_fd_sc_hd__fill_1
XFILLER_0_70_103 VGND VGND VPWR VPWR sky130_fd_sc_hd__fill_2
XFILLER_0_24_564 VGND VGND VPWR VPWR sky130_fd_sc_hd__fill_2
XTAP_TAPCELL_ROW_58_1011 VGND VPWR sky130_fd_sc_hd__tapvpwrvgnd_1
X_5300_ _2044_ _2045_ _1767_ VGND VGND VPWR VPWR _2046_ sky130_fd_sc_hd__mux2_1
XANTENNA__7771__A _3792_ VGND VGND VPWR VPWR sky130_fd_sc_hd__diode_2
X_6280_ registers\[19\]\[7\] _2976_ _2962_ VGND VGND VPWR VPWR _2977_ sky130_fd_sc_hd__mux2_1
XFILLER_0_59_55 VGND VGND VPWR VPWR sky130_fd_sc_hd__fill_1
XANTENNA__8078__S _3973_ VGND VGND VPWR VPWR sky130_fd_sc_hd__diode_2
X_5231_ registers\[20\]\[19\] registers\[21\]\[19\] registers\[22\]\[19\] registers\[23\]\[19\]
+ _1719_ _1720_ VGND VGND VPWR VPWR _1980_ sky130_fd_sc_hd__mux4_1
X_5162_ registers\[16\]\[15\] registers\[17\]\[15\] registers\[18\]\[15\] registers\[19\]\[15\]
+ _1806_ _1759_ VGND VGND VPWR VPWR _1915_ sky130_fd_sc_hd__mux4_1
X_5093_ _1741_ _1842_ _1846_ _1850_ VGND VGND VPWR VPWR _1851_ sky130_fd_sc_hd__a2bb2o_4
XFILLER_0_45_7 VGND VGND VPWR VPWR sky130_fd_sc_hd__decap_4
X_8921_ clknet_leaf_79_clk _0018_ VGND VGND VPWR VPWR registers\[16\]\[25\] sky130_fd_sc_hd__dfxtp_1
XANTENNA__7710__S _3779_ VGND VGND VPWR VPWR sky130_fd_sc_hd__diode_2
XFILLER_0_79_726 VGND VGND VPWR VPWR sky130_fd_sc_hd__fill_2
XFILLER_0_79_715 VGND VGND VPWR VPWR sky130_fd_sc_hd__fill_1
XFILLER_0_79_704 VGND VGND VPWR VPWR sky130_fd_sc_hd__decap_4
XANTENNA__4635__A _1160_ VGND VGND VPWR VPWR sky130_fd_sc_hd__diode_2
XFILLER_0_78_236 VGND VGND VPWR VPWR sky130_fd_sc_hd__fill_2
XTAP_TAPCELL_ROW_69_1162 VGND VPWR sky130_fd_sc_hd__tapvpwrvgnd_1
XTAP_TAPCELL_ROW_69_1151 VGND VPWR sky130_fd_sc_hd__tapvpwrvgnd_1
X_8852_ clknet_leaf_84_clk _0973_ VGND VGND VPWR VPWR registers\[14\]\[20\] sky130_fd_sc_hd__dfxtp_1
XFILLER_0_78_247 VGND VGND VPWR VPWR sky130_fd_sc_hd__fill_2
X_8783_ clknet_leaf_47_clk _0904_ VGND VGND VPWR VPWR registers\[12\]\[15\] sky130_fd_sc_hd__dfxtp_1
X_7803_ _3832_ VGND VGND VPWR VPWR _0315_ sky130_fd_sc_hd__clkbuf_1
XANTENNA_clkbuf_4_2_0_clk_A clknet_0_clk VGND VGND VPWR VPWR sky130_fd_sc_hd__diode_2
XTAP_TAPCELL_ROW_35_710 VGND VPWR sky130_fd_sc_hd__tapvpwrvgnd_1
XFILLER_0_115_82 VGND VGND VPWR VPWR sky130_fd_sc_hd__fill_2
XFILLER_0_91_97 VGND VGND VPWR VPWR sky130_fd_sc_hd__decap_4
XANTENNA__4297__S0 _1060_ VGND VGND VPWR VPWR sky130_fd_sc_hd__diode_2
X_5995_ _1943_ _2709_ VGND VGND VPWR VPWR _2714_ sky130_fd_sc_hd__nor2_1
XFILLER_0_47_623 VGND VGND VPWR VPWR sky130_fd_sc_hd__decap_8
XFILLER_0_19_314 VGND VGND VPWR VPWR sky130_fd_sc_hd__fill_2
X_7734_ _3073_ registers\[25\]\[2\] _3793_ VGND VGND VPWR VPWR _3796_ sky130_fd_sc_hd__mux2_1
X_4946_ registers\[28\]\[4\] registers\[29\]\[4\] registers\[30\]\[4\] registers\[31\]\[4\]
+ _1705_ _1706_ VGND VGND VPWR VPWR _1710_ sky130_fd_sc_hd__mux4_1
XFILLER_0_46_133 VGND VGND VPWR VPWR sky130_fd_sc_hd__fill_2
XANTENNA__6850__A _3287_ VGND VGND VPWR VPWR sky130_fd_sc_hd__diode_2
XFILLER_0_117_544 VGND VGND VPWR VPWR sky130_fd_sc_hd__fill_2
X_4877_ registers\[20\]\[1\] registers\[21\]\[1\] registers\[22\]\[1\] registers\[23\]\[1\]
+ _1642_ _1643_ VGND VGND VPWR VPWR _1644_ sky130_fd_sc_hd__mux4_1
X_7665_ _3759_ VGND VGND VPWR VPWR _0250_ sky130_fd_sc_hd__clkbuf_1
XANTENNA__7560__A0 _3104_ VGND VGND VPWR VPWR sky130_fd_sc_hd__diode_2
X_6616_ registers\[0\]\[8\] _2978_ _3175_ VGND VGND VPWR VPWR _3184_ sky130_fd_sc_hd__mux2_1
XFILLER_0_46_188 VGND VGND VPWR VPWR sky130_fd_sc_hd__fill_2
XANTENNA__6363__A1 _2966_ VGND VGND VPWR VPWR sky130_fd_sc_hd__diode_2
X_9404_ clknet_leaf_105_clk _0501_ VGND VGND VPWR VPWR registers\[9\]\[28\] sky130_fd_sc_hd__dfxtp_1
X_7596_ _3722_ VGND VGND VPWR VPWR _0218_ sky130_fd_sc_hd__clkbuf_1
XFILLER_0_27_380 VGND VGND VPWR VPWR sky130_fd_sc_hd__fill_2
XFILLER_0_104_227 VGND VGND VPWR VPWR sky130_fd_sc_hd__fill_2
X_6547_ _3146_ VGND VGND VPWR VPWR _0769_ sky130_fd_sc_hd__clkbuf_1
XANTENNA__6996__S _3383_ VGND VGND VPWR VPWR sky130_fd_sc_hd__diode_2
X_9335_ clknet_leaf_92_clk _0432_ VGND VGND VPWR VPWR registers\[2\]\[23\] sky130_fd_sc_hd__dfxtp_1
XFILLER_0_70_692 VGND VGND VPWR VPWR sky130_fd_sc_hd__decap_4
XFILLER_0_42_383 VGND VGND VPWR VPWR sky130_fd_sc_hd__fill_2
X_6478_ net23 VGND VGND VPWR VPWR _3102_ sky130_fd_sc_hd__clkbuf_2
X_9266_ clknet_leaf_71_clk _0363_ VGND VGND VPWR VPWR registers\[27\]\[18\] sky130_fd_sc_hd__dfxtp_1
X_8217_ _4051_ VGND VGND VPWR VPWR _0510_ sky130_fd_sc_hd__clkbuf_1
X_9197_ clknet_leaf_57_clk _0294_ VGND VGND VPWR VPWR registers\[25\]\[13\] sky130_fd_sc_hd__dfxtp_1
X_5429_ _1977_ _2159_ _2163_ _2167_ VGND VGND VPWR VPWR _2168_ sky130_fd_sc_hd__o2bb2a_4
XFILLER_0_30_589 VGND VGND VPWR VPWR sky130_fd_sc_hd__fill_1
X_8148_ registers\[9\]\[5\] _3445_ _4009_ VGND VGND VPWR VPWR _4015_ sky130_fd_sc_hd__mux2_1
XFILLER_0_100_477 VGND VGND VPWR VPWR sky130_fd_sc_hd__fill_2
XANTENNA__4772__S1 _1405_ VGND VGND VPWR VPWR sky130_fd_sc_hd__diode_2
XANTENNA__7620__S _3731_ VGND VGND VPWR VPWR sky130_fd_sc_hd__diode_2
X_8079_ _3978_ VGND VGND VPWR VPWR _0445_ sky130_fd_sc_hd__clkbuf_1
XFILLER_0_97_523 VGND VGND VPWR VPWR sky130_fd_sc_hd__decap_3
XANTENNA__4545__A _1140_ VGND VGND VPWR VPWR sky130_fd_sc_hd__diode_2
XFILLER_0_85_707 VGND VGND VPWR VPWR sky130_fd_sc_hd__fill_2
XFILLER_0_69_258 VGND VGND VPWR VPWR sky130_fd_sc_hd__fill_2
XFILLER_0_57_409 VGND VGND VPWR VPWR sky130_fd_sc_hd__fill_2
XFILLER_0_85_729 VGND VGND VPWR VPWR sky130_fd_sc_hd__fill_1
XANTENNA__4288__S0 _1039_ VGND VGND VPWR VPWR sky130_fd_sc_hd__diode_2
XFILLER_0_38_645 VGND VGND VPWR VPWR sky130_fd_sc_hd__fill_2
XFILLER_0_37_111 VGND VGND VPWR VPWR sky130_fd_sc_hd__fill_1
XFILLER_0_108_533 VGND VGND VPWR VPWR sky130_fd_sc_hd__fill_2
XFILLER_0_53_615 VGND VGND VPWR VPWR sky130_fd_sc_hd__fill_1
XANTENNA__7067__S _3420_ VGND VGND VPWR VPWR sky130_fd_sc_hd__diode_2
XTAP_TAPCELL_ROW_13_426 VGND VPWR sky130_fd_sc_hd__tapvpwrvgnd_1
XFILLER_0_37_155 VGND VGND VPWR VPWR sky130_fd_sc_hd__fill_2
XFILLER_0_108_577 VGND VGND VPWR VPWR sky130_fd_sc_hd__fill_2
XFILLER_0_53_637 VGND VGND VPWR VPWR sky130_fd_sc_hd__decap_3
XFILLER_0_52_114 VGND VGND VPWR VPWR sky130_fd_sc_hd__fill_2
XTAP_TAPCELL_ROW_96_1509 VGND VPWR sky130_fd_sc_hd__tapvpwrvgnd_1
XFILLER_0_80_456 VGND VGND VPWR VPWR sky130_fd_sc_hd__fill_2
XFILLER_0_80_445 VGND VGND VPWR VPWR sky130_fd_sc_hd__fill_2
XFILLER_0_20_49 VGND VGND VPWR VPWR sky130_fd_sc_hd__fill_1
XANTENNA__4460__S0 _1110_ VGND VGND VPWR VPWR sky130_fd_sc_hd__diode_2
XFILLER_0_80_489 VGND VGND VPWR VPWR sky130_fd_sc_hd__fill_2
XFILLER_0_60_191 VGND VGND VPWR VPWR sky130_fd_sc_hd__decap_3
XFILLER_0_103_271 VGND VGND VPWR VPWR sky130_fd_sc_hd__decap_6
XFILLER_0_45_57 VGND VGND VPWR VPWR sky130_fd_sc_hd__decap_3
XTAP_TAPCELL_ROW_105_1627 VGND VPWR sky130_fd_sc_hd__tapvpwrvgnd_1
XFILLER_0_61_23 VGND VGND VPWR VPWR sky130_fd_sc_hd__fill_2
XFILLER_0_61_12 VGND VGND VPWR VPWR sky130_fd_sc_hd__fill_2
X_4800_ registers\[16\]\[29\] registers\[17\]\[29\] registers\[18\]\[29\] registers\[19\]\[29\]
+ _1555_ _1556_ VGND VGND VPWR VPWR _1571_ sky130_fd_sc_hd__mux4_1
XANTENNA__4279__S0 _1039_ VGND VGND VPWR VPWR sky130_fd_sc_hd__diode_2
X_5780_ _2409_ _2401_ _2403_ VGND VGND VPWR VPWR _2510_ sky130_fd_sc_hd__mux2_1
XFILLER_0_68_280 VGND VGND VPWR VPWR sky130_fd_sc_hd__decap_3
XFILLER_0_8_506 VGND VGND VPWR VPWR sky130_fd_sc_hd__fill_2
XFILLER_0_28_122 VGND VGND VPWR VPWR sky130_fd_sc_hd__fill_2
XFILLER_0_29_645 VGND VGND VPWR VPWR sky130_fd_sc_hd__decap_4
XTAP_TAPCELL_ROW_64_1092 VGND VPWR sky130_fd_sc_hd__tapvpwrvgnd_1
XFILLER_0_56_475 VGND VGND VPWR VPWR sky130_fd_sc_hd__fill_1
XFILLER_0_44_615 VGND VGND VPWR VPWR sky130_fd_sc_hd__decap_4
X_4731_ _1504_ _1505_ _1421_ VGND VGND VPWR VPWR _1506_ sky130_fd_sc_hd__mux2_1
XFILLER_0_28_144 VPWR VGND VPWR VGND sky130_ef_sc_hd__decap_12
XFILLER_0_29_689 VGND VGND VPWR VPWR sky130_fd_sc_hd__decap_3
XANTENNA__6345__A1 _3020_ VGND VGND VPWR VPWR sky130_fd_sc_hd__diode_2
X_7450_ _3644_ VGND VGND VPWR VPWR _0150_ sky130_fd_sc_hd__clkbuf_1
X_4662_ registers\[24\]\[21\] registers\[25\]\[21\] registers\[26\]\[21\] registers\[27\]\[21\]
+ _1427_ _1428_ VGND VGND VPWR VPWR _1441_ sky130_fd_sc_hd__mux4_1
XFILLER_0_28_177 VGND VGND VPWR VPWR sky130_fd_sc_hd__decap_4
XFILLER_0_28_188 VGND VGND VPWR VPWR sky130_fd_sc_hd__fill_2
XFILLER_0_114_525 VGND VGND VPWR VPWR sky130_fd_sc_hd__fill_1
XFILLER_0_9_57 VGND VGND VPWR VPWR sky130_fd_sc_hd__fill_2
X_6401_ registers\[3\]\[20\] _3003_ _3052_ VGND VGND VPWR VPWR _3053_ sky130_fd_sc_hd__mux2_1
XANTENNA__4451__S0 _1110_ VGND VGND VPWR VPWR sky130_fd_sc_hd__diode_2
X_4593_ _1373_ _1374_ _1344_ VGND VGND VPWR VPWR _1375_ sky130_fd_sc_hd__mux2_1
X_7381_ _3607_ VGND VGND VPWR VPWR _0118_ sky130_fd_sc_hd__clkbuf_1
X_9120_ clknet_leaf_112_clk _0217_ VGND VGND VPWR VPWR registers\[23\]\[0\] sky130_fd_sc_hd__dfxtp_1
XTAP_TAPCELL_ROW_116_1767 VGND VPWR sky130_fd_sc_hd__tapvpwrvgnd_1
XFILLER_0_3_277 VGND VGND VPWR VPWR sky130_fd_sc_hd__decap_3
X_6332_ net32 VGND VGND VPWR VPWR _3012_ sky130_fd_sc_hd__buf_2
XFILLER_0_110_720 VGND VGND VPWR VPWR sky130_fd_sc_hd__fill_2
XANTENNA__5733__B _1108_ VGND VGND VPWR VPWR sky130_fd_sc_hd__diode_2
XFILLER_0_86_20 VGND VGND VPWR VPWR sky130_fd_sc_hd__fill_2
XFILLER_0_12_589 VGND VGND VPWR VPWR sky130_fd_sc_hd__decap_8
X_6263_ _2965_ VGND VGND VPWR VPWR _0666_ sky130_fd_sc_hd__clkbuf_1
X_9051_ clknet_leaf_102_clk _0148_ VGND VGND VPWR VPWR registers\[20\]\[27\] sky130_fd_sc_hd__dfxtp_1
X_5214_ registers\[28\]\[18\] registers\[29\]\[18\] registers\[30\]\[18\] registers\[31\]\[18\]
+ _1820_ _1821_ VGND VGND VPWR VPWR _1964_ sky130_fd_sc_hd__mux4_1
X_8002_ registers\[2\]\[0\] _3433_ _3937_ VGND VGND VPWR VPWR _3938_ sky130_fd_sc_hd__mux2_1
XANTENNA__4659__A1 _1389_ VGND VGND VPWR VPWR sky130_fd_sc_hd__diode_2
X_6194_ _2874_ _2883_ VGND VGND VPWR VPWR _2902_ sky130_fd_sc_hd__and2b_1
XANTENNA__4754__S1 _1324_ VGND VGND VPWR VPWR sky130_fd_sc_hd__diode_2
X_5145_ _1899_ VGND VGND VPWR VPWR net85 sky130_fd_sc_hd__inv_2
XANTENNA__8536__S _4211_ VGND VGND VPWR VPWR sky130_fd_sc_hd__diode_2
XFILLER_0_36_3 VGND VGND VPWR VPWR sky130_fd_sc_hd__fill_2
XFILLER_0_98_309 VGND VGND VPWR VPWR sky130_fd_sc_hd__decap_3
X_5076_ _1741_ _1826_ _1834_ VGND VGND VPWR VPWR _1835_ sky130_fd_sc_hd__o21ai_4
XANTENNA__4365__A _1125_ VGND VGND VPWR VPWR sky130_fd_sc_hd__diode_2
X_8904_ clknet_leaf_12_clk _0001_ VGND VGND VPWR VPWR registers\[16\]\[8\] sky130_fd_sc_hd__dfxtp_1
XFILLER_0_67_707 VGND VGND VPWR VPWR sky130_fd_sc_hd__decap_4
XANTENNA__4831__A1 _1438_ VGND VGND VPWR VPWR sky130_fd_sc_hd__diode_2
XFILLER_0_79_578 VPWR VGND VPWR VGND sky130_ef_sc_hd__decap_12
XFILLER_0_67_729 VGND VGND VPWR VPWR sky130_fd_sc_hd__fill_1
X_8835_ clknet_leaf_21_clk _0956_ VGND VGND VPWR VPWR registers\[14\]\[3\] sky130_fd_sc_hd__dfxtp_1
X_5978_ _2626_ _2647_ _2662_ _2682_ VGND VGND VPWR VPWR _2698_ sky130_fd_sc_hd__and4_1
X_8766_ clknet_leaf_12_clk _0887_ VGND VGND VPWR VPWR registers\[11\]\[30\] sky130_fd_sc_hd__dfxtp_1
XFILLER_0_19_111 VGND VGND VPWR VPWR sky130_fd_sc_hd__fill_1
XFILLER_0_19_122 VGND VGND VPWR VPWR sky130_fd_sc_hd__decap_4
XANTENNA__6584__A1 _3016_ VGND VGND VPWR VPWR sky130_fd_sc_hd__diode_2
X_4929_ _1689_ _1693_ VGND VGND VPWR VPWR _1694_ sky130_fd_sc_hd__or2_1
XFILLER_0_47_453 VGND VGND VPWR VPWR sky130_fd_sc_hd__fill_2
XFILLER_0_47_442 VGND VGND VPWR VPWR sky130_fd_sc_hd__fill_2
X_8697_ clknet_leaf_86_clk _0818_ VGND VGND VPWR VPWR registers\[0\]\[25\] sky130_fd_sc_hd__dfxtp_1
X_7717_ _3786_ VGND VGND VPWR VPWR _0275_ sky130_fd_sc_hd__clkbuf_1
XFILLER_0_117_341 VGND VGND VPWR VPWR sky130_fd_sc_hd__fill_2
XANTENNA__6336__A1 _3014_ VGND VGND VPWR VPWR sky130_fd_sc_hd__diode_2
X_7648_ _3749_ VGND VGND VPWR VPWR _0243_ sky130_fd_sc_hd__clkbuf_1
XFILLER_0_34_114 VGND VGND VPWR VPWR sky130_fd_sc_hd__decap_4
XFILLER_0_7_561 VGND VGND VPWR VPWR sky130_fd_sc_hd__fill_2
XANTENNA__4442__S0 _1196_ VGND VGND VPWR VPWR sky130_fd_sc_hd__diode_2
XANTENNA__5924__A _1899_ VGND VGND VPWR VPWR sky130_fd_sc_hd__diode_2
XFILLER_0_50_618 VGND VGND VPWR VPWR sky130_fd_sc_hd__fill_2
XFILLER_0_43_681 VGND VGND VPWR VPWR sky130_fd_sc_hd__decap_4
X_7579_ _3123_ registers\[22\]\[26\] _3706_ VGND VGND VPWR VPWR _3713_ sky130_fd_sc_hd__mux2_1
X_9318_ clknet_leaf_35_clk _0415_ VGND VGND VPWR VPWR registers\[2\]\[6\] sky130_fd_sc_hd__dfxtp_1
X_9249_ clknet_leaf_109_clk _0346_ VGND VGND VPWR VPWR registers\[27\]\[1\] sky130_fd_sc_hd__dfxtp_1
XANTENNA__5135__S _1687_ VGND VGND VPWR VPWR sky130_fd_sc_hd__diode_2
XFILLER_0_100_230 VGND VGND VPWR VPWR sky130_fd_sc_hd__fill_2
XTAP_TAPCELL_ROW_91_1439 VGND VPWR sky130_fd_sc_hd__tapvpwrvgnd_1
XANTENNA__5847__B1 _2515_ VGND VGND VPWR VPWR sky130_fd_sc_hd__diode_2
XFILLER_0_100_285 VGND VGND VPWR VPWR sky130_fd_sc_hd__fill_2
XANTENNA__4745__S1 _1348_ VGND VGND VPWR VPWR sky130_fd_sc_hd__diode_2
XANTENNA__5075__B2 _1714_ VGND VGND VPWR VPWR sky130_fd_sc_hd__diode_2
XFILLER_0_106_29 VPWR VGND VPWR VGND sky130_ef_sc_hd__decap_12
XFILLER_0_97_331 VGND VGND VPWR VPWR sky130_fd_sc_hd__fill_2
XANTENNA__5170__S1 _1743_ VGND VGND VPWR VPWR sky130_fd_sc_hd__diode_2
XFILLER_0_97_386 VGND VGND VPWR VPWR sky130_fd_sc_hd__decap_3
XFILLER_0_85_537 VGND VGND VPWR VPWR sky130_fd_sc_hd__decap_3
XANTENNA__7772__A0 _3110_ VGND VGND VPWR VPWR sky130_fd_sc_hd__diode_2
XANTENNA__6490__A net28 VGND VGND VPWR VPWR sky130_fd_sc_hd__diode_2
XANTENNA__5783__C1 _2420_ VGND VGND VPWR VPWR sky130_fd_sc_hd__diode_2
XFILLER_0_38_442 VGND VGND VPWR VPWR sky130_fd_sc_hd__fill_2
XTAP_TAPCELL_ROW_26_595 VGND VPWR sky130_fd_sc_hd__tapvpwrvgnd_1
XTAP_TAPCELL_ROW_100_1557 VGND VPWR sky130_fd_sc_hd__tapvpwrvgnd_1
XFILLER_0_93_592 VGND VGND VPWR VPWR sky130_fd_sc_hd__fill_1
XANTENNA__4681__S0 _1362_ VGND VGND VPWR VPWR sky130_fd_sc_hd__diode_2
XFILLER_0_26_626 VGND VGND VPWR VPWR sky130_fd_sc_hd__fill_2
XFILLER_0_31_37 VGND VGND VPWR VPWR sky130_fd_sc_hd__fill_2
XFILLER_0_80_253 VGND VGND VPWR VPWR sky130_fd_sc_hd__decap_3
XFILLER_0_25_136 VGND VGND VPWR VPWR sky130_fd_sc_hd__decap_3
XFILLER_0_103_7 VGND VGND VPWR VPWR sky130_fd_sc_hd__fill_2
XFILLER_0_53_489 VGND VGND VPWR VPWR sky130_fd_sc_hd__fill_2
XANTENNA__7525__S _3684_ VGND VGND VPWR VPWR sky130_fd_sc_hd__diode_2
XFILLER_0_104_580 VGND VGND VPWR VPWR sky130_fd_sc_hd__fill_2
XFILLER_0_0_236 VGND VGND VPWR VPWR sky130_fd_sc_hd__fill_2
XFILLER_0_0_225 VGND VGND VPWR VPWR sky130_fd_sc_hd__decap_8
XANTENNA_output88_A net88 VGND VGND VPWR VPWR sky130_fd_sc_hd__diode_2
XANTENNA__5045__S _1714_ VGND VGND VPWR VPWR sky130_fd_sc_hd__diode_2
XFILLER_0_0_247 VGND VGND VPWR VPWR sky130_fd_sc_hd__decap_3
XFILLER_0_56_12 VGND VGND VPWR VPWR sky130_fd_sc_hd__fill_2
XANTENNA__4736__S1 _1391_ VGND VGND VPWR VPWR sky130_fd_sc_hd__diode_2
XTAP_TAPCELL_ROW_111_1697 VGND VPWR sky130_fd_sc_hd__tapvpwrvgnd_1
XANTENNA__8356__S _4117_ VGND VGND VPWR VPWR sky130_fd_sc_hd__diode_2
XANTENNA__7260__S _3539_ VGND VGND VPWR VPWR sky130_fd_sc_hd__diode_2
X_6950_ _3073_ registers\[14\]\[2\] _3361_ VGND VGND VPWR VPWR _3364_ sky130_fd_sc_hd__mux2_1
XFILLER_0_88_342 VGND VGND VPWR VPWR sky130_fd_sc_hd__fill_1
XFILLER_0_72_22 VGND VGND VPWR VPWR sky130_fd_sc_hd__fill_2
XANTENNA__5161__S1 _1759_ VGND VGND VPWR VPWR sky130_fd_sc_hd__diode_2
X_5901_ _1882_ _2623_ VGND VGND VPWR VPWR _2625_ sky130_fd_sc_hd__and2_1
XANTENNA__8004__A1 _3437_ VGND VGND VPWR VPWR sky130_fd_sc_hd__diode_2
XANTENNA_clkbuf_leaf_80_clk_A clknet_4_10_0_clk VGND VGND VPWR VPWR sky130_fd_sc_hd__diode_2
XANTENNA__4813__A1 _1389_ VGND VGND VPWR VPWR sky130_fd_sc_hd__diode_2
XTAP_TAPCELL_ROW_66_1121 VGND VPWR sky130_fd_sc_hd__tapvpwrvgnd_1
XFILLER_0_49_729 VGND VGND VPWR VPWR sky130_fd_sc_hd__fill_1
XFILLER_0_49_718 VGND VGND VPWR VPWR sky130_fd_sc_hd__fill_1
X_6881_ _3073_ registers\[13\]\[2\] _3324_ VGND VGND VPWR VPWR _3327_ sky130_fd_sc_hd__mux2_1
XFILLER_0_119_617 VPWR VGND VPWR VGND sky130_ef_sc_hd__decap_12
XANTENNA__8091__S _3984_ VGND VGND VPWR VPWR sky130_fd_sc_hd__diode_2
X_5832_ _2467_ VGND VGND VPWR VPWR _2560_ sky130_fd_sc_hd__clkbuf_4
X_8620_ clknet_leaf_44_clk _0741_ VGND VGND VPWR VPWR registers\[29\]\[12\] sky130_fd_sc_hd__dfxtp_1
XANTENNA__4913__A _1628_ VGND VGND VPWR VPWR sky130_fd_sc_hd__diode_2
XANTENNA__6604__S _3175_ VGND VGND VPWR VPWR sky130_fd_sc_hd__diode_2
XFILLER_0_118_105 VGND VGND VPWR VPWR sky130_fd_sc_hd__fill_1
X_5763_ _2447_ _2493_ _2293_ VGND VGND VPWR VPWR _2494_ sky130_fd_sc_hd__mux2_1
X_8551_ clknet_leaf_24_clk _0672_ VGND VGND VPWR VPWR registers\[19\]\[7\] sky130_fd_sc_hd__dfxtp_1
XANTENNA_clkbuf_leaf_95_clk_A clknet_4_9_0_clk VGND VGND VPWR VPWR sky130_fd_sc_hd__diode_2
XFILLER_0_44_412 VGND VGND VPWR VPWR sky130_fd_sc_hd__fill_2
XFILLER_0_8_369 VGND VGND VPWR VPWR sky130_fd_sc_hd__fill_2
XFILLER_0_8_358 VGND VGND VPWR VPWR sky130_fd_sc_hd__decap_4
X_4714_ _1488_ _1489_ _1344_ VGND VGND VPWR VPWR _1490_ sky130_fd_sc_hd__mux2_1
XANTENNA__4672__S0 _1382_ VGND VGND VPWR VPWR sky130_fd_sc_hd__diode_2
XFILLER_0_17_615 VGND VGND VPWR VPWR sky130_fd_sc_hd__fill_1
X_7502_ _3672_ VGND VGND VPWR VPWR _0174_ sky130_fd_sc_hd__clkbuf_1
XFILLER_0_71_220 VGND VGND VPWR VPWR sky130_fd_sc_hd__fill_2
X_5694_ _2425_ _2427_ VGND VGND VPWR VPWR _2428_ sky130_fd_sc_hd__xor2_2
XFILLER_0_44_456 VGND VGND VPWR VPWR sky130_fd_sc_hd__fill_2
X_8482_ registers\[4\]\[2\] net38 _4189_ VGND VGND VPWR VPWR _4192_ sky130_fd_sc_hd__mux2_1
XANTENNA__4424__S0 _1196_ VGND VGND VPWR VPWR sky130_fd_sc_hd__diode_2
X_7433_ registers\[20\]\[21\] _3479_ _3634_ VGND VGND VPWR VPWR _3636_ sky130_fd_sc_hd__mux2_1
XFILLER_0_21_81 VGND VGND VPWR VPWR sky130_fd_sc_hd__fill_2
XFILLER_0_31_117 VGND VGND VPWR VPWR sky130_fd_sc_hd__fill_1
XANTENNA__7435__S _3634_ VGND VGND VPWR VPWR sky130_fd_sc_hd__diode_2
X_4645_ _1423_ _1424_ _1344_ VGND VGND VPWR VPWR _1425_ sky130_fd_sc_hd__mux2_1
X_4576_ registers\[16\]\[17\] registers\[17\]\[17\] registers\[18\]\[17\] registers\[19\]\[17\]
+ _1160_ _1161_ VGND VGND VPWR VPWR _1359_ sky130_fd_sc_hd__mux4_1
XANTENNA__5744__A net139 VGND VGND VPWR VPWR sky130_fd_sc_hd__diode_2
XFILLER_0_40_640 VGND VGND VPWR VPWR sky130_fd_sc_hd__fill_2
XFILLER_0_4_575 VGND VGND VPWR VPWR sky130_fd_sc_hd__fill_1
X_7364_ registers\[1\]\[21\] _3479_ _3597_ VGND VGND VPWR VPWR _3599_ sky130_fd_sc_hd__mux2_1
XFILLER_0_25_681 VGND VGND VPWR VPWR sky130_fd_sc_hd__fill_2
XTAP_TAPCELL_ROW_77_1261 VGND VPWR sky130_fd_sc_hd__tapvpwrvgnd_1
X_9103_ clknet_leaf_65_clk _0200_ VGND VGND VPWR VPWR registers\[22\]\[15\] sky130_fd_sc_hd__dfxtp_1
X_6315_ _3000_ VGND VGND VPWR VPWR _0683_ sky130_fd_sc_hd__clkbuf_1
X_9034_ clknet_leaf_37_clk _0131_ VGND VGND VPWR VPWR registers\[20\]\[10\] sky130_fd_sc_hd__dfxtp_1
X_7295_ _3562_ VGND VGND VPWR VPWR _0077_ sky130_fd_sc_hd__clkbuf_1
XANTENNA_clkbuf_leaf_33_clk_A clknet_4_5_0_clk VGND VGND VPWR VPWR sky130_fd_sc_hd__diode_2
X_6246_ _2947_ _2950_ VGND VGND VPWR VPWR _2951_ sky130_fd_sc_hd__xnor2_1
XANTENNA__4727__S1 _1416_ VGND VGND VPWR VPWR sky130_fd_sc_hd__diode_2
X_6177_ _2883_ _2885_ VGND VGND VPWR VPWR _2886_ sky130_fd_sc_hd__xnor2_1
XANTENNA__7170__S _3477_ VGND VGND VPWR VPWR sky130_fd_sc_hd__diode_2
XANTENNA__8266__S _4067_ VGND VGND VPWR VPWR sky130_fd_sc_hd__diode_2
X_5128_ _1731_ VGND VGND VPWR VPWR _1883_ sky130_fd_sc_hd__clkbuf_8
XANTENNA__8243__A1 _3472_ VGND VGND VPWR VPWR sky130_fd_sc_hd__diode_2
XANTENNA__5152__S1 _1720_ VGND VGND VPWR VPWR sky130_fd_sc_hd__diode_2
XANTENNA_clkbuf_leaf_48_clk_A clknet_4_13_0_clk VGND VGND VPWR VPWR sky130_fd_sc_hd__diode_2
XFILLER_0_79_320 VGND VGND VPWR VPWR sky130_fd_sc_hd__fill_1
X_5059_ _1741_ _1805_ _1818_ VGND VGND VPWR VPWR _1819_ sky130_fd_sc_hd__o21ai_4
XFILLER_0_79_386 VGND VGND VPWR VPWR sky130_fd_sc_hd__decap_4
XANTENNA__6557__A1 _2989_ VGND VGND VPWR VPWR sky130_fd_sc_hd__diode_2
XFILLER_0_67_559 VGND VGND VPWR VPWR sky130_fd_sc_hd__fill_1
X_8818_ clknet_leaf_68_clk _0939_ VGND VGND VPWR VPWR registers\[13\]\[18\] sky130_fd_sc_hd__dfxtp_1
XTAP_TAPCELL_ROW_43_819 VGND VPWR sky130_fd_sc_hd__tapvpwrvgnd_1
XFILLER_0_109_105 VGND VGND VPWR VPWR sky130_fd_sc_hd__decap_4
XFILLER_0_94_378 VGND VGND VPWR VPWR sky130_fd_sc_hd__decap_3
XFILLER_0_47_250 VGND VGND VPWR VPWR sky130_fd_sc_hd__decap_3
X_8749_ clknet_leaf_50_clk _0870_ VGND VGND VPWR VPWR registers\[11\]\[13\] sky130_fd_sc_hd__dfxtp_1
XFILLER_0_63_732 VGND VGND VPWR VPWR sky130_fd_sc_hd__fill_1
XFILLER_0_47_272 VGND VGND VPWR VPWR sky130_fd_sc_hd__fill_2
XANTENNA__4663__S0 _1427_ VGND VGND VPWR VPWR sky130_fd_sc_hd__diode_2
XTAP_TAPCELL_ROW_23_554 VGND VPWR sky130_fd_sc_hd__tapvpwrvgnd_1
XFILLER_0_35_401 VGND VGND VPWR VPWR sky130_fd_sc_hd__decap_6
XPHY_EDGE_ROW_109_Right_109 VGND VGND VPWR VPWR sky130_fd_sc_hd__decap_3
XFILLER_0_105_300 VGND VGND VPWR VPWR sky130_fd_sc_hd__fill_2
XANTENNA_clkbuf_leaf_106_clk_A clknet_4_2_0_clk VGND VGND VPWR VPWR sky130_fd_sc_hd__diode_2
XANTENNA__7345__S _3586_ VGND VGND VPWR VPWR sky130_fd_sc_hd__diode_2
XFILLER_0_62_275 VGND VGND VPWR VPWR sky130_fd_sc_hd__fill_2
XFILLER_0_62_264 VGND VGND VPWR VPWR sky130_fd_sc_hd__fill_2
XFILLER_0_62_253 VGND VGND VPWR VPWR sky130_fd_sc_hd__decap_8
XFILLER_0_7_391 VGND VGND VPWR VPWR sky130_fd_sc_hd__fill_1
XFILLER_0_23_629 VGND VGND VPWR VPWR sky130_fd_sc_hd__fill_2
XANTENNA__4966__S1 _1720_ VGND VGND VPWR VPWR sky130_fd_sc_hd__diode_2
XANTENNA__4740__B1 _1124_ VGND VGND VPWR VPWR sky130_fd_sc_hd__diode_2
XFILLER_0_31_673 VGND VGND VPWR VPWR sky130_fd_sc_hd__fill_1
XANTENNA__8482__A1 net38 VGND VGND VPWR VPWR sky130_fd_sc_hd__diode_2
XFILLER_0_101_594 VGND VGND VPWR VPWR sky130_fd_sc_hd__decap_4
XANTENNA__5391__S1 _2127_ VGND VGND VPWR VPWR sky130_fd_sc_hd__diode_2
XANTENNA_clkbuf_4_10_0_clk_A clknet_0_clk VGND VGND VPWR VPWR sky130_fd_sc_hd__diode_2
XFILLER_0_117_39 VPWR VGND VPWR VGND sky130_ef_sc_hd__decap_12
XFILLER_0_98_684 VGND VGND VPWR VPWR sky130_fd_sc_hd__fill_2
XFILLER_0_98_673 VGND VGND VPWR VPWR sky130_fd_sc_hd__decap_6
XFILLER_0_98_695 VGND VGND VPWR VPWR sky130_fd_sc_hd__decap_4
XANTENNA__6548__A1 _2980_ VGND VGND VPWR VPWR sky130_fd_sc_hd__diode_2
XANTENNA__4271__A2 _1059_ VGND VGND VPWR VPWR sky130_fd_sc_hd__diode_2
XFILLER_0_85_367 VGND VGND VPWR VPWR sky130_fd_sc_hd__fill_2
Xclkbuf_4_14_0_clk clknet_0_clk VGND VGND VPWR VPWR clknet_4_14_0_clk sky130_fd_sc_hd__clkbuf_8
XTAP_TAPCELL_ROW_61_1051 VGND VPWR sky130_fd_sc_hd__tapvpwrvgnd_1
XFILLER_0_53_264 VGND VGND VPWR VPWR sky130_fd_sc_hd__fill_2
XANTENNA__4879__S _1621_ VGND VGND VPWR VPWR sky130_fd_sc_hd__diode_2
XANTENNA_2 _2525_ VGND VGND VPWR VPWR sky130_fd_sc_hd__diode_2
XANTENNA__5564__A _1796_ VGND VGND VPWR VPWR sky130_fd_sc_hd__diode_2
X_4430_ _1220_ _1221_ _1131_ VGND VGND VPWR VPWR _1222_ sky130_fd_sc_hd__mux2_1
XFILLER_0_53_297 VGND VGND VPWR VPWR sky130_fd_sc_hd__decap_3
XFILLER_0_41_426 VGND VGND VPWR VPWR sky130_fd_sc_hd__fill_2
XANTENNA__4957__S1 _1720_ VGND VGND VPWR VPWR sky130_fd_sc_hd__diode_2
XFILLER_0_22_640 VGND VGND VPWR VPWR sky130_fd_sc_hd__fill_2
XTAP_TAPCELL_ROW_113_1726 VGND VPWR sky130_fd_sc_hd__tapvpwrvgnd_1
X_4361_ registers\[12\]\[5\] registers\[13\]\[5\] registers\[14\]\[5\] registers\[15\]\[5\]
+ _1126_ _1128_ VGND VGND VPWR VPWR _1156_ sky130_fd_sc_hd__mux4_1
X_6100_ _2676_ _2692_ _2767_ _2541_ VGND VGND VPWR VPWR _2813_ sky130_fd_sc_hd__a22o_1
XFILLER_0_1_556 VGND VGND VPWR VPWR sky130_fd_sc_hd__fill_1
X_4292_ _1089_ VGND VGND VPWR VPWR _1090_ sky130_fd_sc_hd__inv_2
XFILLER_0_67_55 VGND VGND VPWR VPWR sky130_fd_sc_hd__fill_1
XFILLER_0_6_69 VGND VGND VPWR VPWR sky130_fd_sc_hd__fill_1
XANTENNA__4709__S1 _1419_ VGND VGND VPWR VPWR sky130_fd_sc_hd__diode_2
X_7080_ _3432_ VGND VGND VPWR VPWR _1016_ sky130_fd_sc_hd__clkbuf_1
X_6031_ _2429_ _2737_ _2738_ _2748_ VGND VGND VPWR VPWR net58 sky130_fd_sc_hd__o31a_1
XANTENNA__8086__S _3973_ VGND VGND VPWR VPWR sky130_fd_sc_hd__diode_2
XFILLER_0_83_10 VGND VGND VPWR VPWR sky130_fd_sc_hd__fill_2
XTAP_TAPCELL_ROW_72_1191 VGND VPWR sky130_fd_sc_hd__tapvpwrvgnd_1
XANTENNA__5382__S1 _2120_ VGND VGND VPWR VPWR sky130_fd_sc_hd__diode_2
X_7982_ _3010_ registers\[28\]\[23\] _3923_ VGND VGND VPWR VPWR _3927_ sky130_fd_sc_hd__mux2_1
XFILLER_0_107_72 VGND VGND VPWR VPWR sky130_fd_sc_hd__fill_2
XFILLER_0_107_61 VGND VGND VPWR VPWR sky130_fd_sc_hd__fill_2
XFILLER_0_89_673 VGND VGND VPWR VPWR sky130_fd_sc_hd__decap_6
XFILLER_0_83_98 VGND VGND VPWR VPWR sky130_fd_sc_hd__decap_3
XFILLER_0_16_70 VGND VGND VPWR VPWR sky130_fd_sc_hd__fill_2
X_6933_ _3125_ registers\[13\]\[27\] _3346_ VGND VGND VPWR VPWR _3354_ sky130_fd_sc_hd__mux2_1
XFILLER_0_76_334 VGND VGND VPWR VPWR sky130_fd_sc_hd__fill_2
X_6864_ _3317_ VGND VGND VPWR VPWR _0915_ sky130_fd_sc_hd__clkbuf_1
X_5815_ _2297_ _2450_ _2453_ _2270_ VGND VGND VPWR VPWR _2544_ sky130_fd_sc_hd__a22o_1
XFILLER_0_9_612 VGND VGND VPWR VPWR sky130_fd_sc_hd__decap_4
X_8603_ clknet_leaf_106_clk _0724_ VGND VGND VPWR VPWR registers\[3\]\[27\] sky130_fd_sc_hd__dfxtp_1
XFILLER_0_91_337 VGND VGND VPWR VPWR sky130_fd_sc_hd__fill_1
XFILLER_0_91_315 VGND VGND VPWR VPWR sky130_fd_sc_hd__fill_2
XFILLER_0_45_721 VGND VGND VPWR VPWR sky130_fd_sc_hd__fill_2
XANTENNA__7954__A _3900_ VGND VGND VPWR VPWR sky130_fd_sc_hd__diode_2
XFILLER_0_8_144 VPWR VGND VPWR VGND sky130_ef_sc_hd__decap_12
XFILLER_0_9_667 VGND VGND VPWR VPWR sky130_fd_sc_hd__fill_1
XFILLER_0_17_423 VGND VGND VPWR VPWR sky130_fd_sc_hd__fill_2
X_6795_ registers\[11\]\[27\] _3018_ _3272_ VGND VGND VPWR VPWR _3280_ sky130_fd_sc_hd__mux2_1
X_5746_ _1725_ _2476_ VGND VGND VPWR VPWR _2478_ sky130_fd_sc_hd__and2_1
XFILLER_0_17_456 VGND VGND VPWR VPWR sky130_fd_sc_hd__fill_2
XTAP_TAPCELL_ROW_20_513 VGND VPWR sky130_fd_sc_hd__tapvpwrvgnd_1
XTAP_TAPCELL_ROW_20_524 VGND VPWR sky130_fd_sc_hd__tapvpwrvgnd_1
X_8534_ registers\[4\]\[27\] net35 _4211_ VGND VGND VPWR VPWR _4219_ sky130_fd_sc_hd__mux2_1
XFILLER_0_32_80 VGND VGND VPWR VPWR sky130_fd_sc_hd__fill_2
X_5677_ _2409_ _2410_ net135 VGND VGND VPWR VPWR _2411_ sky130_fd_sc_hd__mux2_1
XFILLER_0_44_253 VGND VGND VPWR VPWR sky130_fd_sc_hd__fill_1
X_8465_ _4182_ VGND VGND VPWR VPWR _0627_ sky130_fd_sc_hd__clkbuf_1
XFILLER_0_114_141 VGND VGND VPWR VPWR sky130_fd_sc_hd__fill_2
X_7416_ registers\[20\]\[13\] _3462_ _3623_ VGND VGND VPWR VPWR _3627_ sky130_fd_sc_hd__mux2_1
X_4628_ _1381_ _1408_ VGND VGND VPWR VPWR _1409_ sky130_fd_sc_hd__nand2_1
XANTENNA__5474__A _1569_ VGND VGND VPWR VPWR sky130_fd_sc_hd__diode_2
XFILLER_0_115_697 VPWR VGND VPWR VGND sky130_ef_sc_hd__decap_12
XANTENNA__5070__S0 _1806_ VGND VGND VPWR VPWR sky130_fd_sc_hd__diode_2
X_8396_ registers\[5\]\[26\] _3489_ _4139_ VGND VGND VPWR VPWR _4146_ sky130_fd_sc_hd__mux2_1
X_7347_ registers\[1\]\[13\] _3462_ _3586_ VGND VGND VPWR VPWR _3590_ sky130_fd_sc_hd__mux2_1
X_4559_ registers\[24\]\[16\] registers\[25\]\[16\] registers\[26\]\[16\] registers\[27\]\[16\]
+ _1320_ _1321_ VGND VGND VPWR VPWR _1343_ sky130_fd_sc_hd__mux4_1
X_7278_ _3553_ VGND VGND VPWR VPWR _0069_ sky130_fd_sc_hd__clkbuf_1
XANTENNA__8464__A1 net34 VGND VGND VPWR VPWR sky130_fd_sc_hd__diode_2
XFILLER_0_110_391 VGND VGND VPWR VPWR sky130_fd_sc_hd__fill_2
X_6229_ _2298_ _2863_ _2934_ _2560_ VGND VGND VPWR VPWR _2935_ sky130_fd_sc_hd__a211o_1
X_9017_ clknet_leaf_87_clk _0114_ VGND VGND VPWR VPWR registers\[1\]\[25\] sky130_fd_sc_hd__dfxtp_1
XANTENNA__8216__A1 _3445_ VGND VGND VPWR VPWR sky130_fd_sc_hd__diode_2
XANTENNA__5373__S1 _2021_ VGND VGND VPWR VPWR sky130_fd_sc_hd__diode_2
XTAP_TAPCELL_ROW_28_624 VGND VPWR sky130_fd_sc_hd__tapvpwrvgnd_1
XANTENNA__4553__A _1337_ VGND VGND VPWR VPWR sky130_fd_sc_hd__diode_2
XTAP_TAPCELL_ROW_56_988 VGND VPWR sky130_fd_sc_hd__tapvpwrvgnd_1
XANTENNA__4884__S0 _1628_ VGND VGND VPWR VPWR sky130_fd_sc_hd__diode_2
XTAP_TAPCELL_ROW_0_260 VGND VPWR sky130_fd_sc_hd__tapvpwrvgnd_1
XFILLER_0_94_175 VGND VGND VPWR VPWR sky130_fd_sc_hd__fill_1
XFILLER_0_82_304 VGND VGND VPWR VPWR sky130_fd_sc_hd__fill_1
XFILLER_0_48_570 VGND VGND VPWR VPWR sky130_fd_sc_hd__fill_2
XFILLER_0_12_17 VGND VGND VPWR VPWR sky130_fd_sc_hd__fill_2
XFILLER_0_94_197 VGND VGND VPWR VPWR sky130_fd_sc_hd__fill_2
XFILLER_0_82_348 VGND VGND VPWR VPWR sky130_fd_sc_hd__fill_1
XFILLER_0_35_220 VGND VGND VPWR VPWR sky130_fd_sc_hd__fill_2
XFILLER_0_106_631 VGND VGND VPWR VPWR sky130_fd_sc_hd__fill_1
XFILLER_0_35_242 VGND VGND VPWR VPWR sky130_fd_sc_hd__fill_1
XFILLER_0_2_309 VGND VGND VPWR VPWR sky130_fd_sc_hd__fill_2
XANTENNA__7075__S _3420_ VGND VGND VPWR VPWR sky130_fd_sc_hd__diode_2
XFILLER_0_50_245 VGND VGND VPWR VPWR sky130_fd_sc_hd__decap_4
Xoutput50 net50 VGND VGND VPWR VPWR alu_result[10] sky130_fd_sc_hd__buf_1
Xoutput61 net61 VGND VGND VPWR VPWR alu_result[20] sky130_fd_sc_hd__buf_1
Xoutput72 net72 VGND VGND VPWR VPWR alu_result[30] sky130_fd_sc_hd__buf_1
XANTENNA__6419__S _3052_ VGND VGND VPWR VPWR sky130_fd_sc_hd__diode_2
XTAP_TAPCELL_ROW_8_360 VGND VPWR sky130_fd_sc_hd__tapvpwrvgnd_1
Xoutput94 net94 VGND VGND VPWR VPWR rd1[21] sky130_fd_sc_hd__buf_1
Xoutput83 net83 VGND VGND VPWR VPWR rd1[11] sky130_fd_sc_hd__buf_1
XANTENNA__5323__S _2031_ VGND VGND VPWR VPWR sky130_fd_sc_hd__diode_2
XANTENNA__5364__S1 _1997_ VGND VGND VPWR VPWR sky130_fd_sc_hd__diode_2
XFILLER_0_98_470 VGND VGND VPWR VPWR sky130_fd_sc_hd__fill_2
XFILLER_0_86_643 VGND VGND VPWR VPWR sky130_fd_sc_hd__fill_1
XANTENNA__5559__A _1089_ VGND VGND VPWR VPWR sky130_fd_sc_hd__diode_2
XFILLER_0_53_57 VGND VGND VPWR VPWR sky130_fd_sc_hd__fill_2
XANTENNA__7194__A1 _3445_ VGND VGND VPWR VPWR sky130_fd_sc_hd__diode_2
XFILLER_0_73_304 VGND VGND VPWR VPWR sky130_fd_sc_hd__fill_2
XFILLER_0_46_529 VGND VGND VPWR VPWR sky130_fd_sc_hd__decap_3
XFILLER_0_85_197 VGND VGND VPWR VPWR sky130_fd_sc_hd__fill_2
X_5600_ _2333_ _2334_ VGND VGND VPWR VPWR _2335_ sky130_fd_sc_hd__nand2_1
XFILLER_0_73_348 VGND VGND VPWR VPWR sky130_fd_sc_hd__decap_8
XFILLER_0_73_337 VGND VGND VPWR VPWR sky130_fd_sc_hd__fill_1
X_6580_ registers\[7\]\[24\] _3012_ _3159_ VGND VGND VPWR VPWR _3164_ sky130_fd_sc_hd__mux2_1
X_5531_ _2253_ VGND VGND VPWR VPWR _2267_ sky130_fd_sc_hd__clkbuf_4
XFILLER_0_26_253 VGND VGND VPWR VPWR sky130_fd_sc_hd__fill_1
XFILLER_0_5_147 VGND VGND VPWR VPWR sky130_fd_sc_hd__fill_1
X_8250_ registers\[6\]\[21\] _3479_ _4067_ VGND VGND VPWR VPWR _4069_ sky130_fd_sc_hd__mux2_1
X_5462_ net15 _1166_ VGND VGND VPWR VPWR _2198_ sky130_fd_sc_hd__nand2_1
XFILLER_0_75_7 VGND VGND VPWR VPWR sky130_fd_sc_hd__fill_2
XANTENNA__5052__S0 _1810_ VGND VGND VPWR VPWR sky130_fd_sc_hd__diode_2
X_7201_ _3512_ VGND VGND VPWR VPWR _0033_ sky130_fd_sc_hd__clkbuf_1
XFILLER_0_111_133 VGND VGND VPWR VPWR sky130_fd_sc_hd__fill_2
X_4413_ _1200_ _1205_ _1148_ VGND VGND VPWR VPWR _1206_ sky130_fd_sc_hd__mux2_1
XFILLER_0_78_76 VGND VGND VPWR VPWR sky130_fd_sc_hd__fill_1
XTAP_TAPCELL_ROW_74_1220 VGND VPWR sky130_fd_sc_hd__tapvpwrvgnd_1
XFILLER_0_41_289 VGND VGND VPWR VPWR sky130_fd_sc_hd__fill_2
XFILLER_0_41_278 VGND VGND VPWR VPWR sky130_fd_sc_hd__fill_2
X_5393_ _2132_ _2133_ _2081_ VGND VGND VPWR VPWR _2134_ sky130_fd_sc_hd__mux2_1
X_8181_ _4032_ VGND VGND VPWR VPWR _0493_ sky130_fd_sc_hd__clkbuf_1
X_4344_ _1116_ VGND VGND VPWR VPWR _1140_ sky130_fd_sc_hd__clkbuf_8
XFILLER_0_78_98 VGND VGND VPWR VPWR sky130_fd_sc_hd__fill_2
X_7132_ net23 VGND VGND VPWR VPWR _3468_ sky130_fd_sc_hd__buf_2
XFILLER_0_10_632 VGND VGND VPWR VPWR sky130_fd_sc_hd__decap_8
XFILLER_0_10_654 VGND VGND VPWR VPWR sky130_fd_sc_hd__fill_2
XFILLER_0_22_492 VGND VGND VPWR VPWR sky130_fd_sc_hd__decap_3
XANTENNA__6457__A0 _3087_ VGND VGND VPWR VPWR sky130_fd_sc_hd__diode_2
X_7063_ _3117_ registers\[15\]\[23\] _3420_ VGND VGND VPWR VPWR _3424_ sky130_fd_sc_hd__mux2_1
X_6014_ _2218_ _2224_ VGND VGND VPWR VPWR _2732_ sky130_fd_sc_hd__nand2_1
X_4275_ _1052_ VGND VGND VPWR VPWR _1073_ sky130_fd_sc_hd__buf_6
XANTENNA__5233__S _1695_ VGND VGND VPWR VPWR sky130_fd_sc_hd__diode_2
XANTENNA__4638__A _1198_ VGND VGND VPWR VPWR sky130_fd_sc_hd__diode_2
XANTENNA__5355__S1 _2021_ VGND VGND VPWR VPWR sky130_fd_sc_hd__diode_2
XANTENNA__5680__A1 _2413_ VGND VGND VPWR VPWR sky130_fd_sc_hd__diode_2
XANTENNA__7957__A0 _2985_ VGND VGND VPWR VPWR sky130_fd_sc_hd__diode_2
XTAP_TAPCELL_ROW_85_1360 VGND VPWR sky130_fd_sc_hd__tapvpwrvgnd_1
XFILLER_0_77_610 VGND VGND VPWR VPWR sky130_fd_sc_hd__fill_1
X_7965_ _2993_ registers\[28\]\[15\] _3912_ VGND VGND VPWR VPWR _3918_ sky130_fd_sc_hd__mux2_1
XANTENNA__5469__A _1286_ VGND VGND VPWR VPWR sky130_fd_sc_hd__diode_2
X_7896_ _3881_ VGND VGND VPWR VPWR _0359_ sky130_fd_sc_hd__clkbuf_1
XANTENNA__4373__A _1110_ VGND VGND VPWR VPWR sky130_fd_sc_hd__diode_2
XFILLER_0_77_665 VGND VGND VPWR VPWR sky130_fd_sc_hd__fill_2
X_6916_ _3108_ registers\[13\]\[19\] _3335_ VGND VGND VPWR VPWR _3345_ sky130_fd_sc_hd__mux2_1
XTAP_TAPCELL_ROW_53_947 VGND VPWR sky130_fd_sc_hd__tapvpwrvgnd_1
XFILLER_0_64_315 VGND VGND VPWR VPWR sky130_fd_sc_hd__decap_4
X_6847_ _3308_ VGND VGND VPWR VPWR _0907_ sky130_fd_sc_hd__clkbuf_1
XFILLER_0_37_529 VGND VGND VPWR VPWR sky130_fd_sc_hd__fill_2
XFILLER_0_9_453 VGND VGND VPWR VPWR sky130_fd_sc_hd__decap_3
XFILLER_0_92_657 VGND VGND VPWR VPWR sky130_fd_sc_hd__fill_1
XFILLER_0_91_134 VGND VGND VPWR VPWR sky130_fd_sc_hd__fill_2
XFILLER_0_76_197 VGND VGND VPWR VPWR sky130_fd_sc_hd__decap_3
XFILLER_0_64_359 VGND VGND VPWR VPWR sky130_fd_sc_hd__fill_2
X_6778_ registers\[11\]\[19\] _3001_ _3261_ VGND VGND VPWR VPWR _3271_ sky130_fd_sc_hd__mux2_1
X_9566_ clknet_leaf_11_clk _0663_ VGND VGND VPWR VPWR registers\[4\]\[30\] sky130_fd_sc_hd__dfxtp_1
XTAP_TAPCELL_ROW_33_682 VGND VPWR sky130_fd_sc_hd__tapvpwrvgnd_1
X_5729_ _2226_ _2286_ _2460_ VGND VGND VPWR VPWR _2461_ sky130_fd_sc_hd__mux2_1
X_8517_ registers\[4\]\[19\] net26 _4200_ VGND VGND VPWR VPWR _4210_ sky130_fd_sc_hd__mux2_1
XANTENNA__5291__S0 _1810_ VGND VGND VPWR VPWR sky130_fd_sc_hd__diode_2
XTAP_TAPCELL_ROW_33_693 VGND VPWR sky130_fd_sc_hd__tapvpwrvgnd_1
XFILLER_0_33_713 VPWR VGND VPWR VGND sky130_ef_sc_hd__decap_12
X_9497_ clknet_leaf_87_clk _0594_ VGND VGND VPWR VPWR registers\[5\]\[25\] sky130_fd_sc_hd__dfxtp_1
XANTENNA__5043__S0 _1798_ VGND VGND VPWR VPWR sky130_fd_sc_hd__diode_2
X_8448_ _4173_ VGND VGND VPWR VPWR _0619_ sky130_fd_sc_hd__clkbuf_1
Xclkbuf_leaf_111_clk clknet_4_0_0_clk VGND VGND VPWR VPWR clknet_leaf_111_clk sky130_fd_sc_hd__clkbuf_8
XFILLER_0_102_144 VGND VGND VPWR VPWR sky130_fd_sc_hd__fill_1
XANTENNA__6160__A2 _2587_ VGND VGND VPWR VPWR sky130_fd_sc_hd__diode_2
X_8379_ registers\[5\]\[18\] _3472_ _4128_ VGND VGND VPWR VPWR _4137_ sky130_fd_sc_hd__mux2_1
XANTENNA__8437__A1 net20 VGND VGND VPWR VPWR sky130_fd_sc_hd__diode_2
XANTENNA__4459__C1 _1122_ VGND VGND VPWR VPWR sky130_fd_sc_hd__diode_2
XANTENNA__5346__S1 _2028_ VGND VGND VPWR VPWR sky130_fd_sc_hd__diode_2
XTAP_TAPCELL_ROW_5_330 VGND VPWR sky130_fd_sc_hd__tapvpwrvgnd_1
XFILLER_0_99_234 VGND VGND VPWR VPWR sky130_fd_sc_hd__fill_1
XANTENNA__7948__A0 _2976_ VGND VGND VPWR VPWR sky130_fd_sc_hd__diode_2
XANTENNA__8454__S _4175_ VGND VGND VPWR VPWR sky130_fd_sc_hd__diode_2
XFILLER_0_59_109 VGND VGND VPWR VPWR sky130_fd_sc_hd__decap_3
XANTENNA__5379__A _2109_ VGND VGND VPWR VPWR sky130_fd_sc_hd__diode_2
XFILLER_0_114_29 VPWR VGND VPWR VGND sky130_ef_sc_hd__decap_12
XFILLER_0_67_142 VGND VGND VPWR VPWR sky130_fd_sc_hd__fill_2
XFILLER_0_82_134 VGND VGND VPWR VPWR sky130_fd_sc_hd__decap_3
XANTENNA__6702__S _3225_ VGND VGND VPWR VPWR sky130_fd_sc_hd__diode_2
XFILLER_0_83_679 VPWR VGND VPWR VGND sky130_ef_sc_hd__decap_12
XFILLER_0_82_167 VGND VGND VPWR VPWR sky130_fd_sc_hd__fill_2
XANTENNA__5282__S0 _2027_ VGND VGND VPWR VPWR sky130_fd_sc_hd__diode_2
XANTENNA__6003__A _1145_ VGND VGND VPWR VPWR sky130_fd_sc_hd__diode_2
XTAP_TAPCELL_ROW_11_398 VGND VPWR sky130_fd_sc_hd__tapvpwrvgnd_1
Xclkbuf_leaf_102_clk clknet_4_8_0_clk VGND VGND VPWR VPWR clknet_leaf_102_clk sky130_fd_sc_hd__clkbuf_8
XANTENNA__7533__S _3684_ VGND VGND VPWR VPWR sky130_fd_sc_hd__diode_2
XANTENNA__8428__A1 net47 VGND VGND VPWR VPWR sky130_fd_sc_hd__diode_2
XANTENNA__5561__B _1108_ VGND VGND VPWR VPWR sky130_fd_sc_hd__diode_2
XFILLER_0_48_46 VGND VGND VPWR VPWR sky130_fd_sc_hd__fill_2
XANTENNA__4458__A _1131_ VGND VGND VPWR VPWR sky130_fd_sc_hd__diode_2
XFILLER_0_3_26 VGND VGND VPWR VPWR sky130_fd_sc_hd__fill_2
XFILLER_0_3_48 VGND VGND VPWR VPWR sky130_fd_sc_hd__fill_2
XFILLER_0_64_67 VGND VGND VPWR VPWR sky130_fd_sc_hd__decap_3
XTAP_TAPCELL_ROW_108_1669 VGND VPWR sky130_fd_sc_hd__tapvpwrvgnd_1
XTAP_TAPCELL_ROW_108_1658 VGND VPWR sky130_fd_sc_hd__tapvpwrvgnd_1
XFILLER_0_59_621 VGND VGND VPWR VPWR sky130_fd_sc_hd__decap_4
XFILLER_0_80_11 VGND VGND VPWR VPWR sky130_fd_sc_hd__fill_1
X_7750_ _3792_ VGND VGND VPWR VPWR _3804_ sky130_fd_sc_hd__clkbuf_8
X_4962_ _1725_ VGND VGND VPWR VPWR net107 sky130_fd_sc_hd__inv_2
X_6701_ _3230_ VGND VGND VPWR VPWR _0839_ sky130_fd_sc_hd__clkbuf_1
XFILLER_0_74_624 VGND VGND VPWR VPWR sky130_fd_sc_hd__fill_2
XFILLER_0_74_613 VGND VGND VPWR VPWR sky130_fd_sc_hd__fill_1
XTAP_TAPCELL_ROW_50_906 VGND VPWR sky130_fd_sc_hd__tapvpwrvgnd_1
X_4893_ _1616_ _1650_ _1654_ _1659_ VGND VGND VPWR VPWR _1660_ sky130_fd_sc_hd__a2bb2o_4
X_7681_ _3767_ VGND VGND VPWR VPWR _0258_ sky130_fd_sc_hd__clkbuf_1
XFILLER_0_19_529 VGND VGND VPWR VPWR sky130_fd_sc_hd__fill_2
XANTENNA__7167__A1 _3491_ VGND VGND VPWR VPWR sky130_fd_sc_hd__diode_2
XANTENNA__6612__S _3175_ VGND VGND VPWR VPWR sky130_fd_sc_hd__diode_2
X_6632_ _3192_ VGND VGND VPWR VPWR _0808_ sky130_fd_sc_hd__clkbuf_1
X_9420_ clknet_leaf_43_clk _0517_ VGND VGND VPWR VPWR registers\[6\]\[12\] sky130_fd_sc_hd__dfxtp_1
XFILLER_0_74_657 VGND VGND VPWR VPWR sky130_fd_sc_hd__fill_2
XFILLER_0_58_197 VGND VGND VPWR VPWR sky130_fd_sc_hd__decap_4
XANTENNA__7708__S _3779_ VGND VGND VPWR VPWR sky130_fd_sc_hd__diode_2
XFILLER_0_116_225 VGND VGND VPWR VPWR sky130_fd_sc_hd__decap_4
XFILLER_0_73_178 VGND VGND VPWR VPWR sky130_fd_sc_hd__fill_2
XFILLER_0_6_412 VGND VGND VPWR VPWR sky130_fd_sc_hd__fill_2
XFILLER_0_104_409 VGND VGND VPWR VPWR sky130_fd_sc_hd__decap_8
X_9351_ clknet_leaf_23_clk _0448_ VGND VGND VPWR VPWR registers\[30\]\[7\] sky130_fd_sc_hd__dfxtp_1
X_6563_ registers\[7\]\[16\] _2995_ _3148_ VGND VGND VPWR VPWR _3155_ sky130_fd_sc_hd__mux2_1
XFILLER_0_14_201 VGND VGND VPWR VPWR sky130_fd_sc_hd__fill_1
XTAP_TAPCELL_ROW_30_652 VGND VPWR sky130_fd_sc_hd__tapvpwrvgnd_1
X_8302_ _4096_ VGND VGND VPWR VPWR _0550_ sky130_fd_sc_hd__clkbuf_1
X_5514_ _2244_ _2249_ _1072_ VGND VGND VPWR VPWR _2250_ sky130_fd_sc_hd__mux2_1
XFILLER_0_89_53 VGND VGND VPWR VPWR sky130_fd_sc_hd__fill_1
X_6494_ net29 VGND VGND VPWR VPWR _3113_ sky130_fd_sc_hd__clkbuf_2
X_9282_ clknet_leaf_4_clk _0379_ VGND VGND VPWR VPWR registers\[28\]\[2\] sky130_fd_sc_hd__dfxtp_1
X_8233_ registers\[6\]\[13\] _3462_ _4056_ VGND VGND VPWR VPWR _4060_ sky130_fd_sc_hd__mux2_1
X_5445_ _2182_ VGND VGND VPWR VPWR net104 sky130_fd_sc_hd__inv_2
X_8164_ _4023_ VGND VGND VPWR VPWR _0485_ sky130_fd_sc_hd__clkbuf_1
XANTENNA__4689__C1 _1143_ VGND VGND VPWR VPWR sky130_fd_sc_hd__diode_2
XANTENNA__7443__S _3634_ VGND VGND VPWR VPWR sky130_fd_sc_hd__diode_2
X_7115_ registers\[16\]\[10\] _3455_ _3456_ VGND VGND VPWR VPWR _3457_ sky130_fd_sc_hd__mux2_1
XANTENNA__5471__B _1414_ VGND VGND VPWR VPWR sky130_fd_sc_hd__diode_2
XFILLER_0_10_451 VGND VGND VPWR VPWR sky130_fd_sc_hd__decap_3
X_5376_ _1977_ _2108_ _2117_ VGND VGND VPWR VPWR _2118_ sky130_fd_sc_hd__a21oi_2
X_4327_ _1118_ _1121_ _1122_ VGND VGND VPWR VPWR _1123_ sky130_fd_sc_hd__mux2_1
X_8095_ _2987_ registers\[30\]\[12\] _3984_ VGND VGND VPWR VPWR _3987_ sky130_fd_sc_hd__mux2_1
XFILLER_0_10_473 VGND VGND VPWR VPWR sky130_fd_sc_hd__decap_3
X_7046_ _3100_ registers\[15\]\[15\] _3409_ VGND VGND VPWR VPWR _3415_ sky130_fd_sc_hd__mux2_1
X_4258_ registers\[16\]\[1\] registers\[17\]\[1\] registers\[18\]\[1\] registers\[19\]\[1\]
+ _1053_ _1054_ VGND VGND VPWR VPWR _1057_ sky130_fd_sc_hd__mux4_1
XANTENNA__8274__S _4081_ VGND VGND VPWR VPWR sky130_fd_sc_hd__diode_2
X_8997_ clknet_leaf_32_clk _0094_ VGND VGND VPWR VPWR registers\[1\]\[5\] sky130_fd_sc_hd__dfxtp_1
XTAP_TAPCELL_ROW_38_752 VGND VPWR sky130_fd_sc_hd__tapvpwrvgnd_1
XANTENNA__4839__S0 _1382_ VGND VGND VPWR VPWR sky130_fd_sc_hd__diode_2
X_7948_ _2976_ registers\[28\]\[7\] _3901_ VGND VGND VPWR VPWR _3909_ sky130_fd_sc_hd__mux2_1
XANTENNA__4307__S net6 VGND VGND VPWR VPWR sky130_fd_sc_hd__diode_2
XFILLER_0_77_484 VGND VGND VPWR VPWR sky130_fd_sc_hd__fill_1
XFILLER_0_77_462 VGND VGND VPWR VPWR sky130_fd_sc_hd__fill_1
XANTENNA__7158__A1 _3485_ VGND VGND VPWR VPWR sky130_fd_sc_hd__diode_2
X_7879_ _3872_ VGND VGND VPWR VPWR _0351_ sky130_fd_sc_hd__clkbuf_1
XANTENNA__7618__S _3731_ VGND VGND VPWR VPWR sky130_fd_sc_hd__diode_2
XFILLER_0_9_250 VGND VGND VPWR VPWR sky130_fd_sc_hd__fill_2
XANTENNA__6522__S _3068_ VGND VGND VPWR VPWR sky130_fd_sc_hd__diode_2
XFILLER_0_65_679 VGND VGND VPWR VPWR sky130_fd_sc_hd__decap_4
XFILLER_0_52_318 VGND VGND VPWR VPWR sky130_fd_sc_hd__fill_1
XANTENNA__5138__S _1809_ VGND VGND VPWR VPWR sky130_fd_sc_hd__diode_2
X_9549_ clknet_leaf_48_clk _0646_ VGND VGND VPWR VPWR registers\[4\]\[13\] sky130_fd_sc_hd__dfxtp_1
XFILLER_0_45_370 VGND VGND VPWR VPWR sky130_fd_sc_hd__fill_2
XFILLER_0_60_340 VGND VGND VPWR VPWR sky130_fd_sc_hd__fill_2
XANTENNA__8449__S _4164_ VGND VGND VPWR VPWR sky130_fd_sc_hd__diode_2
XANTENNA__7330__A1 _3445_ VGND VGND VPWR VPWR sky130_fd_sc_hd__diode_2
XFILLER_0_103_453 VGND VGND VPWR VPWR sky130_fd_sc_hd__fill_2
XANTENNA__5662__A _1660_ VGND VGND VPWR VPWR sky130_fd_sc_hd__diode_2
XANTENNA__7353__S _3586_ VGND VGND VPWR VPWR sky130_fd_sc_hd__diode_2
XFILLER_0_18_38 VGND VGND VPWR VPWR sky130_fd_sc_hd__fill_1
XANTENNA__8184__S _4031_ VGND VGND VPWR VPWR sky130_fd_sc_hd__diode_2
XANTENNA__5601__S _1072_ VGND VGND VPWR VPWR sky130_fd_sc_hd__diode_2
XANTENNA__7397__A1 _3443_ VGND VGND VPWR VPWR sky130_fd_sc_hd__diode_2
XPHY_EDGE_ROW_16_Right_16 VGND VGND VPWR VPWR sky130_fd_sc_hd__decap_3
XFILLER_0_34_48 VGND VGND VPWR VPWR sky130_fd_sc_hd__decap_4
XFILLER_0_34_59 VGND VGND VPWR VPWR sky130_fd_sc_hd__fill_2
XFILLER_0_68_451 VGND VGND VPWR VPWR sky130_fd_sc_hd__decap_3
XFILLER_0_56_624 VGND VGND VPWR VPWR sky130_fd_sc_hd__decap_6
XANTENNA__7149__A1 _3479_ VGND VGND VPWR VPWR sky130_fd_sc_hd__diode_2
XFILLER_0_83_443 VGND VGND VPWR VPWR sky130_fd_sc_hd__fill_2
XFILLER_0_55_134 VGND VGND VPWR VPWR sky130_fd_sc_hd__fill_2
XTAP_TAPCELL_ROW_16_468 VGND VPWR sky130_fd_sc_hd__tapvpwrvgnd_1
XTAP_TAPCELL_ROW_103_1599 VGND VPWR sky130_fd_sc_hd__tapvpwrvgnd_1
XFILLER_0_83_476 VGND VGND VPWR VPWR sky130_fd_sc_hd__fill_2
XFILLER_0_56_679 VGND VGND VPWR VPWR sky130_fd_sc_hd__fill_1
XFILLER_0_56_668 VGND VGND VPWR VPWR sky130_fd_sc_hd__decap_4
XANTENNA__5255__S0 _1968_ VGND VGND VPWR VPWR sky130_fd_sc_hd__diode_2
XFILLER_0_71_649 VGND VGND VPWR VPWR sky130_fd_sc_hd__fill_2
XFILLER_0_71_627 VGND VGND VPWR VPWR sky130_fd_sc_hd__fill_2
XFILLER_0_55_189 VGND VGND VPWR VPWR sky130_fd_sc_hd__fill_2
XFILLER_0_50_69 VGND VGND VPWR VPWR sky130_fd_sc_hd__fill_1
XFILLER_0_43_318 VGND VGND VPWR VPWR sky130_fd_sc_hd__fill_2
XFILLER_0_36_370 VGND VGND VPWR VPWR sky130_fd_sc_hd__fill_2
XPHY_EDGE_ROW_25_Right_25 VGND VGND VPWR VPWR sky130_fd_sc_hd__decap_3
XFILLER_0_36_392 VGND VGND VPWR VPWR sky130_fd_sc_hd__fill_2
XTAP_TAPCELL_ROW_58_1012 VGND VPWR sky130_fd_sc_hd__tapvpwrvgnd_1
X_5230_ _1979_ VGND VGND VPWR VPWR net90 sky130_fd_sc_hd__inv_2
XFILLER_0_75_11 VGND VGND VPWR VPWR sky130_fd_sc_hd__fill_1
X_5161_ registers\[20\]\[15\] registers\[21\]\[15\] registers\[22\]\[15\] registers\[23\]\[15\]
+ _1806_ _1759_ VGND VGND VPWR VPWR _1914_ sky130_fd_sc_hd__mux4_1
X_5092_ _1771_ _1849_ _1778_ VGND VGND VPWR VPWR _1850_ sky130_fd_sc_hd__a21oi_1
XFILLER_0_75_44 VGND VGND VPWR VPWR sky130_fd_sc_hd__fill_2
X_8920_ clknet_leaf_82_clk _0017_ VGND VGND VPWR VPWR registers\[16\]\[24\] sky130_fd_sc_hd__dfxtp_1
XPHY_EDGE_ROW_34_Right_34 VGND VGND VPWR VPWR sky130_fd_sc_hd__decap_3
XFILLER_0_91_10 VGND VGND VPWR VPWR sky130_fd_sc_hd__decap_6
XTAP_TAPCELL_ROW_69_1152 VGND VPWR sky130_fd_sc_hd__tapvpwrvgnd_1
X_8851_ clknet_leaf_12_clk _0972_ VGND VGND VPWR VPWR registers\[14\]\[19\] sky130_fd_sc_hd__dfxtp_1
X_5994_ _2687_ _2697_ _2713_ _2422_ VGND VGND VPWR VPWR net56 sky130_fd_sc_hd__o22a_1
X_8782_ clknet_leaf_52_clk _0903_ VGND VGND VPWR VPWR registers\[12\]\[14\] sky130_fd_sc_hd__dfxtp_1
X_7802_ _3073_ registers\[26\]\[2\] _3829_ VGND VGND VPWR VPWR _3832_ sky130_fd_sc_hd__mux2_1
XTAP_TAPCELL_ROW_35_711 VGND VPWR sky130_fd_sc_hd__tapvpwrvgnd_1
X_4945_ _1707_ _1708_ _1627_ VGND VGND VPWR VPWR _1709_ sky130_fd_sc_hd__mux2_1
XFILLER_0_93_207 VGND VGND VPWR VPWR sky130_fd_sc_hd__fill_2
XTAP_TAPCELL_ROW_82_1330 VGND VPWR sky130_fd_sc_hd__tapvpwrvgnd_1
XANTENNA__4297__S1 _1061_ VGND VGND VPWR VPWR sky130_fd_sc_hd__diode_2
X_7733_ _3795_ VGND VGND VPWR VPWR _0282_ sky130_fd_sc_hd__clkbuf_1
XFILLER_0_86_281 VGND VGND VPWR VPWR sky130_fd_sc_hd__fill_2
XFILLER_0_47_657 VGND VGND VPWR VPWR sky130_fd_sc_hd__fill_1
XFILLER_0_19_337 VGND VGND VPWR VPWR sky130_fd_sc_hd__fill_2
XANTENNA__6342__S _3004_ VGND VGND VPWR VPWR sky130_fd_sc_hd__diode_2
XFILLER_0_117_523 VGND VGND VPWR VPWR sky130_fd_sc_hd__fill_2
XFILLER_0_117_512 VGND VGND VPWR VPWR sky130_fd_sc_hd__fill_2
X_4876_ net2 VGND VGND VPWR VPWR _1643_ sky130_fd_sc_hd__clkbuf_4
X_7664_ registers\[24\]\[1\] _3437_ _3757_ VGND VGND VPWR VPWR _3759_ sky130_fd_sc_hd__mux2_1
X_6615_ _3183_ VGND VGND VPWR VPWR _0800_ sky130_fd_sc_hd__clkbuf_1
XFILLER_0_61_104 VGND VGND VPWR VPWR sky130_fd_sc_hd__fill_2
XPHY_EDGE_ROW_43_Right_43 VGND VGND VPWR VPWR sky130_fd_sc_hd__decap_3
XFILLER_0_6_253 VGND VGND VPWR VPWR sky130_fd_sc_hd__decap_3
XFILLER_0_15_521 VGND VGND VPWR VPWR sky130_fd_sc_hd__fill_2
X_7595_ _3071_ registers\[23\]\[1\] _3720_ VGND VGND VPWR VPWR _3722_ sky130_fd_sc_hd__mux2_1
X_9403_ clknet_leaf_100_clk _0500_ VGND VGND VPWR VPWR registers\[9\]\[27\] sky130_fd_sc_hd__dfxtp_1
XFILLER_0_105_729 VGND VGND VPWR VPWR sky130_fd_sc_hd__fill_1
X_6546_ registers\[7\]\[8\] _2978_ _3137_ VGND VGND VPWR VPWR _3146_ sky130_fd_sc_hd__mux2_1
XFILLER_0_15_543 VGND VGND VPWR VPWR sky130_fd_sc_hd__fill_2
X_9334_ clknet_leaf_93_clk _0431_ VGND VGND VPWR VPWR registers\[2\]\[22\] sky130_fd_sc_hd__dfxtp_1
X_9265_ clknet_leaf_55_clk _0362_ VGND VGND VPWR VPWR registers\[27\]\[17\] sky130_fd_sc_hd__dfxtp_1
X_6477_ _3101_ VGND VGND VPWR VPWR _0744_ sky130_fd_sc_hd__clkbuf_1
XANTENNA__7312__A1 _3495_ VGND VGND VPWR VPWR sky130_fd_sc_hd__diode_2
XANTENNA__7173__S _3477_ VGND VGND VPWR VPWR sky130_fd_sc_hd__diode_2
XPHY_EDGE_ROW_18_Left_138 VGND VGND VPWR VPWR sky130_fd_sc_hd__decap_3
X_8216_ registers\[6\]\[5\] _3445_ _4045_ VGND VGND VPWR VPWR _4051_ sky130_fd_sc_hd__mux2_1
XTAP_TAPCELL_ROW_93_1470 VGND VPWR sky130_fd_sc_hd__tapvpwrvgnd_1
X_9196_ clknet_leaf_44_clk _0293_ VGND VGND VPWR VPWR registers\[25\]\[12\] sky130_fd_sc_hd__dfxtp_1
XFILLER_0_2_481 VGND VGND VPWR VPWR sky130_fd_sc_hd__fill_2
X_5428_ _2019_ _2166_ _1960_ VGND VGND VPWR VPWR _2167_ sky130_fd_sc_hd__o21ai_1
X_8147_ _4014_ VGND VGND VPWR VPWR _0477_ sky130_fd_sc_hd__clkbuf_1
X_5359_ _2101_ VGND VGND VPWR VPWR net98 sky130_fd_sc_hd__inv_2
XANTENNA__7901__S _3876_ VGND VGND VPWR VPWR sky130_fd_sc_hd__diode_2
X_8078_ _2970_ registers\[30\]\[4\] _3973_ VGND VGND VPWR VPWR _3978_ sky130_fd_sc_hd__mux2_1
XFILLER_0_100_489 VGND VGND VPWR VPWR sky130_fd_sc_hd__decap_3
X_7029_ _3083_ registers\[15\]\[7\] _3398_ VGND VGND VPWR VPWR _3406_ sky130_fd_sc_hd__mux2_1
XPHY_EDGE_ROW_52_Right_52 VGND VGND VPWR VPWR sky130_fd_sc_hd__decap_3
XANTENNA__4826__A _1389_ VGND VGND VPWR VPWR sky130_fd_sc_hd__diode_2
XFILLER_0_4_80 VGND VGND VPWR VPWR sky130_fd_sc_hd__fill_2
XPHY_EDGE_ROW_27_Left_147 VGND VGND VPWR VPWR sky130_fd_sc_hd__decap_3
XFILLER_0_97_579 VGND VGND VPWR VPWR sky130_fd_sc_hd__fill_1
XANTENNA__4288__S1 _1040_ VGND VGND VPWR VPWR sky130_fd_sc_hd__diode_2
XFILLER_0_77_281 VGND VGND VPWR VPWR sky130_fd_sc_hd__fill_2
XANTENNA__8328__A0 _3016_ VGND VGND VPWR VPWR sky130_fd_sc_hd__diode_2
XPHY_EDGE_ROW_61_Right_61 VGND VGND VPWR VPWR sky130_fd_sc_hd__decap_3
XTAP_TAPCELL_ROW_13_427 VGND VPWR sky130_fd_sc_hd__tapvpwrvgnd_1
XANTENNA__7000__A0 _3123_ VGND VGND VPWR VPWR sky130_fd_sc_hd__diode_2
XFILLER_0_37_145 VGND VGND VPWR VPWR sky130_fd_sc_hd__fill_2
XFILLER_0_108_545 VGND VGND VPWR VPWR sky130_fd_sc_hd__decap_4
XFILLER_0_108_589 VGND VGND VPWR VPWR sky130_fd_sc_hd__decap_8
XFILLER_0_20_17 VGND VGND VPWR VPWR sky130_fd_sc_hd__fill_1
XFILLER_0_33_340 VGND VGND VPWR VPWR sky130_fd_sc_hd__fill_2
XANTENNA__4460__S1 _1112_ VGND VGND VPWR VPWR sky130_fd_sc_hd__diode_2
XFILLER_0_61_671 VGND VGND VPWR VPWR sky130_fd_sc_hd__fill_1
XPHY_EDGE_ROW_36_Left_156 VGND VGND VPWR VPWR sky130_fd_sc_hd__decap_3
XFILLER_0_103_250 VGND VGND VPWR VPWR sky130_fd_sc_hd__fill_2
XFILLER_0_61_693 VPWR VGND VPWR VGND sky130_ef_sc_hd__decap_12
XFILLER_0_0_418 VGND VGND VPWR VPWR sky130_fd_sc_hd__fill_2
XANTENNA__5314__B1 _1687_ VGND VGND VPWR VPWR sky130_fd_sc_hd__diode_2
XPHY_EDGE_ROW_70_Right_70 VGND VGND VPWR VPWR sky130_fd_sc_hd__decap_3
XANTENNA__5865__A1 _1819_ VGND VGND VPWR VPWR sky130_fd_sc_hd__diode_2
XANTENNA__5865__B2 _1835_ VGND VGND VPWR VPWR sky130_fd_sc_hd__diode_2
XPHY_EDGE_ROW_45_Left_165 VGND VGND VPWR VPWR sky130_fd_sc_hd__decap_3
XTAP_TAPCELL_ROW_105_1628 VGND VPWR sky130_fd_sc_hd__tapvpwrvgnd_1
XFILLER_0_76_719 VGND VGND VPWR VPWR sky130_fd_sc_hd__fill_1
XANTENNA__4279__S1 _1040_ VGND VGND VPWR VPWR sky130_fd_sc_hd__diode_2
XFILLER_0_118_309 VGND VGND VPWR VPWR sky130_fd_sc_hd__fill_1
XANTENNA__7258__S _3539_ VGND VGND VPWR VPWR sky130_fd_sc_hd__diode_2
XFILLER_0_61_57 VGND VGND VPWR VPWR sky130_fd_sc_hd__decap_4
XFILLER_0_8_518 VGND VGND VPWR VPWR sky130_fd_sc_hd__fill_2
XTAP_TAPCELL_ROW_64_1093 VGND VPWR sky130_fd_sc_hd__tapvpwrvgnd_1
XFILLER_0_61_68 VGND VGND VPWR VPWR sky130_fd_sc_hd__fill_2
XFILLER_0_44_605 VGND VGND VPWR VPWR sky130_fd_sc_hd__fill_1
X_4730_ registers\[24\]\[25\] registers\[25\]\[25\] registers\[26\]\[25\] registers\[27\]\[25\]
+ _1415_ _1416_ VGND VGND VPWR VPWR _1505_ sky130_fd_sc_hd__mux4_1
XFILLER_0_16_307 VGND VGND VPWR VPWR sky130_fd_sc_hd__fill_1
XFILLER_0_28_156 VGND VGND VPWR VPWR sky130_fd_sc_hd__fill_2
XFILLER_0_29_668 VGND VGND VPWR VPWR sky130_fd_sc_hd__fill_2
XFILLER_0_71_424 VGND VGND VPWR VPWR sky130_fd_sc_hd__decap_3
X_4661_ _1440_ VGND VGND VPWR VPWR net125 sky130_fd_sc_hd__inv_2
XFILLER_0_44_649 VGND VGND VPWR VPWR sky130_fd_sc_hd__fill_1
XFILLER_0_9_14 VGND VGND VPWR VPWR sky130_fd_sc_hd__decap_4
XPHY_EDGE_ROW_54_Left_174 VGND VGND VPWR VPWR sky130_fd_sc_hd__decap_3
XTAP_TAPCELL_ROW_40_780 VGND VPWR sky130_fd_sc_hd__tapvpwrvgnd_1
XFILLER_0_37_690 VGND VGND VPWR VPWR sky130_fd_sc_hd__fill_2
X_7380_ registers\[1\]\[29\] _3495_ _3597_ VGND VGND VPWR VPWR _3607_ sky130_fd_sc_hd__mux2_1
X_6400_ _3029_ VGND VGND VPWR VPWR _3052_ sky130_fd_sc_hd__clkbuf_8
XFILLER_0_114_537 VGND VGND VPWR VPWR sky130_fd_sc_hd__decap_3
XANTENNA__4451__S1 _1112_ VGND VGND VPWR VPWR sky130_fd_sc_hd__diode_2
X_4592_ registers\[16\]\[18\] registers\[17\]\[18\] registers\[18\]\[18\] registers\[19\]\[18\]
+ _1338_ _1339_ VGND VGND VPWR VPWR _1374_ sky130_fd_sc_hd__mux4_1
XFILLER_0_52_682 VGND VGND VPWR VPWR sky130_fd_sc_hd__decap_6
X_6331_ _3011_ VGND VGND VPWR VPWR _0688_ sky130_fd_sc_hd__clkbuf_1
XTAP_TAPCELL_ROW_116_1768 VGND VPWR sky130_fd_sc_hd__tapvpwrvgnd_1
XFILLER_0_24_395 VGND VGND VPWR VPWR sky130_fd_sc_hd__fill_2
XFILLER_0_110_732 VGND VGND VPWR VPWR sky130_fd_sc_hd__fill_1
XFILLER_0_10_83 VGND VGND VPWR VPWR sky130_fd_sc_hd__fill_1
XFILLER_0_12_557 VGND VGND VPWR VPWR sky130_fd_sc_hd__decap_3
XFILLER_0_12_579 VGND VGND VPWR VPWR sky130_fd_sc_hd__decap_3
X_6262_ registers\[19\]\[1\] _2964_ _2962_ VGND VGND VPWR VPWR _2965_ sky130_fd_sc_hd__mux2_1
X_9050_ clknet_leaf_78_clk _0147_ VGND VGND VPWR VPWR registers\[20\]\[26\] sky130_fd_sc_hd__dfxtp_1
X_6193_ _2638_ _2695_ VGND VGND VPWR VPWR _2901_ sky130_fd_sc_hd__nand2_1
X_8001_ _3936_ VGND VGND VPWR VPWR _3937_ sky130_fd_sc_hd__clkbuf_8
X_5213_ _1961_ _1962_ _1746_ VGND VGND VPWR VPWR _1963_ sky130_fd_sc_hd__mux2_1
XANTENNA__5400__S0 _2097_ VGND VGND VPWR VPWR sky130_fd_sc_hd__diode_2
X_5144_ _1677_ _1890_ _1894_ _1898_ VGND VGND VPWR VPWR _1899_ sky130_fd_sc_hd__a2bb2o_2
XPHY_EDGE_ROW_63_Left_183 VGND VGND VPWR VPWR sky130_fd_sc_hd__decap_3
X_5075_ _1828_ _1830_ _1833_ _1714_ _1702_ VGND VGND VPWR VPWR _1834_ sky130_fd_sc_hd__a221o_1
X_8903_ clknet_leaf_24_clk _0000_ VGND VGND VPWR VPWR registers\[16\]\[7\] sky130_fd_sc_hd__dfxtp_1
XFILLER_0_79_568 VGND VGND VPWR VPWR sky130_fd_sc_hd__fill_1
XTAP_TAPCELL_ROW_48_880 VGND VPWR sky130_fd_sc_hd__tapvpwrvgnd_1
X_8834_ clknet_leaf_4_clk _0955_ VGND VGND VPWR VPWR registers\[14\]\[2\] sky130_fd_sc_hd__dfxtp_1
XFILLER_0_66_218 VGND VGND VPWR VPWR sky130_fd_sc_hd__fill_2
Xclkbuf_leaf_91_clk clknet_4_8_0_clk VGND VGND VPWR VPWR clknet_leaf_91_clk sky130_fd_sc_hd__clkbuf_8
X_5977_ _2468_ _2691_ _2693_ _2696_ VGND VGND VPWR VPWR _2697_ sky130_fd_sc_hd__a211o_1
XFILLER_0_47_432 VGND VGND VPWR VPWR sky130_fd_sc_hd__decap_8
X_8765_ clknet_leaf_106_clk _0886_ VGND VGND VPWR VPWR registers\[11\]\[29\] sky130_fd_sc_hd__dfxtp_1
XANTENNA__6072__S _2353_ VGND VGND VPWR VPWR sky130_fd_sc_hd__diode_2
X_4928_ registers\[8\]\[3\] registers\[9\]\[3\] registers\[10\]\[3\] registers\[11\]\[3\]
+ _1690_ _1692_ VGND VGND VPWR VPWR _1693_ sky130_fd_sc_hd__mux4_1
X_8696_ clknet_leaf_87_clk _0817_ VGND VGND VPWR VPWR registers\[0\]\[24\] sky130_fd_sc_hd__dfxtp_1
XFILLER_0_19_145 VPWR VGND VPWR VGND sky130_ef_sc_hd__decap_12
X_7716_ registers\[24\]\[26\] _3489_ _3779_ VGND VGND VPWR VPWR _3786_ sky130_fd_sc_hd__mux2_1
XFILLER_0_35_605 VGND VGND VPWR VPWR sky130_fd_sc_hd__fill_2
XPHY_EDGE_ROW_72_Left_192 VGND VGND VPWR VPWR sky130_fd_sc_hd__decap_3
XFILLER_0_62_413 VGND VGND VPWR VPWR sky130_fd_sc_hd__decap_4
XFILLER_0_47_487 VGND VGND VPWR VPWR sky130_fd_sc_hd__fill_1
XFILLER_0_7_540 VGND VGND VPWR VPWR sky130_fd_sc_hd__fill_2
X_7647_ _3123_ registers\[23\]\[26\] _3742_ VGND VGND VPWR VPWR _3749_ sky130_fd_sc_hd__mux2_1
XFILLER_0_34_104 VGND VGND VPWR VPWR sky130_fd_sc_hd__fill_1
XFILLER_0_117_375 VGND VGND VPWR VPWR sky130_fd_sc_hd__decap_8
XFILLER_0_62_446 VGND VGND VPWR VPWR sky130_fd_sc_hd__fill_2
XANTENNA_clkbuf_leaf_7_clk_A clknet_4_1_0_clk VGND VGND VPWR VPWR sky130_fd_sc_hd__diode_2
X_4859_ _1621_ VGND VGND VPWR VPWR _1627_ sky130_fd_sc_hd__buf_4
XFILLER_0_105_537 VGND VGND VPWR VPWR sky130_fd_sc_hd__decap_3
XANTENNA__4442__S1 _1202_ VGND VGND VPWR VPWR sky130_fd_sc_hd__diode_2
XFILLER_0_43_671 VGND VGND VPWR VPWR sky130_fd_sc_hd__fill_1
X_7578_ _3712_ VGND VGND VPWR VPWR _0210_ sky130_fd_sc_hd__clkbuf_1
XFILLER_0_15_362 VGND VGND VPWR VPWR sky130_fd_sc_hd__fill_2
X_9317_ clknet_leaf_32_clk _0414_ VGND VGND VPWR VPWR registers\[2\]\[5\] sky130_fd_sc_hd__dfxtp_1
X_6529_ _3136_ VGND VGND VPWR VPWR _3137_ sky130_fd_sc_hd__clkbuf_8
XANTENNA__5416__S _2081_ VGND VGND VPWR VPWR sky130_fd_sc_hd__diode_2
X_9248_ clknet_leaf_111_clk _0345_ VGND VGND VPWR VPWR registers\[27\]\[0\] sky130_fd_sc_hd__dfxtp_1
XFILLER_0_30_365 VGND VGND VPWR VPWR sky130_fd_sc_hd__decap_3
XFILLER_0_100_275 VGND VGND VPWR VPWR sky130_fd_sc_hd__decap_4
XFILLER_0_100_253 VGND VGND VPWR VPWR sky130_fd_sc_hd__fill_1
XANTENNA__5940__A net86 VGND VGND VPWR VPWR sky130_fd_sc_hd__diode_2
X_9179_ clknet_leaf_89_clk _0276_ VGND VGND VPWR VPWR registers\[24\]\[27\] sky130_fd_sc_hd__dfxtp_1
XANTENNA__8462__S _4175_ VGND VGND VPWR VPWR sky130_fd_sc_hd__diode_2
XFILLER_0_58_719 VGND VGND VPWR VPWR sky130_fd_sc_hd__fill_2
Xclkbuf_leaf_82_clk clknet_4_10_0_clk VGND VGND VPWR VPWR clknet_leaf_82_clk sky130_fd_sc_hd__clkbuf_8
XTAP_TAPCELL_ROW_26_596 VGND VPWR sky130_fd_sc_hd__tapvpwrvgnd_1
XTAP_TAPCELL_ROW_100_1558 VGND VPWR sky130_fd_sc_hd__tapvpwrvgnd_1
XFILLER_0_80_210 VGND VGND VPWR VPWR sky130_fd_sc_hd__fill_1
XFILLER_0_53_402 VPWR VGND VPWR VGND sky130_ef_sc_hd__decap_12
XFILLER_0_38_498 VGND VGND VPWR VPWR sky130_fd_sc_hd__fill_2
XFILLER_0_31_49 VGND VGND VPWR VPWR sky130_fd_sc_hd__fill_2
XANTENNA__4681__S1 _1159_ VGND VGND VPWR VPWR sky130_fd_sc_hd__diode_2
XANTENNA__7806__S _3829_ VGND VGND VPWR VPWR sky130_fd_sc_hd__diode_2
XFILLER_0_80_232 VPWR VGND VPWR VGND sky130_ef_sc_hd__decap_12
XANTENNA__6710__S _3225_ VGND VGND VPWR VPWR sky130_fd_sc_hd__diode_2
XANTENNA__5326__S _2031_ VGND VGND VPWR VPWR sky130_fd_sc_hd__diode_2
XFILLER_0_1_705 VPWR VGND VPWR VGND sky130_ef_sc_hd__decap_12
XANTENNA__7107__A net46 VGND VGND VPWR VPWR sky130_fd_sc_hd__diode_2
XANTENNA__5838__A1 _2269_ VGND VGND VPWR VPWR sky130_fd_sc_hd__diode_2
XANTENNA__7541__S _3684_ VGND VGND VPWR VPWR sky130_fd_sc_hd__diode_2
XTAP_TAPCELL_ROW_111_1698 VGND VPWR sky130_fd_sc_hd__tapvpwrvgnd_1
XFILLER_0_56_24 VGND VGND VPWR VPWR sky130_fd_sc_hd__fill_2
XTAP_TAPCELL_ROW_66_1111 VGND VPWR sky130_fd_sc_hd__tapvpwrvgnd_1
X_5900_ _1882_ _2623_ VGND VGND VPWR VPWR _2624_ sky130_fd_sc_hd__nor2_1
XFILLER_0_15_9 VGND VGND VPWR VPWR sky130_fd_sc_hd__fill_1
XFILLER_0_88_365 VGND VGND VPWR VPWR sky130_fd_sc_hd__fill_1
XTAP_TAPCELL_ROW_66_1122 VGND VPWR sky130_fd_sc_hd__tapvpwrvgnd_1
X_6880_ _3326_ VGND VGND VPWR VPWR _0922_ sky130_fd_sc_hd__clkbuf_1
Xclkbuf_leaf_73_clk clknet_4_11_0_clk VGND VGND VPWR VPWR clknet_leaf_73_clk sky130_fd_sc_hd__clkbuf_8
XANTENNA__5449__S0 _2119_ VGND VGND VPWR VPWR sky130_fd_sc_hd__diode_2
X_5831_ _2557_ _2558_ VGND VGND VPWR VPWR _2559_ sky130_fd_sc_hd__or2b_1
XTAP_TAPCELL_ROW_45_850 VGND VPWR sky130_fd_sc_hd__tapvpwrvgnd_1
XFILLER_0_119_629 VPWR VGND VPWR VGND sky130_ef_sc_hd__decap_12
X_8550_ clknet_leaf_34_clk _0671_ VGND VGND VPWR VPWR registers\[19\]\[6\] sky130_fd_sc_hd__dfxtp_1
X_5762_ _2355_ _2350_ VGND VGND VPWR VPWR _2493_ sky130_fd_sc_hd__and2_1
XANTENNA__5297__A _1754_ VGND VGND VPWR VPWR sky130_fd_sc_hd__diode_2
XFILLER_0_56_273 VGND VGND VPWR VPWR sky130_fd_sc_hd__fill_2
XFILLER_0_44_402 VGND VGND VPWR VPWR sky130_fd_sc_hd__fill_1
X_4713_ registers\[16\]\[24\] registers\[17\]\[24\] registers\[18\]\[24\] registers\[19\]\[24\]
+ _1418_ _1419_ VGND VGND VPWR VPWR _1489_ sky130_fd_sc_hd__mux4_1
XANTENNA__4672__S1 _1383_ VGND VGND VPWR VPWR sky130_fd_sc_hd__diode_2
XFILLER_0_17_638 VGND VGND VPWR VPWR sky130_fd_sc_hd__fill_2
X_7501_ _3113_ registers\[21\]\[21\] _3670_ VGND VGND VPWR VPWR _3672_ sky130_fd_sc_hd__mux2_1
X_5693_ _2274_ _2397_ _2426_ VGND VGND VPWR VPWR _2427_ sky130_fd_sc_hd__o21ai_2
X_8481_ _4191_ VGND VGND VPWR VPWR _0634_ sky130_fd_sc_hd__clkbuf_1
XFILLER_0_17_649 VGND VGND VPWR VPWR sky130_fd_sc_hd__fill_2
XANTENNA__7716__S _3779_ VGND VGND VPWR VPWR sky130_fd_sc_hd__diode_2
XFILLER_0_71_254 VGND VGND VPWR VPWR sky130_fd_sc_hd__fill_1
X_7432_ _3635_ VGND VGND VPWR VPWR _0141_ sky130_fd_sc_hd__clkbuf_1
XFILLER_0_32_619 VGND VGND VPWR VPWR sky130_fd_sc_hd__fill_2
X_4644_ registers\[24\]\[20\] registers\[25\]\[20\] registers\[26\]\[20\] registers\[27\]\[20\]
+ _1418_ _1419_ VGND VGND VPWR VPWR _1424_ sky130_fd_sc_hd__mux4_1
XFILLER_0_114_378 VGND VGND VPWR VPWR sky130_fd_sc_hd__fill_2
X_4575_ registers\[28\]\[17\] registers\[29\]\[17\] registers\[30\]\[17\] registers\[31\]\[17\]
+ _1136_ _1137_ VGND VGND VPWR VPWR _1358_ sky130_fd_sc_hd__mux4_1
XFILLER_0_102_518 VGND VGND VPWR VPWR sky130_fd_sc_hd__fill_2
XANTENNA__4424__S1 _1202_ VGND VGND VPWR VPWR sky130_fd_sc_hd__diode_2
XFILLER_0_21_93 VGND VGND VPWR VPWR sky130_fd_sc_hd__fill_1
X_7363_ _3598_ VGND VGND VPWR VPWR _0109_ sky130_fd_sc_hd__clkbuf_1
X_9102_ clknet_leaf_38_clk _0199_ VGND VGND VPWR VPWR registers\[22\]\[14\] sky130_fd_sc_hd__dfxtp_1
XTAP_TAPCELL_ROW_77_1262 VGND VPWR sky130_fd_sc_hd__tapvpwrvgnd_1
XANTENNA__5236__S _1682_ VGND VGND VPWR VPWR sky130_fd_sc_hd__diode_2
X_6314_ registers\[19\]\[18\] _2999_ _2983_ VGND VGND VPWR VPWR _3000_ sky130_fd_sc_hd__mux2_1
X_7294_ registers\[18\]\[20\] _3476_ _3561_ VGND VGND VPWR VPWR _3562_ sky130_fd_sc_hd__mux2_1
XFILLER_0_24_192 VGND VGND VPWR VPWR sky130_fd_sc_hd__fill_2
XFILLER_0_97_97 VGND VGND VPWR VPWR sky130_fd_sc_hd__fill_2
X_6245_ _2948_ _2949_ VGND VGND VPWR VPWR _2950_ sky130_fd_sc_hd__xnor2_1
X_9033_ clknet_leaf_8_clk _0130_ VGND VGND VPWR VPWR registers\[20\]\[9\] sky130_fd_sc_hd__dfxtp_1
XFILLER_0_12_365 VGND VGND VPWR VPWR sky130_fd_sc_hd__decap_3
XANTENNA__7451__S _3611_ VGND VGND VPWR VPWR sky130_fd_sc_hd__diode_2
XANTENNA__5429__A1_N _1977_ VGND VGND VPWR VPWR sky130_fd_sc_hd__diode_2
X_6176_ _2874_ _2877_ _2884_ VGND VGND VPWR VPWR _2885_ sky130_fd_sc_hd__o21ba_1
X_5127_ _1882_ VGND VGND VPWR VPWR net84 sky130_fd_sc_hd__inv_2
X_5058_ _1808_ _1813_ _1817_ _1754_ _1702_ VGND VGND VPWR VPWR _1818_ sky130_fd_sc_hd__a221o_1
XPHY_EDGE_ROW_2_Right_2 VGND VGND VPWR VPWR sky130_fd_sc_hd__decap_3
XANTENNA__4360__S0 _1126_ VGND VGND VPWR VPWR sky130_fd_sc_hd__diode_2
XANTENNA__8282__S _4081_ VGND VGND VPWR VPWR sky130_fd_sc_hd__diode_2
XFILLER_0_79_365 VGND VGND VPWR VPWR sky130_fd_sc_hd__fill_2
XFILLER_0_79_354 VGND VGND VPWR VPWR sky130_fd_sc_hd__decap_4
Xclkbuf_leaf_64_clk clknet_4_14_0_clk VGND VGND VPWR VPWR clknet_leaf_64_clk sky130_fd_sc_hd__clkbuf_8
X_8817_ clknet_leaf_50_clk _0938_ VGND VGND VPWR VPWR registers\[13\]\[17\] sky130_fd_sc_hd__dfxtp_1
XFILLER_0_1_81 VPWR VGND VPWR VGND sky130_ef_sc_hd__decap_12
XPHY_EDGE_ROW_80_Left_200 VGND VGND VPWR VPWR sky130_fd_sc_hd__decap_3
X_8748_ clknet_leaf_15_clk _0869_ VGND VGND VPWR VPWR registers\[11\]\[12\] sky130_fd_sc_hd__dfxtp_1
XANTENNA__4568__A1 _1346_ VGND VGND VPWR VPWR sky130_fd_sc_hd__diode_2
XFILLER_0_75_582 VGND VGND VPWR VPWR sky130_fd_sc_hd__fill_2
XANTENNA__5000__A _1731_ VGND VGND VPWR VPWR sky130_fd_sc_hd__diode_2
XANTENNA__4663__S1 _1428_ VGND VGND VPWR VPWR sky130_fd_sc_hd__diode_2
XTAP_TAPCELL_ROW_23_555 VGND VPWR sky130_fd_sc_hd__tapvpwrvgnd_1
XFILLER_0_90_541 VGND VGND VPWR VPWR sky130_fd_sc_hd__decap_4
X_8679_ clknet_leaf_18_clk _0800_ VGND VGND VPWR VPWR registers\[0\]\[7\] sky130_fd_sc_hd__dfxtp_1
XANTENNA__7626__S _3731_ VGND VGND VPWR VPWR sky130_fd_sc_hd__diode_2
XFILLER_0_62_221 VGND VGND VPWR VPWR sky130_fd_sc_hd__fill_2
XFILLER_0_90_552 VGND VGND VPWR VPWR sky130_fd_sc_hd__decap_4
XANTENNA__6530__S _3137_ VGND VGND VPWR VPWR sky130_fd_sc_hd__diode_2
XANTENNA__4740__A1 _1513_ VGND VGND VPWR VPWR sky130_fd_sc_hd__diode_2
XANTENNA__4985__S _1746_ VGND VGND VPWR VPWR sky130_fd_sc_hd__diode_2
XANTENNA_input32_A wd3[24] VGND VGND VPWR VPWR sky130_fd_sc_hd__diode_2
Xclkbuf_leaf_55_clk clknet_4_13_0_clk VGND VGND VPWR VPWR clknet_leaf_55_clk sky130_fd_sc_hd__clkbuf_8
XFILLER_0_97_151 VGND VGND VPWR VPWR sky130_fd_sc_hd__fill_2
XANTENNA__4351__S0 _1111_ VGND VGND VPWR VPWR sky130_fd_sc_hd__diode_2
XFILLER_0_85_302 VGND VGND VPWR VPWR sky130_fd_sc_hd__decap_3
XFILLER_0_58_516 VGND VGND VPWR VPWR sky130_fd_sc_hd__fill_2
XANTENNA__8192__S _4031_ VGND VGND VPWR VPWR sky130_fd_sc_hd__diode_2
XFILLER_0_38_262 VGND VGND VPWR VPWR sky130_fd_sc_hd__decap_3
XFILLER_0_109_673 VPWR VGND VPWR VGND sky130_ef_sc_hd__decap_12
XFILLER_0_108_150 VGND VGND VPWR VPWR sky130_fd_sc_hd__fill_2
XTAP_TAPCELL_ROW_61_1052 VGND VPWR sky130_fd_sc_hd__tapvpwrvgnd_1
XFILLER_0_26_446 VGND VGND VPWR VPWR sky130_fd_sc_hd__decap_3
XFILLER_0_53_276 VGND VGND VPWR VPWR sky130_fd_sc_hd__fill_2
XANTENNA__5564__B _2213_ VGND VGND VPWR VPWR sky130_fd_sc_hd__diode_2
X_4360_ registers\[8\]\[5\] registers\[9\]\[5\] registers\[10\]\[5\] registers\[11\]\[5\]
+ _1126_ _1128_ VGND VGND VPWR VPWR _1155_ sky130_fd_sc_hd__mux4_1
XFILLER_0_6_15 VGND VGND VPWR VPWR sky130_fd_sc_hd__fill_1
XTAP_TAPCELL_ROW_113_1727 VGND VPWR sky130_fd_sc_hd__tapvpwrvgnd_1
XFILLER_0_111_337 VGND VGND VPWR VPWR sky130_fd_sc_hd__decap_4
XFILLER_0_22_696 VGND VGND VPWR VPWR sky130_fd_sc_hd__fill_1
XANTENNA__8367__S _4128_ VGND VGND VPWR VPWR sky130_fd_sc_hd__diode_2
X_4291_ _1073_ _1080_ _1088_ VGND VGND VPWR VPWR _1089_ sky130_fd_sc_hd__o21ai_4
XFILLER_0_67_78 VGND VGND VPWR VPWR sky130_fd_sc_hd__fill_2
X_6030_ _2746_ _2747_ _2399_ VGND VGND VPWR VPWR _2748_ sky130_fd_sc_hd__a21o_1
XTAP_TAPCELL_ROW_72_1192 VGND VPWR sky130_fd_sc_hd__tapvpwrvgnd_1
XFILLER_0_89_641 VGND VGND VPWR VPWR sky130_fd_sc_hd__fill_2
X_7981_ _3926_ VGND VGND VPWR VPWR _0399_ sky130_fd_sc_hd__clkbuf_1
XANTENNA__4342__S0 _1136_ VGND VGND VPWR VPWR sky130_fd_sc_hd__diode_2
XFILLER_0_89_652 VGND VGND VPWR VPWR sky130_fd_sc_hd__fill_1
Xclkbuf_leaf_46_clk clknet_4_12_0_clk VGND VGND VPWR VPWR clknet_leaf_46_clk sky130_fd_sc_hd__clkbuf_8
XFILLER_0_49_505 VGND VGND VPWR VPWR sky130_fd_sc_hd__fill_2
XANTENNA__4924__A _1631_ VGND VGND VPWR VPWR sky130_fd_sc_hd__diode_2
XFILLER_0_13_6 VGND VGND VPWR VPWR sky130_fd_sc_hd__fill_1
X_6932_ _3353_ VGND VGND VPWR VPWR _0947_ sky130_fd_sc_hd__clkbuf_1
XFILLER_0_107_95 VGND VGND VPWR VPWR sky130_fd_sc_hd__decap_4
XANTENNA__5739__B _2269_ VGND VGND VPWR VPWR sky130_fd_sc_hd__diode_2
XFILLER_0_89_696 VGND VGND VPWR VPWR sky130_fd_sc_hd__fill_1
XFILLER_0_16_93 VGND VGND VPWR VPWR sky130_fd_sc_hd__fill_2
X_6863_ registers\[12\]\[26\] _3016_ _3310_ VGND VGND VPWR VPWR _3317_ sky130_fd_sc_hd__mux2_1
X_5814_ _2451_ _2443_ net135 VGND VGND VPWR VPWR _2543_ sky130_fd_sc_hd__mux2_1
X_8602_ clknet_leaf_90_clk _0723_ VGND VGND VPWR VPWR registers\[3\]\[26\] sky130_fd_sc_hd__dfxtp_1
XFILLER_0_29_240 VGND VGND VPWR VPWR sky130_fd_sc_hd__decap_4
XFILLER_0_57_571 VGND VGND VPWR VPWR sky130_fd_sc_hd__decap_4
X_6794_ _3279_ VGND VGND VPWR VPWR _0883_ sky130_fd_sc_hd__clkbuf_1
X_5745_ _1725_ _2476_ VGND VGND VPWR VPWR _2477_ sky130_fd_sc_hd__nor2_1
XANTENNA__5755__A _1166_ VGND VGND VPWR VPWR sky130_fd_sc_hd__diode_2
XFILLER_0_72_541 VGND VGND VPWR VPWR sky130_fd_sc_hd__decap_6
XFILLER_0_72_530 VGND VGND VPWR VPWR sky130_fd_sc_hd__fill_2
XTAP_TAPCELL_ROW_20_514 VGND VPWR sky130_fd_sc_hd__tapvpwrvgnd_1
X_8533_ _4218_ VGND VGND VPWR VPWR _0659_ sky130_fd_sc_hd__clkbuf_1
XANTENNA__8161__A1 _3458_ VGND VGND VPWR VPWR sky130_fd_sc_hd__diode_2
X_5676_ _2237_ _2244_ _2266_ VGND VGND VPWR VPWR _2410_ sky130_fd_sc_hd__mux2_1
XFILLER_0_72_574 VGND VGND VPWR VPWR sky130_fd_sc_hd__fill_2
XTAP_TAPCELL_ROW_20_525 VGND VPWR sky130_fd_sc_hd__tapvpwrvgnd_1
X_8464_ registers\[8\]\[26\] net34 _4175_ VGND VGND VPWR VPWR _4182_ sky130_fd_sc_hd__mux2_1
X_7415_ _3626_ VGND VGND VPWR VPWR _0133_ sky130_fd_sc_hd__clkbuf_1
XFILLER_0_60_725 VGND VGND VPWR VPWR sky130_fd_sc_hd__fill_2
X_4627_ _1406_ _1407_ _1362_ VGND VGND VPWR VPWR _1408_ sky130_fd_sc_hd__mux2_1
XANTENNA__5474__B _1585_ VGND VGND VPWR VPWR sky130_fd_sc_hd__diode_2
XFILLER_0_32_416 VGND VGND VPWR VPWR sky130_fd_sc_hd__fill_1
XANTENNA__5070__S1 _1759_ VGND VGND VPWR VPWR sky130_fd_sc_hd__diode_2
X_8395_ _4145_ VGND VGND VPWR VPWR _0594_ sky130_fd_sc_hd__clkbuf_1
XFILLER_0_114_197 VGND VGND VPWR VPWR sky130_fd_sc_hd__fill_2
X_7346_ _3589_ VGND VGND VPWR VPWR _0101_ sky130_fd_sc_hd__clkbuf_1
X_4558_ registers\[28\]\[16\] registers\[29\]\[16\] registers\[30\]\[16\] registers\[31\]\[16\]
+ _1320_ _1321_ VGND VGND VPWR VPWR _1342_ sky130_fd_sc_hd__mux4_1
X_7277_ registers\[18\]\[12\] _3460_ _3550_ VGND VGND VPWR VPWR _3553_ sky130_fd_sc_hd__mux2_1
X_4489_ _1273_ _1276_ _1122_ VGND VGND VPWR VPWR _1277_ sky130_fd_sc_hd__mux2_1
XFILLER_0_110_381 VGND VGND VPWR VPWR sky130_fd_sc_hd__fill_1
X_6228_ _2308_ _2896_ _2933_ VGND VGND VPWR VPWR _2934_ sky130_fd_sc_hd__o21a_1
X_9016_ clknet_leaf_87_clk _0113_ VGND VGND VPWR VPWR registers\[1\]\[24\] sky130_fd_sc_hd__dfxtp_1
X_6159_ _2867_ _2868_ _2460_ VGND VGND VPWR VPWR _2869_ sky130_fd_sc_hd__mux2_1
XANTENNA__4581__S0 _1201_ VGND VGND VPWR VPWR sky130_fd_sc_hd__diode_2
XFILLER_0_99_449 VGND VGND VPWR VPWR sky130_fd_sc_hd__fill_2
XANTENNA__4333__S0 _1126_ VGND VGND VPWR VPWR sky130_fd_sc_hd__diode_2
Xclkbuf_leaf_37_clk clknet_4_7_0_clk VGND VGND VPWR VPWR clknet_leaf_37_clk sky130_fd_sc_hd__clkbuf_8
XTAP_TAPCELL_ROW_28_625 VGND VPWR sky130_fd_sc_hd__tapvpwrvgnd_1
XANTENNA__6525__S _3068_ VGND VGND VPWR VPWR sky130_fd_sc_hd__diode_2
XFILLER_0_79_173 VGND VGND VPWR VPWR sky130_fd_sc_hd__decap_3
XTAP_TAPCELL_ROW_56_989 VGND VPWR sky130_fd_sc_hd__tapvpwrvgnd_1
XANTENNA__4884__S1 _1629_ VGND VGND VPWR VPWR sky130_fd_sc_hd__diode_2
XTAP_TAPCELL_ROW_0_250 VGND VPWR sky130_fd_sc_hd__tapvpwrvgnd_1
XTAP_TAPCELL_ROW_0_261 VGND VPWR sky130_fd_sc_hd__tapvpwrvgnd_1
XFILLER_0_95_677 VGND VGND VPWR VPWR sky130_fd_sc_hd__decap_6
XFILLER_0_36_711 VGND VGND VPWR VPWR sky130_fd_sc_hd__fill_2
XFILLER_0_12_29 VGND VGND VPWR VPWR sky130_fd_sc_hd__decap_3
XFILLER_0_35_232 VGND VGND VPWR VPWR sky130_fd_sc_hd__decap_3
XFILLER_0_51_703 VGND VGND VPWR VPWR sky130_fd_sc_hd__fill_1
XANTENNA__8152__A1 _3449_ VGND VGND VPWR VPWR sky130_fd_sc_hd__diode_2
XFILLER_0_23_449 VGND VGND VPWR VPWR sky130_fd_sc_hd__decap_3
Xoutput51 net51 VGND VGND VPWR VPWR alu_result[11] sky130_fd_sc_hd__buf_1
Xoutput62 net62 VGND VGND VPWR VPWR alu_result[21] sky130_fd_sc_hd__buf_1
Xoutput73 net73 VGND VGND VPWR VPWR alu_result[31] sky130_fd_sc_hd__buf_1
XTAP_TAPCELL_ROW_8_361 VGND VPWR sky130_fd_sc_hd__tapvpwrvgnd_1
Xoutput84 net84 VGND VGND VPWR VPWR rd1[12] sky130_fd_sc_hd__buf_1
XANTENNA__5674__C1 _2362_ VGND VGND VPWR VPWR sky130_fd_sc_hd__diode_2
Xoutput95 net95 VGND VGND VPWR VPWR rd1[22] sky130_fd_sc_hd__buf_1
XANTENNA_clkbuf_leaf_94_clk_A clknet_4_9_0_clk VGND VGND VPWR VPWR sky130_fd_sc_hd__diode_2
XFILLER_0_37_26 VGND VGND VPWR VPWR sky130_fd_sc_hd__fill_2
XFILLER_0_37_48 VGND VGND VPWR VPWR sky130_fd_sc_hd__fill_2
XANTENNA__4515__A1_N _1073_ VGND VGND VPWR VPWR sky130_fd_sc_hd__diode_2
Xclkbuf_leaf_28_clk clknet_4_5_0_clk VGND VGND VPWR VPWR clknet_leaf_28_clk sky130_fd_sc_hd__clkbuf_8
XANTENNA__4324__S0 _1111_ VGND VGND VPWR VPWR sky130_fd_sc_hd__diode_2
XANTENNA__7120__A net19 VGND VGND VPWR VPWR sky130_fd_sc_hd__diode_2
XFILLER_0_58_302 VGND VGND VPWR VPWR sky130_fd_sc_hd__decap_4
XANTENNA__7718__A1 _3491_ VGND VGND VPWR VPWR sky130_fd_sc_hd__diode_2
XANTENNA_clkbuf_leaf_32_clk_A clknet_4_5_0_clk VGND VGND VPWR VPWR sky130_fd_sc_hd__diode_2
XANTENNA__7266__S _3539_ VGND VGND VPWR VPWR sky130_fd_sc_hd__diode_2
XFILLER_0_26_210 VGND VGND VPWR VPWR sky130_fd_sc_hd__fill_1
XFILLER_0_109_481 VGND VGND VPWR VPWR sky130_fd_sc_hd__fill_1
X_5530_ _1071_ VGND VGND VPWR VPWR _2266_ sky130_fd_sc_hd__clkbuf_4
XANTENNA__5575__A _1704_ VGND VGND VPWR VPWR sky130_fd_sc_hd__diode_2
XFILLER_0_14_405 VGND VGND VPWR VPWR sky130_fd_sc_hd__fill_2
X_5461_ net14 VGND VGND VPWR VPWR _2197_ sky130_fd_sc_hd__inv_2
XFILLER_0_26_298 VGND VGND VPWR VPWR sky130_fd_sc_hd__fill_1
XFILLER_0_26_287 VGND VGND VPWR VPWR sky130_fd_sc_hd__decap_3
X_4412_ registers\[0\]\[7\] registers\[1\]\[7\] registers\[2\]\[7\] registers\[3\]\[7\]
+ _1201_ _1204_ VGND VGND VPWR VPWR _1205_ sky130_fd_sc_hd__mux4_1
XANTENNA__5052__S1 _1811_ VGND VGND VPWR VPWR sky130_fd_sc_hd__diode_2
X_7200_ registers\[17\]\[8\] _3451_ _3503_ VGND VGND VPWR VPWR _3512_ sky130_fd_sc_hd__mux2_1
XTAP_TAPCELL_ROW_74_1221 VGND VPWR sky130_fd_sc_hd__tapvpwrvgnd_1
X_5392_ registers\[0\]\[27\] registers\[1\]\[27\] registers\[2\]\[27\] registers\[3\]\[27\]
+ _2126_ _2127_ VGND VGND VPWR VPWR _2133_ sky130_fd_sc_hd__mux4_1
X_8180_ registers\[9\]\[20\] _3476_ _4031_ VGND VGND VPWR VPWR _4032_ sky130_fd_sc_hd__mux2_1
X_4343_ registers\[0\]\[4\] registers\[1\]\[4\] registers\[2\]\[4\] registers\[3\]\[4\]
+ _1136_ _1137_ VGND VGND VPWR VPWR _1139_ sky130_fd_sc_hd__mux4_1
XANTENNA__8097__S _3984_ VGND VGND VPWR VPWR sky130_fd_sc_hd__diode_2
XPHY_EDGE_ROW_99_Right_99 VGND VGND VPWR VPWR sky130_fd_sc_hd__decap_3
XFILLER_0_68_7 VGND VGND VPWR VPWR sky130_fd_sc_hd__fill_2
X_7131_ _3467_ VGND VGND VPWR VPWR _0008_ sky130_fd_sc_hd__clkbuf_1
XANTENNA__5514__S _1072_ VGND VGND VPWR VPWR sky130_fd_sc_hd__diode_2
X_4274_ _1072_ VGND VGND VPWR VPWR net124 sky130_fd_sc_hd__clkbuf_4
X_7062_ _3423_ VGND VGND VPWR VPWR _1007_ sky130_fd_sc_hd__clkbuf_1
X_6013_ _2490_ _2607_ VGND VGND VPWR VPWR _2731_ sky130_fd_sc_hd__or2_1
XANTENNA_clkbuf_leaf_105_clk_A clknet_4_2_0_clk VGND VGND VPWR VPWR sky130_fd_sc_hd__diode_2
XFILLER_0_118_83 VGND VGND VPWR VPWR sky130_fd_sc_hd__fill_1
XFILLER_0_27_81 VGND VGND VPWR VPWR sky130_fd_sc_hd__decap_3
X_7964_ _3917_ VGND VGND VPWR VPWR _0391_ sky130_fd_sc_hd__clkbuf_1
Xclkbuf_leaf_19_clk clknet_4_4_0_clk VGND VGND VPWR VPWR clknet_leaf_19_clk sky130_fd_sc_hd__clkbuf_8
XANTENNA__4654__A _1321_ VGND VGND VPWR VPWR sky130_fd_sc_hd__diode_2
XANTENNA__6345__S _3004_ VGND VGND VPWR VPWR sky130_fd_sc_hd__diode_2
XANTENNA__5469__B _1302_ VGND VGND VPWR VPWR sky130_fd_sc_hd__diode_2
X_6915_ _3344_ VGND VGND VPWR VPWR _0939_ sky130_fd_sc_hd__clkbuf_1
XFILLER_0_11_3 VGND VGND VPWR VPWR sky130_fd_sc_hd__decap_3
X_7895_ _3098_ registers\[27\]\[14\] _3876_ VGND VGND VPWR VPWR _3881_ sky130_fd_sc_hd__mux2_1
XTAP_TAPCELL_ROW_85_1361 VGND VPWR sky130_fd_sc_hd__tapvpwrvgnd_1
XTAP_TAPCELL_ROW_53_948 VGND VPWR sky130_fd_sc_hd__tapvpwrvgnd_1
XANTENNA__6255__C_N net13 VGND VGND VPWR VPWR sky130_fd_sc_hd__diode_2
XFILLER_0_77_677 VPWR VGND VPWR VGND sky130_ef_sc_hd__decap_12
XFILLER_0_76_154 VGND VGND VPWR VPWR sky130_fd_sc_hd__fill_2
X_6846_ registers\[12\]\[18\] _2999_ _3299_ VGND VGND VPWR VPWR _3308_ sky130_fd_sc_hd__mux2_1
X_6777_ _3270_ VGND VGND VPWR VPWR _0875_ sky130_fd_sc_hd__clkbuf_1
X_9565_ clknet_leaf_107_clk _0662_ VGND VGND VPWR VPWR registers\[4\]\[29\] sky130_fd_sc_hd__dfxtp_1
X_5728_ _2344_ VGND VGND VPWR VPWR _2460_ sky130_fd_sc_hd__clkbuf_4
X_8516_ _4209_ VGND VGND VPWR VPWR _0651_ sky130_fd_sc_hd__clkbuf_1
XANTENNA__5291__S1 _1811_ VGND VGND VPWR VPWR sky130_fd_sc_hd__diode_2
XANTENNA__7176__S _3434_ VGND VGND VPWR VPWR sky130_fd_sc_hd__diode_2
XTAP_TAPCELL_ROW_33_683 VGND VPWR sky130_fd_sc_hd__tapvpwrvgnd_1
XTAP_TAPCELL_ROW_33_694 VGND VPWR sky130_fd_sc_hd__tapvpwrvgnd_1
XFILLER_0_60_533 VGND VGND VPWR VPWR sky130_fd_sc_hd__fill_2
XFILLER_0_60_500 VGND VGND VPWR VPWR sky130_fd_sc_hd__fill_2
X_9496_ clknet_leaf_88_clk _0593_ VGND VGND VPWR VPWR registers\[5\]\[24\] sky130_fd_sc_hd__dfxtp_1
XFILLER_0_17_298 VGND VGND VPWR VPWR sky130_fd_sc_hd__fill_2
XFILLER_0_32_224 VGND VGND VPWR VPWR sky130_fd_sc_hd__fill_2
XFILLER_0_33_725 VGND VGND VPWR VPWR sky130_fd_sc_hd__fill_1
XFILLER_0_103_613 VGND VGND VPWR VPWR sky130_fd_sc_hd__decap_3
X_5659_ net15 _2197_ VGND VGND VPWR VPWR _2394_ sky130_fd_sc_hd__nor2_4
X_8447_ registers\[8\]\[18\] net25 _4164_ VGND VGND VPWR VPWR _4173_ sky130_fd_sc_hd__mux2_1
XFILLER_0_5_671 VGND VGND VPWR VPWR sky130_fd_sc_hd__fill_1
XFILLER_0_115_495 VGND VGND VPWR VPWR sky130_fd_sc_hd__fill_1
XFILLER_0_103_657 VGND VGND VPWR VPWR sky130_fd_sc_hd__fill_2
X_8378_ _4136_ VGND VGND VPWR VPWR _0586_ sky130_fd_sc_hd__clkbuf_1
XANTENNA__5043__S1 _1799_ VGND VGND VPWR VPWR sky130_fd_sc_hd__diode_2
XFILLER_0_60_577 VGND VGND VPWR VPWR sky130_fd_sc_hd__decap_8
XFILLER_0_4_192 VGND VGND VPWR VPWR sky130_fd_sc_hd__fill_2
XFILLER_0_4_181 VGND VGND VPWR VPWR sky130_fd_sc_hd__fill_1
X_7329_ _3580_ VGND VGND VPWR VPWR _0093_ sky130_fd_sc_hd__clkbuf_1
XTAP_TAPCELL_ROW_5_320 VGND VPWR sky130_fd_sc_hd__tapvpwrvgnd_1
Xclkbuf_4_13_0_clk clknet_0_clk VGND VGND VPWR VPWR clknet_4_13_0_clk sky130_fd_sc_hd__clkbuf_8
XANTENNA__5959__B1 _2515_ VGND VGND VPWR VPWR sky130_fd_sc_hd__diode_2
XANTENNA__4564__A _1324_ VGND VGND VPWR VPWR sky130_fd_sc_hd__diode_2
XANTENNA__4306__S0 _1039_ VGND VGND VPWR VPWR sky130_fd_sc_hd__diode_2
XANTENNA__8070__A0 _2958_ VGND VGND VPWR VPWR sky130_fd_sc_hd__diode_2
XANTENNA__8373__A1 _3466_ VGND VGND VPWR VPWR sky130_fd_sc_hd__diode_2
XANTENNA__8470__S _4175_ VGND VGND VPWR VPWR sky130_fd_sc_hd__diode_2
XFILLER_0_83_636 VGND VGND VPWR VPWR sky130_fd_sc_hd__decap_3
XFILLER_0_82_124 VGND VGND VPWR VPWR sky130_fd_sc_hd__fill_2
XANTENNA__5282__S1 _2028_ VGND VGND VPWR VPWR sky130_fd_sc_hd__diode_2
XFILLER_0_106_440 VGND VGND VPWR VPWR sky130_fd_sc_hd__fill_2
XFILLER_0_91_691 VGND VGND VPWR VPWR sky130_fd_sc_hd__fill_1
XFILLER_0_106_473 VGND VGND VPWR VPWR sky130_fd_sc_hd__decap_3
XFILLER_0_106_462 VGND VGND VPWR VPWR sky130_fd_sc_hd__decap_8
XANTENNA__7814__S _3829_ VGND VGND VPWR VPWR sky130_fd_sc_hd__diode_2
XTAP_TAPCELL_ROW_11_399 VGND VPWR sky130_fd_sc_hd__tapvpwrvgnd_1
XANTENNA__6687__A1 _2978_ VGND VGND VPWR VPWR sky130_fd_sc_hd__diode_2
XANTENNA__7884__A0 _3087_ VGND VGND VPWR VPWR sky130_fd_sc_hd__diode_2
XFILLER_0_23_268 VGND VGND VPWR VPWR sky130_fd_sc_hd__fill_2
XANTENNA__5842__B _2317_ VGND VGND VPWR VPWR sky130_fd_sc_hd__diode_2
XANTENNA__4793__S0 _1550_ VGND VGND VPWR VPWR sky130_fd_sc_hd__diode_2
XFILLER_0_31_290 VGND VGND VPWR VPWR sky130_fd_sc_hd__fill_1
XFILLER_0_64_24 VGND VGND VPWR VPWR sky130_fd_sc_hd__fill_2
XANTENNA__4474__A _1131_ VGND VGND VPWR VPWR sky130_fd_sc_hd__diode_2
XTAP_TAPCELL_ROW_108_1659 VGND VPWR sky130_fd_sc_hd__tapvpwrvgnd_1
X_4961_ _1677_ _1713_ _1718_ _1724_ VGND VGND VPWR VPWR _1725_ sky130_fd_sc_hd__a2bb2o_4
XFILLER_0_86_441 VGND VGND VPWR VPWR sky130_fd_sc_hd__fill_1
XFILLER_0_59_666 VGND VGND VPWR VPWR sky130_fd_sc_hd__fill_2
XFILLER_0_59_655 VGND VGND VPWR VPWR sky130_fd_sc_hd__fill_2
X_6700_ registers\[10\]\[14\] _2991_ _3225_ VGND VGND VPWR VPWR _3230_ sky130_fd_sc_hd__mux2_1
XFILLER_0_86_463 VGND VGND VPWR VPWR sky130_fd_sc_hd__fill_2
XFILLER_0_80_56 VGND VGND VPWR VPWR sky130_fd_sc_hd__fill_2
X_4892_ _1655_ _1658_ net5 VGND VGND VPWR VPWR _1659_ sky130_fd_sc_hd__a21oi_1
XTAP_TAPCELL_ROW_50_907 VGND VPWR sky130_fd_sc_hd__tapvpwrvgnd_1
XFILLER_0_46_305 VGND VGND VPWR VPWR sky130_fd_sc_hd__decap_3
X_7680_ registers\[24\]\[9\] _3453_ _3757_ VGND VGND VPWR VPWR _3767_ sky130_fd_sc_hd__mux2_1
XFILLER_0_117_727 VGND VGND VPWR VPWR sky130_fd_sc_hd__fill_1
XFILLER_0_104_63 VGND VGND VPWR VPWR sky130_fd_sc_hd__fill_1
XFILLER_0_86_496 VGND VGND VPWR VPWR sky130_fd_sc_hd__fill_2
X_6631_ registers\[0\]\[15\] _2993_ _3186_ VGND VGND VPWR VPWR _3192_ sky130_fd_sc_hd__mux2_1
XFILLER_0_74_636 VGND VGND VPWR VPWR sky130_fd_sc_hd__fill_2
XFILLER_0_73_113 VGND VGND VPWR VPWR sky130_fd_sc_hd__fill_1
XFILLER_0_73_124 VGND VGND VPWR VPWR sky130_fd_sc_hd__decap_3
XFILLER_0_13_50 VGND VGND VPWR VPWR sky130_fd_sc_hd__decap_3
XFILLER_0_116_215 VGND VGND VPWR VPWR sky130_fd_sc_hd__decap_4
XFILLER_0_104_85 VGND VGND VPWR VPWR sky130_fd_sc_hd__decap_3
X_9350_ clknet_leaf_33_clk _0447_ VGND VGND VPWR VPWR registers\[30\]\[6\] sky130_fd_sc_hd__dfxtp_1
XANTENNA__4413__S _1148_ VGND VGND VPWR VPWR sky130_fd_sc_hd__diode_2
XFILLER_0_73_146 VGND VGND VPWR VPWR sky130_fd_sc_hd__fill_2
X_8301_ _2989_ registers\[31\]\[13\] _4092_ VGND VGND VPWR VPWR _4096_ sky130_fd_sc_hd__mux2_1
X_6562_ _3154_ VGND VGND VPWR VPWR _0776_ sky130_fd_sc_hd__clkbuf_1
XTAP_TAPCELL_ROW_30_653 VGND VPWR sky130_fd_sc_hd__tapvpwrvgnd_1
X_5513_ _2246_ _2248_ VGND VGND VPWR VPWR _2249_ sky130_fd_sc_hd__nand2_1
XFILLER_0_42_533 VGND VGND VPWR VPWR sky130_fd_sc_hd__fill_2
X_9281_ clknet_leaf_110_clk _0378_ VGND VGND VPWR VPWR registers\[28\]\[1\] sky130_fd_sc_hd__dfxtp_1
X_6493_ _3112_ VGND VGND VPWR VPWR _0749_ sky130_fd_sc_hd__clkbuf_1
XANTENNA__7724__S _3756_ VGND VGND VPWR VPWR sky130_fd_sc_hd__diode_2
XFILLER_0_112_421 VGND VGND VPWR VPWR sky130_fd_sc_hd__decap_3
X_8232_ _4059_ VGND VGND VPWR VPWR _0517_ sky130_fd_sc_hd__clkbuf_1
Xclkbuf_leaf_8_clk clknet_4_3_0_clk VGND VGND VPWR VPWR clknet_leaf_8_clk sky130_fd_sc_hd__clkbuf_8
X_5444_ _1977_ _2173_ _2181_ VGND VGND VPWR VPWR _2182_ sky130_fd_sc_hd__a21oi_4
XFILLER_0_42_577 VGND VGND VPWR VPWR sky130_fd_sc_hd__fill_2
XFILLER_0_14_268 VGND VGND VPWR VPWR sky130_fd_sc_hd__decap_4
XFILLER_0_112_465 VGND VGND VPWR VPWR sky130_fd_sc_hd__fill_2
X_8163_ registers\[9\]\[12\] _3460_ _4020_ VGND VGND VPWR VPWR _4023_ sky130_fd_sc_hd__mux2_1
XANTENNA__5244__S _1631_ VGND VGND VPWR VPWR sky130_fd_sc_hd__diode_2
XFILLER_0_59_3 VGND VGND VPWR VPWR sky130_fd_sc_hd__fill_2
X_7114_ _3434_ VGND VGND VPWR VPWR _3456_ sky130_fd_sc_hd__clkbuf_8
XFILLER_0_10_463 VGND VGND VPWR VPWR sky130_fd_sc_hd__fill_2
X_5375_ _2111_ _2113_ _2116_ _2026_ _1960_ VGND VGND VPWR VPWR _2117_ sky130_fd_sc_hd__o221a_1
X_8094_ _3986_ VGND VGND VPWR VPWR _0452_ sky130_fd_sc_hd__clkbuf_1
X_4326_ _1034_ VGND VGND VPWR VPWR _1122_ sky130_fd_sc_hd__clkbuf_8
X_7045_ _3414_ VGND VGND VPWR VPWR _0999_ sky130_fd_sc_hd__clkbuf_1
X_4257_ registers\[28\]\[1\] registers\[29\]\[1\] registers\[30\]\[1\] registers\[31\]\[1\]
+ _1053_ _1054_ VGND VGND VPWR VPWR _1056_ sky130_fd_sc_hd__mux4_1
X_8996_ clknet_leaf_30_clk _0093_ VGND VGND VPWR VPWR registers\[1\]\[4\] sky130_fd_sc_hd__dfxtp_1
XANTENNA__6602__A1 _2964_ VGND VGND VPWR VPWR sky130_fd_sc_hd__diode_2
XTAP_TAPCELL_ROW_38_753 VGND VPWR sky130_fd_sc_hd__tapvpwrvgnd_1
XANTENNA__4839__S1 _1383_ VGND VGND VPWR VPWR sky130_fd_sc_hd__diode_2
X_7947_ _3908_ VGND VGND VPWR VPWR _0383_ sky130_fd_sc_hd__clkbuf_1
XANTENNA__4613__B1 _1143_ VGND VGND VPWR VPWR sky130_fd_sc_hd__diode_2
XFILLER_0_49_121 VGND VGND VPWR VPWR sky130_fd_sc_hd__fill_2
XFILLER_0_49_110 VGND VGND VPWR VPWR sky130_fd_sc_hd__fill_2
X_7878_ _3081_ registers\[27\]\[6\] _3865_ VGND VGND VPWR VPWR _3872_ sky130_fd_sc_hd__mux2_1
XANTENNA__8290__S _4081_ VGND VGND VPWR VPWR sky130_fd_sc_hd__diode_2
XFILLER_0_108_716 VPWR VGND VPWR VGND sky130_ef_sc_hd__decap_12
X_6829_ _3287_ VGND VGND VPWR VPWR _3299_ sky130_fd_sc_hd__clkbuf_8
XFILLER_0_107_215 VGND VGND VPWR VPWR sky130_fd_sc_hd__decap_3
XFILLER_0_92_477 VGND VGND VPWR VPWR sky130_fd_sc_hd__fill_2
XFILLER_0_80_617 VGND VGND VPWR VPWR sky130_fd_sc_hd__decap_4
XFILLER_0_9_273 VGND VGND VPWR VPWR sky130_fd_sc_hd__fill_2
XFILLER_0_9_262 VGND VGND VPWR VPWR sky130_fd_sc_hd__decap_4
XANTENNA__5419__S _2081_ VGND VGND VPWR VPWR sky130_fd_sc_hd__diode_2
XFILLER_0_18_541 VGND VGND VPWR VPWR sky130_fd_sc_hd__fill_2
XFILLER_0_18_552 VGND VGND VPWR VPWR sky130_fd_sc_hd__fill_2
XTAP_TAPCELL_ROW_98_1530 VGND VPWR sky130_fd_sc_hd__tapvpwrvgnd_1
X_9548_ clknet_leaf_43_clk _0645_ VGND VGND VPWR VPWR registers\[4\]\[12\] sky130_fd_sc_hd__dfxtp_1
XFILLER_0_73_680 VGND VGND VPWR VPWR sky130_fd_sc_hd__fill_2
X_9479_ clknet_leaf_33_clk _0576_ VGND VGND VPWR VPWR registers\[5\]\[7\] sky130_fd_sc_hd__dfxtp_1
XFILLER_0_60_330 VGND VGND VPWR VPWR sky130_fd_sc_hd__fill_2
XANTENNA__6118__B1 net96 VGND VGND VPWR VPWR sky130_fd_sc_hd__diode_2
XFILLER_0_45_393 VGND VGND VPWR VPWR sky130_fd_sc_hd__fill_2
XFILLER_0_5_490 VGND VGND VPWR VPWR sky130_fd_sc_hd__fill_2
XANTENNA__7866__A0 _3065_ VGND VGND VPWR VPWR sky130_fd_sc_hd__diode_2
XFILLER_0_20_205 VGND VGND VPWR VPWR sky130_fd_sc_hd__fill_2
XFILLER_0_60_385 VGND VGND VPWR VPWR sky130_fd_sc_hd__fill_1
XFILLER_0_20_227 VGND VGND VPWR VPWR sky130_fd_sc_hd__fill_1
XFILLER_0_20_249 VGND VGND VPWR VPWR sky130_fd_sc_hd__decap_3
XFILLER_0_33_599 VGND VGND VPWR VPWR sky130_fd_sc_hd__fill_2
XANTENNA__4993__S _1754_ VGND VGND VPWR VPWR sky130_fd_sc_hd__diode_2
XFILLER_0_88_728 VGND VGND VPWR VPWR sky130_fd_sc_hd__fill_2
XANTENNA__6713__S _3236_ VGND VGND VPWR VPWR sky130_fd_sc_hd__diode_2
XFILLER_0_68_485 VGND VGND VPWR VPWR sky130_fd_sc_hd__fill_2
XTAP_TAPCELL_ROW_16_469 VGND VPWR sky130_fd_sc_hd__tapvpwrvgnd_1
XANTENNA__8346__A1 _3439_ VGND VGND VPWR VPWR sky130_fd_sc_hd__diode_2
XFILLER_0_71_617 VGND VGND VPWR VPWR sky130_fd_sc_hd__fill_2
XFILLER_0_55_157 VGND VGND VPWR VPWR sky130_fd_sc_hd__fill_2
XFILLER_0_50_26 VGND VGND VPWR VPWR sky130_fd_sc_hd__fill_2
XANTENNA__5255__S1 _1969_ VGND VGND VPWR VPWR sky130_fd_sc_hd__diode_2
XFILLER_0_24_511 VGND VGND VPWR VPWR sky130_fd_sc_hd__fill_2
XFILLER_0_24_533 VGND VGND VPWR VPWR sky130_fd_sc_hd__fill_2
XFILLER_0_36_382 VGND VGND VPWR VPWR sky130_fd_sc_hd__fill_1
XTAP_TAPCELL_ROW_58_1013 VGND VPWR sky130_fd_sc_hd__tapvpwrvgnd_1
XFILLER_0_3_449 VGND VGND VPWR VPWR sky130_fd_sc_hd__decap_3
XFILLER_0_59_57 VGND VGND VPWR VPWR sky130_fd_sc_hd__fill_2
XFILLER_0_51_396 VGND VGND VPWR VPWR sky130_fd_sc_hd__decap_8
XANTENNA__7609__A0 _3085_ VGND VGND VPWR VPWR sky130_fd_sc_hd__diode_2
X_5160_ _1913_ VGND VGND VPWR VPWR net86 sky130_fd_sc_hd__inv_2
XANTENNA__4518__S0 _1198_ VGND VGND VPWR VPWR sky130_fd_sc_hd__diode_2
X_5091_ _1847_ _1848_ _1746_ VGND VGND VPWR VPWR _1849_ sky130_fd_sc_hd__mux2_1
XANTENNA__8375__S _4128_ VGND VGND VPWR VPWR sky130_fd_sc_hd__diode_2
XANTENNA__6832__A1 _2985_ VGND VGND VPWR VPWR sky130_fd_sc_hd__diode_2
XTAP_TAPCELL_ROW_69_1153 VGND VPWR sky130_fd_sc_hd__tapvpwrvgnd_1
X_8850_ clknet_leaf_68_clk _0971_ VGND VGND VPWR VPWR registers\[14\]\[18\] sky130_fd_sc_hd__dfxtp_1
X_8781_ clknet_leaf_57_clk _0902_ VGND VGND VPWR VPWR registers\[12\]\[13\] sky130_fd_sc_hd__dfxtp_1
X_5993_ _2711_ _2712_ VGND VGND VPWR VPWR _2713_ sky130_fd_sc_hd__nor2_1
X_7801_ _3831_ VGND VGND VPWR VPWR _0314_ sky130_fd_sc_hd__clkbuf_1
XTAP_TAPCELL_ROW_35_712 VGND VPWR sky130_fd_sc_hd__tapvpwrvgnd_1
XANTENNA__6623__S _3186_ VGND VGND VPWR VPWR sky130_fd_sc_hd__diode_2
X_4944_ registers\[16\]\[4\] registers\[17\]\[4\] registers\[18\]\[4\] registers\[19\]\[4\]
+ _1705_ _1706_ VGND VGND VPWR VPWR _1708_ sky130_fd_sc_hd__mux4_1
XFILLER_0_93_219 VGND VGND VPWR VPWR sky130_fd_sc_hd__fill_2
XTAP_TAPCELL_ROW_82_1331 VGND VPWR sky130_fd_sc_hd__tapvpwrvgnd_1
XTAP_TAPCELL_ROW_82_1320 VGND VPWR sky130_fd_sc_hd__tapvpwrvgnd_1
X_7732_ _3071_ registers\[25\]\[1\] _3793_ VGND VGND VPWR VPWR _3795_ sky130_fd_sc_hd__mux2_1
XFILLER_0_117_502 VGND VGND VPWR VPWR sky130_fd_sc_hd__fill_2
XANTENNA__4961__A1_N _1677_ VGND VGND VPWR VPWR sky130_fd_sc_hd__diode_2
XFILLER_0_24_71 VGND VGND VPWR VPWR sky130_fd_sc_hd__fill_2
XFILLER_0_46_157 VGND VGND VPWR VPWR sky130_fd_sc_hd__decap_4
X_4875_ net1 VGND VGND VPWR VPWR _1642_ sky130_fd_sc_hd__buf_4
X_7663_ _3758_ VGND VGND VPWR VPWR _0249_ sky130_fd_sc_hd__clkbuf_1
X_9402_ clknet_leaf_90_clk _0499_ VGND VGND VPWR VPWR registers\[9\]\[26\] sky130_fd_sc_hd__dfxtp_1
X_6614_ registers\[0\]\[7\] _2976_ _3175_ VGND VGND VPWR VPWR _3183_ sky130_fd_sc_hd__mux2_1
XFILLER_0_74_477 VGND VGND VPWR VPWR sky130_fd_sc_hd__fill_2
XFILLER_0_61_127 VGND VGND VPWR VPWR sky130_fd_sc_hd__decap_3
XFILLER_0_6_232 VGND VGND VPWR VPWR sky130_fd_sc_hd__fill_2
X_7594_ _3721_ VGND VGND VPWR VPWR _0217_ sky130_fd_sc_hd__clkbuf_1
XFILLER_0_15_500 VGND VGND VPWR VPWR sky130_fd_sc_hd__fill_1
X_6545_ _3145_ VGND VGND VPWR VPWR _0768_ sky130_fd_sc_hd__clkbuf_1
XFILLER_0_40_81 VGND VGND VPWR VPWR sky130_fd_sc_hd__decap_3
X_9333_ clknet_leaf_85_clk _0430_ VGND VGND VPWR VPWR registers\[2\]\[21\] sky130_fd_sc_hd__dfxtp_1
XFILLER_0_27_393 VPWR VGND VPWR VGND sky130_ef_sc_hd__decap_12
X_9264_ clknet_leaf_62_clk _0361_ VGND VGND VPWR VPWR registers\[27\]\[16\] sky130_fd_sc_hd__dfxtp_1
XFILLER_0_42_363 VGND VGND VPWR VPWR sky130_fd_sc_hd__fill_1
X_8215_ _4050_ VGND VGND VPWR VPWR _0509_ sky130_fd_sc_hd__clkbuf_1
X_6476_ _3100_ registers\[29\]\[15\] _3090_ VGND VGND VPWR VPWR _3101_ sky130_fd_sc_hd__mux2_1
X_9195_ clknet_leaf_59_clk _0292_ VGND VGND VPWR VPWR registers\[25\]\[11\] sky130_fd_sc_hd__dfxtp_1
XFILLER_0_112_262 VGND VGND VPWR VPWR sky130_fd_sc_hd__fill_2
XFILLER_0_100_402 VGND VGND VPWR VPWR sky130_fd_sc_hd__fill_2
X_5427_ _2164_ _2165_ _2081_ VGND VGND VPWR VPWR _2166_ sky130_fd_sc_hd__mux2_1
XFILLER_0_30_558 VGND VGND VPWR VPWR sky130_fd_sc_hd__decap_4
X_8146_ registers\[9\]\[4\] _3443_ _4009_ VGND VGND VPWR VPWR _4014_ sky130_fd_sc_hd__mux2_1
XTAP_TAPCELL_ROW_93_1471 VGND VPWR sky130_fd_sc_hd__tapvpwrvgnd_1
X_5358_ _1977_ _2091_ _2100_ VGND VGND VPWR VPWR _2101_ sky130_fd_sc_hd__a21oi_4
X_4309_ _1052_ _1097_ _1105_ VGND VGND VPWR VPWR _1106_ sky130_fd_sc_hd__o21ai_4
X_8077_ _3977_ VGND VGND VPWR VPWR _0444_ sky130_fd_sc_hd__clkbuf_1
X_7028_ _3405_ VGND VGND VPWR VPWR _0991_ sky130_fd_sc_hd__clkbuf_1
XANTENNA__6823__A1 _2976_ VGND VGND VPWR VPWR sky130_fd_sc_hd__diode_2
X_5289_ registers\[24\]\[22\] registers\[25\]\[22\] registers\[26\]\[22\] registers\[27\]\[22\]
+ _1810_ _1811_ VGND VGND VPWR VPWR _2035_ sky130_fd_sc_hd__mux4_1
XANTENNA__5182__S0 _1809_ VGND VGND VPWR VPWR sky130_fd_sc_hd__diode_2
XFILLER_0_97_503 VGND VGND VPWR VPWR sky130_fd_sc_hd__fill_1
XFILLER_0_69_205 VGND VGND VPWR VPWR sky130_fd_sc_hd__fill_2
XANTENNA__5003__A _1764_ VGND VGND VPWR VPWR sky130_fd_sc_hd__diode_2
X_8979_ clknet_leaf_45_clk _0076_ VGND VGND VPWR VPWR registers\[18\]\[19\] sky130_fd_sc_hd__dfxtp_1
XFILLER_0_37_113 VGND VGND VPWR VPWR sky130_fd_sc_hd__decap_3
XTAP_TAPCELL_ROW_13_428 VGND VPWR sky130_fd_sc_hd__tapvpwrvgnd_1
XFILLER_0_108_557 VGND VGND VPWR VPWR sky130_fd_sc_hd__decap_6
XFILLER_0_53_617 VGND VGND VPWR VPWR sky130_fd_sc_hd__fill_2
XFILLER_0_25_308 VGND VGND VPWR VPWR sky130_fd_sc_hd__fill_1
XFILLER_0_46_691 VGND VGND VPWR VPWR sky130_fd_sc_hd__fill_2
XANTENNA__7364__S _3597_ VGND VGND VPWR VPWR sky130_fd_sc_hd__diode_2
XFILLER_0_21_536 VGND VGND VPWR VPWR sky130_fd_sc_hd__fill_2
XFILLER_0_103_262 VGND VGND VPWR VPWR sky130_fd_sc_hd__fill_2
XANTENNA__5314__A1 _1689_ VGND VGND VPWR VPWR sky130_fd_sc_hd__diode_2
XANTENNA__4748__S0 _1415_ VGND VGND VPWR VPWR sky130_fd_sc_hd__diode_2
XFILLER_0_29_49 VGND VGND VPWR VPWR sky130_fd_sc_hd__decap_4
XANTENNA__6708__S _3225_ VGND VGND VPWR VPWR sky130_fd_sc_hd__diode_2
XANTENNA__5173__S0 _1810_ VGND VGND VPWR VPWR sky130_fd_sc_hd__diode_2
XPHY_EDGE_ROW_100_Left_220 VGND VGND VPWR VPWR sky130_fd_sc_hd__decap_3
XANTENNA__4920__S0 _1678_ VGND VGND VPWR VPWR sky130_fd_sc_hd__diode_2
XTAP_TAPCELL_ROW_105_1629 VGND VPWR sky130_fd_sc_hd__tapvpwrvgnd_1
XTAP_TAPCELL_ROW_105_1618 VGND VPWR sky130_fd_sc_hd__tapvpwrvgnd_1
XFILLER_0_88_569 VGND VGND VPWR VPWR sky130_fd_sc_hd__fill_1
XANTENNA_clkload8_A clknet_4_9_0_clk VGND VGND VPWR VPWR sky130_fd_sc_hd__diode_2
XANTENNA__7539__S _3684_ VGND VGND VPWR VPWR sky130_fd_sc_hd__diode_2
XTAP_TAPCELL_ROW_64_1094 VGND VPWR sky130_fd_sc_hd__tapvpwrvgnd_1
XFILLER_0_56_466 VGND VGND VPWR VPWR sky130_fd_sc_hd__decap_3
XFILLER_0_28_135 VGND VGND VPWR VPWR sky130_fd_sc_hd__fill_2
XFILLER_0_43_105 VGND VGND VPWR VPWR sky130_fd_sc_hd__fill_2
X_4660_ _1372_ _1426_ _1432_ _1439_ VGND VGND VPWR VPWR _1440_ sky130_fd_sc_hd__a2bb2o_2
XFILLER_0_117_3 VPWR VGND VPWR VGND sky130_ef_sc_hd__decap_12
XFILLER_0_114_516 VGND VGND VPWR VPWR sky130_fd_sc_hd__decap_3
XFILLER_0_114_505 VGND VGND VPWR VPWR sky130_fd_sc_hd__decap_4
XANTENNA__5553__A1 _2267_ VGND VGND VPWR VPWR sky130_fd_sc_hd__diode_2
XTAP_TAPCELL_ROW_40_781 VGND VPWR sky130_fd_sc_hd__tapvpwrvgnd_1
X_4591_ registers\[20\]\[18\] registers\[21\]\[18\] registers\[22\]\[18\] registers\[23\]\[18\]
+ _1338_ _1339_ VGND VGND VPWR VPWR _1373_ sky130_fd_sc_hd__mux4_1
X_6330_ registers\[19\]\[23\] _3010_ _3004_ VGND VGND VPWR VPWR _3011_ sky130_fd_sc_hd__mux2_1
XFILLER_0_24_363 VGND VGND VPWR VPWR sky130_fd_sc_hd__fill_1
XFILLER_0_101_75 VGND VGND VPWR VPWR sky130_fd_sc_hd__fill_2
XTAP_TAPCELL_ROW_116_1769 VGND VPWR sky130_fd_sc_hd__tapvpwrvgnd_1
X_6261_ net27 VGND VGND VPWR VPWR _2964_ sky130_fd_sc_hd__clkbuf_4
XANTENNA__4739__S0 _1404_ VGND VGND VPWR VPWR sky130_fd_sc_hd__diode_2
X_6192_ _2262_ _2894_ _2895_ _2899_ _2420_ VGND VGND VPWR VPWR _2900_ sky130_fd_sc_hd__o221a_1
X_5212_ registers\[16\]\[18\] registers\[17\]\[18\] registers\[18\]\[18\] registers\[19\]\[18\]
+ _1820_ _1821_ VGND VGND VPWR VPWR _1962_ sky130_fd_sc_hd__mux4_1
X_8000_ _3028_ _3212_ VGND VGND VPWR VPWR _3936_ sky130_fd_sc_hd__nor2_2
XANTENNA__5400__S1 _2109_ VGND VGND VPWR VPWR sky130_fd_sc_hd__diode_2
X_5143_ _1771_ _1897_ _1778_ VGND VGND VPWR VPWR _1898_ sky130_fd_sc_hd__a21oi_1
XANTENNA__6618__S _3175_ VGND VGND VPWR VPWR sky130_fd_sc_hd__diode_2
XANTENNA__4927__A _1691_ VGND VGND VPWR VPWR sky130_fd_sc_hd__diode_2
XANTENNA__5164__S0 _1806_ VGND VGND VPWR VPWR sky130_fd_sc_hd__diode_2
X_5074_ _1831_ _1832_ _1689_ VGND VGND VPWR VPWR _1833_ sky130_fd_sc_hd__mux2_1
X_8902_ clknet_leaf_41_clk _1023_ VGND VGND VPWR VPWR registers\[16\]\[6\] sky130_fd_sc_hd__dfxtp_1
XFILLER_0_79_503 VGND VGND VPWR VPWR sky130_fd_sc_hd__fill_1
XFILLER_0_79_558 VGND VGND VPWR VPWR sky130_fd_sc_hd__fill_2
XTAP_TAPCELL_ROW_48_881 VGND VPWR sky130_fd_sc_hd__tapvpwrvgnd_1
X_8833_ clknet_leaf_5_clk _0954_ VGND VGND VPWR VPWR registers\[14\]\[1\] sky130_fd_sc_hd__dfxtp_1
XANTENNA__7449__S _3634_ VGND VGND VPWR VPWR sky130_fd_sc_hd__diode_2
XFILLER_0_35_81 VGND VGND VPWR VPWR sky130_fd_sc_hd__fill_2
X_5976_ _2321_ _2694_ _2695_ _2328_ VGND VGND VPWR VPWR _2696_ sky130_fd_sc_hd__a31o_1
XANTENNA__5241__B1 _1655_ VGND VGND VPWR VPWR sky130_fd_sc_hd__diode_2
XFILLER_0_59_271 VGND VGND VPWR VPWR sky130_fd_sc_hd__decap_3
X_8764_ clknet_leaf_105_clk _0885_ VGND VGND VPWR VPWR registers\[11\]\[28\] sky130_fd_sc_hd__dfxtp_1
XFILLER_0_19_113 VGND VGND VPWR VPWR sky130_fd_sc_hd__decap_3
X_4927_ _1691_ VGND VGND VPWR VPWR _1692_ sky130_fd_sc_hd__clkbuf_8
XFILLER_0_47_466 VGND VGND VPWR VPWR sky130_fd_sc_hd__decap_3
X_7715_ _3785_ VGND VGND VPWR VPWR _0274_ sky130_fd_sc_hd__clkbuf_1
XFILLER_0_19_157 VGND VGND VPWR VPWR sky130_fd_sc_hd__fill_1
X_8695_ clknet_leaf_69_clk _0816_ VGND VGND VPWR VPWR registers\[0\]\[23\] sky130_fd_sc_hd__dfxtp_1
XFILLER_0_90_701 VPWR VGND VPWR VGND sky130_ef_sc_hd__decap_12
X_7646_ _3748_ VGND VGND VPWR VPWR _0242_ sky130_fd_sc_hd__clkbuf_1
X_4858_ _1622_ _1625_ net4 VGND VGND VPWR VPWR _1626_ sky130_fd_sc_hd__mux2_1
XFILLER_0_35_628 VGND VGND VPWR VPWR sky130_fd_sc_hd__fill_2
XFILLER_0_105_505 VGND VGND VPWR VPWR sky130_fd_sc_hd__fill_2
XANTENNA__5544__A1 _1899_ VGND VGND VPWR VPWR sky130_fd_sc_hd__diode_2
XFILLER_0_51_91 VGND VGND VPWR VPWR sky130_fd_sc_hd__fill_2
XFILLER_0_15_330 VGND VGND VPWR VPWR sky130_fd_sc_hd__decap_3
X_9316_ clknet_leaf_30_clk _0413_ VGND VGND VPWR VPWR registers\[2\]\[4\] sky130_fd_sc_hd__dfxtp_1
XFILLER_0_105_549 VGND VGND VPWR VPWR sky130_fd_sc_hd__fill_2
XTAP_TAPCELL_ROW_95_1500 VGND VPWR sky130_fd_sc_hd__tapvpwrvgnd_1
X_4789_ registers\[8\]\[28\] registers\[9\]\[28\] registers\[10\]\[28\] registers\[11\]\[28\]
+ _1550_ _1551_ VGND VGND VPWR VPWR _1561_ sky130_fd_sc_hd__mux4_1
X_7577_ _3121_ registers\[22\]\[25\] _3706_ VGND VGND VPWR VPWR _3712_ sky130_fd_sc_hd__mux2_1
XANTENNA__7184__S _3503_ VGND VGND VPWR VPWR sky130_fd_sc_hd__diode_2
XFILLER_0_42_171 VGND VGND VPWR VPWR sky130_fd_sc_hd__fill_2
X_6528_ _2960_ _3135_ VGND VGND VPWR VPWR _3136_ sky130_fd_sc_hd__nor2_2
X_6459_ net17 VGND VGND VPWR VPWR _3089_ sky130_fd_sc_hd__clkbuf_2
XFILLER_0_42_193 VGND VGND VPWR VPWR sky130_fd_sc_hd__decap_3
X_9247_ clknet_leaf_107_clk _0344_ VGND VGND VPWR VPWR registers\[26\]\[31\] sky130_fd_sc_hd__dfxtp_1
X_9178_ clknet_leaf_77_clk _0275_ VGND VGND VPWR VPWR registers\[24\]\[26\] sky130_fd_sc_hd__dfxtp_1
XANTENNA__7912__S _3887_ VGND VGND VPWR VPWR sky130_fd_sc_hd__diode_2
X_8129_ _4004_ VGND VGND VPWR VPWR _0469_ sky130_fd_sc_hd__clkbuf_1
XANTENNA__4902__S0 _1642_ VGND VGND VPWR VPWR sky130_fd_sc_hd__diode_2
XANTENNA__7359__S _3586_ VGND VGND VPWR VPWR sky130_fd_sc_hd__diode_2
XANTENNA__7221__A1 _3472_ VGND VGND VPWR VPWR sky130_fd_sc_hd__diode_2
XFILLER_0_66_731 VGND VGND VPWR VPWR sky130_fd_sc_hd__fill_2
XFILLER_0_65_241 VGND VGND VPWR VPWR sky130_fd_sc_hd__fill_2
XFILLER_0_38_455 VGND VGND VPWR VPWR sky130_fd_sc_hd__fill_2
XTAP_TAPCELL_ROW_26_597 VGND VPWR sky130_fd_sc_hd__tapvpwrvgnd_1
XFILLER_0_108_343 VGND VGND VPWR VPWR sky130_fd_sc_hd__fill_2
XTAP_TAPCELL_ROW_100_1559 VGND VPWR sky130_fd_sc_hd__tapvpwrvgnd_1
XFILLER_0_93_561 VPWR VGND VPWR VGND sky130_ef_sc_hd__decap_12
XFILLER_0_38_488 VGND VGND VPWR VPWR sky130_fd_sc_hd__fill_2
XFILLER_0_38_477 VGND VGND VPWR VPWR sky130_fd_sc_hd__fill_1
XFILLER_0_26_639 VGND VGND VPWR VPWR sky130_fd_sc_hd__fill_2
XFILLER_0_108_365 VGND VGND VPWR VPWR sky130_fd_sc_hd__fill_2
XFILLER_0_80_244 VGND VGND VPWR VPWR sky130_fd_sc_hd__decap_6
XFILLER_0_80_222 VGND VGND VPWR VPWR sky130_fd_sc_hd__decap_4
XANTENNA__4969__S0 _1731_ VGND VGND VPWR VPWR sky130_fd_sc_hd__diode_2
XFILLER_0_1_717 VGND VGND VPWR VPWR sky130_fd_sc_hd__decap_8
XFILLER_0_104_593 VGND VGND VPWR VPWR sky130_fd_sc_hd__decap_8
XFILLER_0_21_377 VGND VGND VPWR VPWR sky130_fd_sc_hd__fill_2
XANTENNA__7123__A net20 VGND VGND VPWR VPWR sky130_fd_sc_hd__diode_2
XANTENNA__5146__S0 _1748_ VGND VGND VPWR VPWR sky130_fd_sc_hd__diode_2
XTAP_TAPCELL_ROW_111_1699 VGND VPWR sky130_fd_sc_hd__tapvpwrvgnd_1
XFILLER_0_56_58 VGND VGND VPWR VPWR sky130_fd_sc_hd__decap_3
XANTENNA__8939__CLK clknet_4_15_0_clk VGND VGND VPWR VPWR sky130_fd_sc_hd__diode_2
XFILLER_0_88_300 VGND VGND VPWR VPWR sky130_fd_sc_hd__fill_2
XANTENNA__5578__A _1660_ VGND VGND VPWR VPWR sky130_fd_sc_hd__diode_2
XTAP_TAPCELL_ROW_66_1123 VGND VPWR sky130_fd_sc_hd__tapvpwrvgnd_1
XTAP_TAPCELL_ROW_66_1112 VGND VPWR sky130_fd_sc_hd__tapvpwrvgnd_1
XFILLER_0_76_528 VGND VGND VPWR VPWR sky130_fd_sc_hd__fill_2
X_5830_ _2551_ _2556_ VGND VGND VPWR VPWR _2558_ sky130_fd_sc_hd__nand2_1
XANTENNA__4482__A _1270_ VGND VGND VPWR VPWR sky130_fd_sc_hd__diode_2
XFILLER_0_57_720 VGND VGND VPWR VPWR sky130_fd_sc_hd__decap_3
XTAP_TAPCELL_ROW_45_840 VGND VPWR sky130_fd_sc_hd__tapvpwrvgnd_1
XANTENNA__5449__S1 _2120_ VGND VGND VPWR VPWR sky130_fd_sc_hd__diode_2
XFILLER_0_118_129 VGND VGND VPWR VPWR sky130_fd_sc_hd__decap_8
XANTENNA__5774__A1 _2413_ VGND VGND VPWR VPWR sky130_fd_sc_hd__diode_2
X_5761_ _2490_ _2491_ _2465_ _2384_ VGND VGND VPWR VPWR _2492_ sky130_fd_sc_hd__o2bb2a_1
XFILLER_0_8_305 VGND VGND VPWR VPWR sky130_fd_sc_hd__decap_3
XFILLER_0_72_723 VGND VGND VPWR VPWR sky130_fd_sc_hd__fill_2
XFILLER_0_72_701 VGND VGND VPWR VPWR sky130_fd_sc_hd__decap_4
X_8480_ registers\[4\]\[1\] net27 _4189_ VGND VGND VPWR VPWR _4191_ sky130_fd_sc_hd__mux2_1
X_4712_ registers\[20\]\[24\] registers\[21\]\[24\] registers\[22\]\[24\] registers\[23\]\[24\]
+ _1418_ _1419_ VGND VGND VPWR VPWR _1488_ sky130_fd_sc_hd__mux4_1
XFILLER_0_16_105 VGND VGND VPWR VPWR sky130_fd_sc_hd__fill_2
X_7500_ _3671_ VGND VGND VPWR VPWR _0173_ sky130_fd_sc_hd__clkbuf_1
XFILLER_0_114_302 VGND VGND VPWR VPWR sky130_fd_sc_hd__decap_4
XFILLER_0_98_7 VGND VGND VPWR VPWR sky130_fd_sc_hd__fill_2
X_5692_ _1660_ _2396_ VGND VGND VPWR VPWR _2426_ sky130_fd_sc_hd__or2_1
XFILLER_0_44_436 VGND VGND VPWR VPWR sky130_fd_sc_hd__fill_2
X_7431_ registers\[20\]\[20\] _3476_ _3634_ VGND VGND VPWR VPWR _3635_ sky130_fd_sc_hd__mux2_1
XFILLER_0_112_85 VGND VGND VPWR VPWR sky130_fd_sc_hd__decap_3
XFILLER_0_4_533 VGND VGND VPWR VPWR sky130_fd_sc_hd__fill_2
X_4643_ registers\[28\]\[20\] registers\[29\]\[20\] registers\[30\]\[20\] registers\[31\]\[20\]
+ _1418_ _1419_ VGND VGND VPWR VPWR _1423_ sky130_fd_sc_hd__mux4_1
X_4574_ registers\[24\]\[17\] registers\[25\]\[17\] registers\[26\]\[17\] registers\[27\]\[17\]
+ _1160_ _1161_ VGND VGND VPWR VPWR _1357_ sky130_fd_sc_hd__mux4_1
XANTENNA__6202__A _2152_ VGND VGND VPWR VPWR sky130_fd_sc_hd__diode_2
XFILLER_0_24_160 VGND VGND VPWR VPWR sky130_fd_sc_hd__fill_2
X_7362_ registers\[1\]\[20\] _3476_ _3597_ VGND VGND VPWR VPWR _3598_ sky130_fd_sc_hd__mux2_1
X_9101_ clknet_leaf_56_clk _0198_ VGND VGND VPWR VPWR registers\[22\]\[13\] sky130_fd_sc_hd__dfxtp_1
XANTENNA__7279__A1 _3462_ VGND VGND VPWR VPWR sky130_fd_sc_hd__diode_2
XTAP_TAPCELL_ROW_77_1263 VGND VPWR sky130_fd_sc_hd__tapvpwrvgnd_1
X_6313_ net25 VGND VGND VPWR VPWR _2999_ sky130_fd_sc_hd__clkbuf_2
XFILLER_0_52_491 VGND VGND VPWR VPWR sky130_fd_sc_hd__decap_4
X_7293_ _3538_ VGND VGND VPWR VPWR _3561_ sky130_fd_sc_hd__clkbuf_8
X_9032_ clknet_leaf_12_clk _0129_ VGND VGND VPWR VPWR registers\[20\]\[8\] sky130_fd_sc_hd__dfxtp_1
X_6244_ net137 _2196_ VGND VGND VPWR VPWR _2949_ sky130_fd_sc_hd__xor2_1
XFILLER_0_40_686 VPWR VGND VPWR VGND sky130_ef_sc_hd__decap_12
XFILLER_0_40_675 VGND VGND VPWR VPWR sky130_fd_sc_hd__fill_2
XANTENNA__7732__S _3793_ VGND VGND VPWR VPWR sky130_fd_sc_hd__diode_2
XFILLER_0_12_377 VGND VGND VPWR VPWR sky130_fd_sc_hd__fill_2
XTAP_TAPCELL_ROW_90_1430 VGND VPWR sky130_fd_sc_hd__tapvpwrvgnd_1
X_6175_ net99 _2873_ VGND VGND VPWR VPWR _2884_ sky130_fd_sc_hd__and2_1
XFILLER_0_41_3 VGND VGND VPWR VPWR sky130_fd_sc_hd__decap_4
XANTENNA__6348__S _3004_ VGND VGND VPWR VPWR sky130_fd_sc_hd__diode_2
XANTENNA__5137__S0 _1742_ VGND VGND VPWR VPWR sky130_fd_sc_hd__diode_2
X_5126_ _1741_ _1873_ _1881_ VGND VGND VPWR VPWR _1882_ sky130_fd_sc_hd__o21ai_4
X_5057_ _1815_ _1816_ _1689_ VGND VGND VPWR VPWR _1817_ sky130_fd_sc_hd__mux2_1
XFILLER_0_46_80 VGND VGND VPWR VPWR sky130_fd_sc_hd__fill_2
XANTENNA__4360__S1 _1128_ VGND VGND VPWR VPWR sky130_fd_sc_hd__diode_2
XANTENNA__7179__S _3434_ VGND VGND VPWR VPWR sky130_fd_sc_hd__diode_2
X_8816_ clknet_leaf_64_clk _0937_ VGND VGND VPWR VPWR registers\[13\]\[16\] sky130_fd_sc_hd__dfxtp_1
X_8747_ clknet_leaf_52_clk _0868_ VGND VGND VPWR VPWR registers\[11\]\[11\] sky130_fd_sc_hd__dfxtp_1
XANTENNA__6962__A0 _3085_ VGND VGND VPWR VPWR sky130_fd_sc_hd__diode_2
X_5959_ net118 _2658_ _2659_ _2515_ VGND VGND VPWR VPWR _2680_ sky130_fd_sc_hd__o31a_1
XFILLER_0_1_93 VPWR VGND VPWR VGND sky130_ef_sc_hd__decap_12
XFILLER_0_118_641 VGND VGND VPWR VPWR sky130_fd_sc_hd__decap_3
XFILLER_0_75_561 VGND VGND VPWR VPWR sky130_fd_sc_hd__fill_2
XANTENNA__6811__S _3288_ VGND VGND VPWR VPWR sky130_fd_sc_hd__diode_2
XTAP_TAPCELL_ROW_23_556 VGND VPWR sky130_fd_sc_hd__tapvpwrvgnd_1
X_8678_ clknet_leaf_37_clk _0799_ VGND VGND VPWR VPWR registers\[0\]\[6\] sky130_fd_sc_hd__dfxtp_1
XFILLER_0_90_531 VGND VGND VPWR VPWR sky130_fd_sc_hd__fill_1
XFILLER_0_75_594 VGND VGND VPWR VPWR sky130_fd_sc_hd__fill_2
XFILLER_0_35_436 VGND VGND VPWR VPWR sky130_fd_sc_hd__decap_3
X_7629_ _3739_ VGND VGND VPWR VPWR _0234_ sky130_fd_sc_hd__clkbuf_1
XFILLER_0_7_393 VGND VGND VPWR VPWR sky130_fd_sc_hd__fill_2
XANTENNA__5427__S _2081_ VGND VGND VPWR VPWR sky130_fd_sc_hd__diode_2
XFILLER_0_90_586 VGND VGND VPWR VPWR sky130_fd_sc_hd__fill_2
XANTENNA__6190__A1 _2321_ VGND VGND VPWR VPWR sky130_fd_sc_hd__diode_2
XFILLER_0_15_160 VGND VGND VPWR VPWR sky130_fd_sc_hd__fill_2
XFILLER_0_30_141 VGND VGND VPWR VPWR sky130_fd_sc_hd__decap_3
XFILLER_0_30_174 VGND VGND VPWR VPWR sky130_fd_sc_hd__fill_2
XFILLER_0_101_585 VGND VGND VPWR VPWR sky130_fd_sc_hd__fill_2
XANTENNA__4567__A _1132_ VGND VGND VPWR VPWR sky130_fd_sc_hd__diode_2
XFILLER_0_89_119 VGND VGND VPWR VPWR sky130_fd_sc_hd__fill_2
XANTENNA_input25_A wd3[18] VGND VGND VPWR VPWR sky130_fd_sc_hd__diode_2
XANTENNA__4351__S1 _1113_ VGND VGND VPWR VPWR sky130_fd_sc_hd__diode_2
XTAP_TAPCELL_ROW_3_292 VGND VPWR sky130_fd_sc_hd__tapvpwrvgnd_1
XANTENNA__4506__S _1122_ VGND VGND VPWR VPWR sky130_fd_sc_hd__diode_2
XTAP_TAPCELL_ROW_42_810 VGND VPWR sky130_fd_sc_hd__tapvpwrvgnd_1
XFILLER_0_42_38 VGND VGND VPWR VPWR sky130_fd_sc_hd__fill_2
XFILLER_0_66_583 VGND VGND VPWR VPWR sky130_fd_sc_hd__fill_2
XFILLER_0_54_701 VGND VGND VPWR VPWR sky130_fd_sc_hd__fill_2
XFILLER_0_38_274 VGND VGND VPWR VPWR sky130_fd_sc_hd__fill_2
XANTENNA__6721__S _3236_ VGND VGND VPWR VPWR sky130_fd_sc_hd__diode_2
XTAP_TAPCELL_ROW_61_1053 VGND VPWR sky130_fd_sc_hd__tapvpwrvgnd_1
XFILLER_0_5_319 VGND VGND VPWR VPWR sky130_fd_sc_hd__fill_2
XFILLER_0_109_685 VGND VGND VPWR VPWR sky130_fd_sc_hd__decap_4
XANTENNA__6181__A1 _2270_ VGND VGND VPWR VPWR sky130_fd_sc_hd__diode_2
XFILLER_0_13_108 VGND VGND VPWR VPWR sky130_fd_sc_hd__fill_2
XFILLER_0_111_316 VGND VGND VPWR VPWR sky130_fd_sc_hd__fill_1
XFILLER_0_1_525 VGND VGND VPWR VPWR sky130_fd_sc_hd__fill_1
XFILLER_0_21_130 VGND VGND VPWR VPWR sky130_fd_sc_hd__fill_2
XTAP_TAPCELL_ROW_113_1728 VGND VPWR sky130_fd_sc_hd__tapvpwrvgnd_1
XANTENNA__7552__S _3695_ VGND VGND VPWR VPWR sky130_fd_sc_hd__diode_2
XFILLER_0_6_27 VGND VGND VPWR VPWR sky130_fd_sc_hd__fill_1
XFILLER_0_22_664 VGND VGND VPWR VPWR sky130_fd_sc_hd__decap_6
X_4290_ _1082_ _1084_ _1087_ _1034_ net8 VGND VGND VPWR VPWR _1088_ sky130_fd_sc_hd__a221o_1
XANTENNA__5119__S0 _1762_ VGND VGND VPWR VPWR sky130_fd_sc_hd__diode_2
XTAP_TAPCELL_ROW_72_1193 VGND VPWR sky130_fd_sc_hd__tapvpwrvgnd_1
XANTENNA_clkbuf_leaf_6_clk_A clknet_4_1_0_clk VGND VGND VPWR VPWR sky130_fd_sc_hd__diode_2
XANTENNA__7433__A1 _3479_ VGND VGND VPWR VPWR sky130_fd_sc_hd__diode_2
X_7980_ _3008_ registers\[28\]\[22\] _3923_ VGND VGND VPWR VPWR _3926_ sky130_fd_sc_hd__mux2_1
XANTENNA__4342__S1 _1137_ VGND VGND VPWR VPWR sky130_fd_sc_hd__diode_2
X_6931_ _3123_ registers\[13\]\[26\] _3346_ VGND VGND VPWR VPWR _3353_ sky130_fd_sc_hd__mux2_1
XFILLER_0_16_50 VGND VGND VPWR VPWR sky130_fd_sc_hd__fill_2
X_6862_ _3316_ VGND VGND VPWR VPWR _0914_ sky130_fd_sc_hd__clkbuf_1
XFILLER_0_16_83 VGND VGND VPWR VPWR sky130_fd_sc_hd__fill_1
XFILLER_0_119_405 VGND VGND VPWR VPWR sky130_fd_sc_hd__fill_2
X_5813_ net139 _2199_ _2537_ _2541_ _2468_ VGND VGND VPWR VPWR _2542_ sky130_fd_sc_hd__a32o_1
XFILLER_0_76_347 VGND VGND VPWR VPWR sky130_fd_sc_hd__fill_2
XFILLER_0_8_102 VGND VGND VPWR VPWR sky130_fd_sc_hd__decap_3
X_8601_ clknet_leaf_87_clk _0722_ VGND VGND VPWR VPWR registers\[3\]\[25\] sky130_fd_sc_hd__dfxtp_1
XFILLER_0_119_449 VGND VGND VPWR VPWR sky130_fd_sc_hd__fill_2
XANTENNA__6631__S _3186_ VGND VGND VPWR VPWR sky130_fd_sc_hd__diode_2
X_6793_ registers\[11\]\[26\] _3016_ _3272_ VGND VGND VPWR VPWR _3279_ sky130_fd_sc_hd__mux2_1
X_8532_ registers\[4\]\[26\] net34 _4211_ VGND VGND VPWR VPWR _4218_ sky130_fd_sc_hd__mux2_1
X_5744_ net139 _2475_ VGND VGND VPWR VPWR _2476_ sky130_fd_sc_hd__xnor2_1
XANTENNA__4940__A _1704_ VGND VGND VPWR VPWR sky130_fd_sc_hd__diode_2
XFILLER_0_17_447 VGND VGND VPWR VPWR sky130_fd_sc_hd__fill_1
XTAP_TAPCELL_ROW_20_515 VGND VPWR sky130_fd_sc_hd__tapvpwrvgnd_1
XFILLER_0_32_60 VGND VGND VPWR VPWR sky130_fd_sc_hd__decap_3
XFILLER_0_115_633 VPWR VGND VPWR VGND sky130_ef_sc_hd__decap_12
X_5675_ _2225_ _2230_ _2266_ VGND VGND VPWR VPWR _2409_ sky130_fd_sc_hd__mux2_1
X_8463_ _4181_ VGND VGND VPWR VPWR _0626_ sky130_fd_sc_hd__clkbuf_1
XFILLER_0_89_3 VPWR VGND VPWR VGND sky130_ef_sc_hd__decap_12
X_7414_ registers\[20\]\[12\] _3460_ _3623_ VGND VGND VPWR VPWR _3626_ sky130_fd_sc_hd__mux2_1
X_4626_ registers\[12\]\[19\] registers\[13\]\[19\] registers\[14\]\[19\] registers\[15\]\[19\]
+ _1404_ _1405_ VGND VGND VPWR VPWR _1407_ sky130_fd_sc_hd__mux4_1
X_8394_ registers\[5\]\[25\] _3487_ _4139_ VGND VGND VPWR VPWR _4145_ sky130_fd_sc_hd__mux2_1
XFILLER_0_102_305 VGND VGND VPWR VPWR sky130_fd_sc_hd__decap_3
X_7345_ registers\[1\]\[12\] _3460_ _3586_ VGND VGND VPWR VPWR _3589_ sky130_fd_sc_hd__mux2_1
XFILLER_0_12_130 VGND VGND VPWR VPWR sky130_fd_sc_hd__fill_2
X_4557_ registers\[16\]\[16\] registers\[17\]\[16\] registers\[18\]\[16\] registers\[19\]\[16\]
+ _1320_ _1321_ VGND VGND VPWR VPWR _1341_ sky130_fd_sc_hd__mux4_1
XFILLER_0_12_163 VGND VGND VPWR VPWR sky130_fd_sc_hd__fill_1
X_7276_ _3552_ VGND VGND VPWR VPWR _0068_ sky130_fd_sc_hd__clkbuf_1
X_4488_ _1274_ _1275_ _1117_ VGND VGND VPWR VPWR _1276_ sky130_fd_sc_hd__mux2_1
XANTENNA__7672__A1 _3445_ VGND VGND VPWR VPWR sky130_fd_sc_hd__diode_2
X_6227_ _2255_ _2866_ _2359_ VGND VGND VPWR VPWR _2933_ sky130_fd_sc_hd__a21oi_1
X_9015_ clknet_leaf_92_clk _0112_ VGND VGND VPWR VPWR registers\[1\]\[23\] sky130_fd_sc_hd__dfxtp_1
X_6158_ _2249_ _2256_ net124 VGND VGND VPWR VPWR _2868_ sky130_fd_sc_hd__mux2_1
XANTENNA__7424__A1 _3470_ VGND VGND VPWR VPWR sky130_fd_sc_hd__diode_2
X_5109_ _1741_ _1857_ _1861_ _1865_ VGND VGND VPWR VPWR _1866_ sky130_fd_sc_hd__a2bb2o_2
XANTENNA__4581__S1 _1204_ VGND VGND VPWR VPWR sky130_fd_sc_hd__diode_2
X_6089_ _1440_ _1454_ _2207_ _2706_ _2394_ VGND VGND VPWR VPWR _2803_ sky130_fd_sc_hd__a41o_1
XANTENNA__4333__S1 _1128_ VGND VGND VPWR VPWR sky130_fd_sc_hd__diode_2
XFILLER_0_79_130 VGND VGND VPWR VPWR sky130_fd_sc_hd__decap_4
XTAP_TAPCELL_ROW_28_626 VGND VPWR sky130_fd_sc_hd__tapvpwrvgnd_1
XFILLER_0_79_185 VGND VGND VPWR VPWR sky130_fd_sc_hd__decap_8
XANTENNA__6107__A net96 VGND VGND VPWR VPWR sky130_fd_sc_hd__diode_2
XTAP_TAPCELL_ROW_0_240 VGND VPWR sky130_fd_sc_hd__tapvpwrvgnd_1
XTAP_TAPCELL_ROW_0_251 VGND VPWR sky130_fd_sc_hd__tapvpwrvgnd_1
XTAP_TAPCELL_ROW_0_262 VGND VPWR sky130_fd_sc_hd__tapvpwrvgnd_1
XFILLER_0_95_656 VPWR VGND VPWR VGND sky130_ef_sc_hd__decap_12
XANTENNA__5011__A _1690_ VGND VGND VPWR VPWR sky130_fd_sc_hd__diode_2
XFILLER_0_95_689 VGND VGND VPWR VPWR sky130_fd_sc_hd__decap_6
XFILLER_0_55_509 VGND VGND VPWR VPWR sky130_fd_sc_hd__fill_1
XFILLER_0_48_550 VGND VGND VPWR VPWR sky130_fd_sc_hd__fill_1
XANTENNA__7637__S _3742_ VGND VGND VPWR VPWR sky130_fd_sc_hd__diode_2
XFILLER_0_36_701 VGND VGND VPWR VPWR sky130_fd_sc_hd__fill_1
XFILLER_0_106_611 VGND VGND VPWR VPWR sky130_fd_sc_hd__decap_3
XFILLER_0_90_383 VGND VGND VPWR VPWR sky130_fd_sc_hd__decap_4
XFILLER_0_51_726 VGND VGND VPWR VPWR sky130_fd_sc_hd__fill_2
XANTENNA__6527__C_N net11 VGND VGND VPWR VPWR sky130_fd_sc_hd__diode_2
XFILLER_0_106_688 VGND VGND VPWR VPWR sky130_fd_sc_hd__fill_2
XFILLER_0_16_480 VGND VGND VPWR VPWR sky130_fd_sc_hd__decap_4
XANTENNA__8468__S _4175_ VGND VGND VPWR VPWR sky130_fd_sc_hd__diode_2
XANTENNA__7372__S _3597_ VGND VGND VPWR VPWR sky130_fd_sc_hd__diode_2
Xoutput52 net52 VGND VGND VPWR VPWR alu_result[12] sky130_fd_sc_hd__buf_1
XANTENNA__5349__S0 _2027_ VGND VGND VPWR VPWR sky130_fd_sc_hd__diode_2
Xoutput74 net74 VGND VGND VPWR VPWR alu_result[3] sky130_fd_sc_hd__buf_1
Xoutput63 net63 VGND VGND VPWR VPWR alu_result[22] sky130_fd_sc_hd__buf_1
XTAP_TAPCELL_ROW_8_362 VGND VPWR sky130_fd_sc_hd__tapvpwrvgnd_1
Xoutput85 net85 VGND VGND VPWR VPWR rd1[13] sky130_fd_sc_hd__buf_1
Xoutput96 net96 VGND VGND VPWR VPWR rd1[23] sky130_fd_sc_hd__buf_1
XANTENNA__4324__S1 _1113_ VGND VGND VPWR VPWR sky130_fd_sc_hd__diode_2
XFILLER_0_86_645 VGND VGND VPWR VPWR sky130_fd_sc_hd__fill_2
XFILLER_0_85_144 VGND VGND VPWR VPWR sky130_fd_sc_hd__fill_2
XFILLER_0_39_572 VGND VGND VPWR VPWR sky130_fd_sc_hd__fill_2
XFILLER_0_39_561 VGND VGND VPWR VPWR sky130_fd_sc_hd__fill_2
XFILLER_0_116_419 VGND VGND VPWR VPWR sky130_fd_sc_hd__fill_1
XFILLER_0_85_188 VGND VGND VPWR VPWR sky130_fd_sc_hd__fill_2
XANTENNA__6451__S _3069_ VGND VGND VPWR VPWR sky130_fd_sc_hd__diode_2
XFILLER_0_73_328 VGND VGND VPWR VPWR sky130_fd_sc_hd__fill_2
XFILLER_0_109_493 VGND VGND VPWR VPWR sky130_fd_sc_hd__fill_2
XFILLER_0_54_586 VGND VGND VPWR VPWR sky130_fd_sc_hd__fill_2
XFILLER_0_42_715 VGND VGND VPWR VPWR sky130_fd_sc_hd__fill_2
XFILLER_0_41_203 VGND VGND VPWR VPWR sky130_fd_sc_hd__decap_3
X_5460_ _2196_ VGND VGND VPWR VPWR net105 sky130_fd_sc_hd__inv_2
XFILLER_0_26_266 VGND VGND VPWR VPWR sky130_fd_sc_hd__fill_2
XANTENNA__6154__B2 _2321_ VGND VGND VPWR VPWR sky130_fd_sc_hd__diode_2
X_4411_ _1203_ VGND VGND VPWR VPWR _1204_ sky130_fd_sc_hd__clkbuf_4
XTAP_TAPCELL_ROW_74_1222 VGND VPWR sky130_fd_sc_hd__tapvpwrvgnd_1
XFILLER_0_1_333 VGND VGND VPWR VPWR sky130_fd_sc_hd__decap_3
XFILLER_0_10_612 VGND VGND VPWR VPWR sky130_fd_sc_hd__fill_2
XANTENNA__4260__S0 net6 VGND VGND VPWR VPWR sky130_fd_sc_hd__diode_2
X_5391_ registers\[4\]\[27\] registers\[5\]\[27\] registers\[6\]\[27\] registers\[7\]\[27\]
+ _2126_ _2127_ VGND VGND VPWR VPWR _2132_ sky130_fd_sc_hd__mux4_1
XFILLER_0_22_461 VGND VGND VPWR VPWR sky130_fd_sc_hd__fill_2
X_4342_ registers\[4\]\[4\] registers\[5\]\[4\] registers\[6\]\[4\] registers\[7\]\[4\]
+ _1136_ _1137_ VGND VGND VPWR VPWR _1138_ sky130_fd_sc_hd__mux4_1
X_7130_ registers\[16\]\[15\] _3466_ _3456_ VGND VGND VPWR VPWR _3467_ sky130_fd_sc_hd__mux2_1
X_4273_ _1071_ VGND VGND VPWR VPWR _1072_ sky130_fd_sc_hd__clkbuf_4
X_7061_ _3115_ registers\[15\]\[22\] _3420_ VGND VGND VPWR VPWR _3423_ sky130_fd_sc_hd__mux2_1
XFILLER_0_94_33 VGND VGND VPWR VPWR sky130_fd_sc_hd__fill_1
X_6012_ _2730_ VGND VGND VPWR VPWR net57 sky130_fd_sc_hd__clkbuf_1
.ends
