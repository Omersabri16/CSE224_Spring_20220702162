* NGSPICE file created from CPU.ext - technology: sky130A

* Black-box entry subcircuit for sky130_fd_sc_hd__mux2_1 abstract view
.subckt sky130_fd_sc_hd__mux2_1 A0 A1 S VGND VNB VPB VPWR X
.ends

* Black-box entry subcircuit for sky130_fd_sc_hd__dfxtp_1 abstract view
.subckt sky130_fd_sc_hd__dfxtp_1 CLK D VGND VNB VPB VPWR Q
.ends

* Black-box entry subcircuit for sky130_ef_sc_hd__decap_12 abstract view
.subckt sky130_ef_sc_hd__decap_12 VPWR VGND VPB VNB
.ends

* Black-box entry subcircuit for sky130_fd_sc_hd__fill_1 abstract view
.subckt sky130_fd_sc_hd__fill_1 VGND VNB VPB VPWR
.ends

* Black-box entry subcircuit for sky130_fd_sc_hd__or2_1 abstract view
.subckt sky130_fd_sc_hd__or2_1 A B VGND VNB VPB VPWR X
.ends

* Black-box entry subcircuit for sky130_fd_sc_hd__dfrtp_1 abstract view
.subckt sky130_fd_sc_hd__dfrtp_1 CLK D RESET_B VGND VNB VPB VPWR Q
.ends

* Black-box entry subcircuit for sky130_fd_sc_hd__inv_2 abstract view
.subckt sky130_fd_sc_hd__inv_2 A VGND VNB VPB VPWR Y
.ends

* Black-box entry subcircuit for sky130_fd_sc_hd__fill_2 abstract view
.subckt sky130_fd_sc_hd__fill_2 VGND VNB VPB VPWR
.ends

* Black-box entry subcircuit for sky130_fd_sc_hd__tapvpwrvgnd_1 abstract view
.subckt sky130_fd_sc_hd__tapvpwrvgnd_1 VGND VPWR
.ends

* Black-box entry subcircuit for sky130_fd_sc_hd__dlygate4sd1_1 abstract view
.subckt sky130_fd_sc_hd__dlygate4sd1_1 A VGND VNB VPB VPWR X
.ends

* Black-box entry subcircuit for sky130_fd_sc_hd__decap_4 abstract view
.subckt sky130_fd_sc_hd__decap_4 VGND VNB VPB VPWR
.ends

* Black-box entry subcircuit for sky130_fd_sc_hd__a21o_1 abstract view
.subckt sky130_fd_sc_hd__a21o_1 A1 A2 B1 VGND VNB VPB VPWR X
.ends

* Black-box entry subcircuit for sky130_fd_sc_hd__a21oi_1 abstract view
.subckt sky130_fd_sc_hd__a21oi_1 A1 A2 B1 VGND VNB VPB VPWR Y
.ends

* Black-box entry subcircuit for sky130_fd_sc_hd__clkbuf_1 abstract view
.subckt sky130_fd_sc_hd__clkbuf_1 A VGND VNB VPB VPWR X
.ends

* Black-box entry subcircuit for sky130_fd_sc_hd__nand2_1 abstract view
.subckt sky130_fd_sc_hd__nand2_1 A B VGND VNB VPB VPWR Y
.ends

* Black-box entry subcircuit for sky130_fd_sc_hd__and2_1 abstract view
.subckt sky130_fd_sc_hd__and2_1 A B VGND VNB VPB VPWR X
.ends

* Black-box entry subcircuit for sky130_fd_sc_hd__decap_8 abstract view
.subckt sky130_fd_sc_hd__decap_8 VGND VNB VPB VPWR
.ends

* Black-box entry subcircuit for sky130_fd_sc_hd__decap_3 abstract view
.subckt sky130_fd_sc_hd__decap_3 VGND VNB VPB VPWR
.ends

* Black-box entry subcircuit for sky130_fd_sc_hd__decap_6 abstract view
.subckt sky130_fd_sc_hd__decap_6 VGND VNB VPB VPWR
.ends

* Black-box entry subcircuit for sky130_fd_sc_hd__and3b_1 abstract view
.subckt sky130_fd_sc_hd__and3b_1 A_N B C VGND VNB VPB VPWR X
.ends

* Black-box entry subcircuit for sky130_fd_sc_hd__and3_1 abstract view
.subckt sky130_fd_sc_hd__and3_1 A B C VGND VNB VPB VPWR X
.ends

* Black-box entry subcircuit for sky130_fd_sc_hd__and3_2 abstract view
.subckt sky130_fd_sc_hd__and3_2 A B C VGND VNB VPB VPWR X
.ends

* Black-box entry subcircuit for sky130_fd_sc_hd__a31o_1 abstract view
.subckt sky130_fd_sc_hd__a31o_1 A1 A2 A3 B1 VGND VNB VPB VPWR X
.ends

* Black-box entry subcircuit for sky130_fd_sc_hd__and2b_1 abstract view
.subckt sky130_fd_sc_hd__and2b_1 A_N B VGND VNB VPB VPWR X
.ends

* Black-box entry subcircuit for sky130_fd_sc_hd__xnor2_1 abstract view
.subckt sky130_fd_sc_hd__xnor2_1 A B VGND VNB VPB VPWR Y
.ends

* Black-box entry subcircuit for sky130_fd_sc_hd__o221ai_4 abstract view
.subckt sky130_fd_sc_hd__o221ai_4 A1 A2 B1 B2 C1 VGND VNB VPB VPWR Y
.ends

* Black-box entry subcircuit for sky130_fd_sc_hd__nand3_1 abstract view
.subckt sky130_fd_sc_hd__nand3_1 A B C VGND VNB VPB VPWR Y
.ends

* Black-box entry subcircuit for sky130_fd_sc_hd__a22o_1 abstract view
.subckt sky130_fd_sc_hd__a22o_1 A1 A2 B1 B2 VGND VNB VPB VPWR X
.ends

* Black-box entry subcircuit for sky130_fd_sc_hd__dlymetal6s2s_1 abstract view
.subckt sky130_fd_sc_hd__dlymetal6s2s_1 A VGND VNB VPB VPWR X
.ends

* Black-box entry subcircuit for sky130_fd_sc_hd__clkbuf_4 abstract view
.subckt sky130_fd_sc_hd__clkbuf_4 A VGND VNB VPB VPWR X
.ends

* Black-box entry subcircuit for sky130_fd_sc_hd__a21bo_1 abstract view
.subckt sky130_fd_sc_hd__a21bo_1 A1 A2 B1_N VGND VNB VPB VPWR X
.ends

* Black-box entry subcircuit for sky130_fd_sc_hd__buf_1 abstract view
.subckt sky130_fd_sc_hd__buf_1 A VGND VNB VPB VPWR X
.ends

* Black-box entry subcircuit for sky130_fd_sc_hd__clkbuf_2 abstract view
.subckt sky130_fd_sc_hd__clkbuf_2 A VGND VNB VPB VPWR X
.ends

* Black-box entry subcircuit for sky130_fd_sc_hd__a221o_1 abstract view
.subckt sky130_fd_sc_hd__a221o_1 A1 A2 B1 B2 C1 VGND VNB VPB VPWR X
.ends

* Black-box entry subcircuit for sky130_fd_sc_hd__nor2_1 abstract view
.subckt sky130_fd_sc_hd__nor2_1 A B VGND VNB VPB VPWR Y
.ends

* Black-box entry subcircuit for sky130_fd_sc_hd__buf_2 abstract view
.subckt sky130_fd_sc_hd__buf_2 A VGND VNB VPB VPWR X
.ends

* Black-box entry subcircuit for sky130_fd_sc_hd__or3_4 abstract view
.subckt sky130_fd_sc_hd__or3_4 A B C VGND VNB VPB VPWR X
.ends

* Black-box entry subcircuit for sky130_fd_sc_hd__o21ai_1 abstract view
.subckt sky130_fd_sc_hd__o21ai_1 A1 A2 B1 VGND VNB VPB VPWR Y
.ends

* Black-box entry subcircuit for sky130_fd_sc_hd__xor2_1 abstract view
.subckt sky130_fd_sc_hd__xor2_1 A B VGND VNB VPB VPWR X
.ends

* Black-box entry subcircuit for sky130_fd_sc_hd__a211o_1 abstract view
.subckt sky130_fd_sc_hd__a211o_1 A1 A2 B1 C1 VGND VNB VPB VPWR X
.ends

* Black-box entry subcircuit for sky130_fd_sc_hd__a2bb2o_1 abstract view
.subckt sky130_fd_sc_hd__a2bb2o_1 A1_N A2_N B1 B2 VGND VNB VPB VPWR X
.ends

* Black-box entry subcircuit for sky130_fd_sc_hd__or2b_1 abstract view
.subckt sky130_fd_sc_hd__or2b_1 A B_N VGND VNB VPB VPWR X
.ends

* Black-box entry subcircuit for sky130_fd_sc_hd__a32o_1 abstract view
.subckt sky130_fd_sc_hd__a32o_1 A1 A2 A3 B1 B2 VGND VNB VPB VPWR X
.ends

* Black-box entry subcircuit for sky130_fd_sc_hd__or4b_4 abstract view
.subckt sky130_fd_sc_hd__or4b_4 A B C D_N VGND VNB VPB VPWR X
.ends

* Black-box entry subcircuit for sky130_fd_sc_hd__and2b_2 abstract view
.subckt sky130_fd_sc_hd__and2b_2 A_N B VGND VNB VPB VPWR X
.ends

* Black-box entry subcircuit for sky130_fd_sc_hd__dfrtp_2 abstract view
.subckt sky130_fd_sc_hd__dfrtp_2 CLK D RESET_B VGND VNB VPB VPWR Q
.ends

* Black-box entry subcircuit for sky130_fd_sc_hd__buf_4 abstract view
.subckt sky130_fd_sc_hd__buf_4 A VGND VNB VPB VPWR X
.ends

* Black-box entry subcircuit for sky130_fd_sc_hd__or3b_4 abstract view
.subckt sky130_fd_sc_hd__or3b_4 A B C_N VGND VNB VPB VPWR X
.ends

* Black-box entry subcircuit for sky130_fd_sc_hd__a21o_2 abstract view
.subckt sky130_fd_sc_hd__a21o_2 A1 A2 B1 VGND VNB VPB VPWR X
.ends

* Black-box entry subcircuit for sky130_fd_sc_hd__o211a_1 abstract view
.subckt sky130_fd_sc_hd__o211a_1 A1 A2 B1 C1 VGND VNB VPB VPWR X
.ends

* Black-box entry subcircuit for sky130_fd_sc_hd__dfxtp_2 abstract view
.subckt sky130_fd_sc_hd__dfxtp_2 CLK D VGND VNB VPB VPWR Q
.ends

* Black-box entry subcircuit for sky130_fd_sc_hd__clkbuf_8 abstract view
.subckt sky130_fd_sc_hd__clkbuf_8 A VGND VNB VPB VPWR X
.ends

* Black-box entry subcircuit for sky130_fd_sc_hd__or3b_1 abstract view
.subckt sky130_fd_sc_hd__or3b_1 A B C_N VGND VNB VPB VPWR X
.ends

* Black-box entry subcircuit for sky130_fd_sc_hd__or3_1 abstract view
.subckt sky130_fd_sc_hd__or3_1 A B C VGND VNB VPB VPWR X
.ends

* Black-box entry subcircuit for sky130_fd_sc_hd__inv_6 abstract view
.subckt sky130_fd_sc_hd__inv_6 A VGND VNB VPB VPWR Y
.ends

* Black-box entry subcircuit for sky130_fd_sc_hd__a21oi_2 abstract view
.subckt sky130_fd_sc_hd__a21oi_2 A1 A2 B1 VGND VNB VPB VPWR Y
.ends

* Black-box entry subcircuit for sky130_fd_sc_hd__and4_2 abstract view
.subckt sky130_fd_sc_hd__and4_2 A B C D VGND VNB VPB VPWR X
.ends

* Black-box entry subcircuit for sky130_fd_sc_hd__nor3b_2 abstract view
.subckt sky130_fd_sc_hd__nor3b_2 A B C_N VGND VNB VPB VPWR Y
.ends

* Black-box entry subcircuit for sky130_fd_sc_hd__mux2_4 abstract view
.subckt sky130_fd_sc_hd__mux2_4 A0 A1 S VGND VNB VPB VPWR X
.ends

* Black-box entry subcircuit for sky130_fd_sc_hd__nand3_2 abstract view
.subckt sky130_fd_sc_hd__nand3_2 A B C VGND VNB VPB VPWR Y
.ends

* Black-box entry subcircuit for sky130_fd_sc_hd__a22oi_1 abstract view
.subckt sky130_fd_sc_hd__a22oi_1 A1 A2 B1 B2 VGND VNB VPB VPWR Y
.ends

* Black-box entry subcircuit for sky130_fd_sc_hd__a31oi_1 abstract view
.subckt sky130_fd_sc_hd__a31oi_1 A1 A2 A3 B1 VGND VNB VPB VPWR Y
.ends

* Black-box entry subcircuit for sky130_fd_sc_hd__o221a_1 abstract view
.subckt sky130_fd_sc_hd__o221a_1 A1 A2 B1 B2 C1 VGND VNB VPB VPWR X
.ends

* Black-box entry subcircuit for sky130_fd_sc_hd__clkinv_8 abstract view
.subckt sky130_fd_sc_hd__clkinv_8 A VGND VNB VPB VPWR Y
.ends

* Black-box entry subcircuit for sky130_fd_sc_hd__nor2_2 abstract view
.subckt sky130_fd_sc_hd__nor2_2 A B VGND VNB VPB VPWR Y
.ends

* Black-box entry subcircuit for sky130_fd_sc_hd__o21a_1 abstract view
.subckt sky130_fd_sc_hd__o21a_1 A1 A2 B1 VGND VNB VPB VPWR X
.ends

* Black-box entry subcircuit for sky130_fd_sc_hd__xnor2_2 abstract view
.subckt sky130_fd_sc_hd__xnor2_2 A B VGND VNB VPB VPWR Y
.ends

* Black-box entry subcircuit for sky130_fd_sc_hd__o21a_2 abstract view
.subckt sky130_fd_sc_hd__o21a_2 A1 A2 B1 VGND VNB VPB VPWR X
.ends

* Black-box entry subcircuit for sky130_fd_sc_hd__a21boi_1 abstract view
.subckt sky130_fd_sc_hd__a21boi_1 A1 A2 B1_N VGND VNB VPB VPWR Y
.ends

* Black-box entry subcircuit for sky130_fd_sc_hd__and4_1 abstract view
.subckt sky130_fd_sc_hd__and4_1 A B C D VGND VNB VPB VPWR X
.ends

* Black-box entry subcircuit for sky130_fd_sc_hd__or4bb_1 abstract view
.subckt sky130_fd_sc_hd__or4bb_1 A B C_N D_N VGND VNB VPB VPWR X
.ends

* Black-box entry subcircuit for sky130_fd_sc_hd__bufinv_16 abstract view
.subckt sky130_fd_sc_hd__bufinv_16 A VGND VNB VPB VPWR Y
.ends

* Black-box entry subcircuit for sky130_fd_sc_hd__or4_4 abstract view
.subckt sky130_fd_sc_hd__or4_4 A B C D VGND VNB VPB VPWR X
.ends

* Black-box entry subcircuit for sky130_fd_sc_hd__a21oi_4 abstract view
.subckt sky130_fd_sc_hd__a21oi_4 A1 A2 B1 VGND VNB VPB VPWR Y
.ends

* Black-box entry subcircuit for sky130_fd_sc_hd__clkbuf_16 abstract view
.subckt sky130_fd_sc_hd__clkbuf_16 A VGND VNB VPB VPWR X
.ends

* Black-box entry subcircuit for sky130_fd_sc_hd__nor3b_1 abstract view
.subckt sky130_fd_sc_hd__nor3b_1 A B C_N VGND VNB VPB VPWR Y
.ends

* Black-box entry subcircuit for sky130_fd_sc_hd__or3_2 abstract view
.subckt sky130_fd_sc_hd__or3_2 A B C VGND VNB VPB VPWR X
.ends

* Black-box entry subcircuit for sky130_fd_sc_hd__inv_8 abstract view
.subckt sky130_fd_sc_hd__inv_8 A VGND VNB VPB VPWR Y
.ends

* Black-box entry subcircuit for sky130_fd_sc_hd__clkinvlp_4 abstract view
.subckt sky130_fd_sc_hd__clkinvlp_4 A VGND VNB VPB VPWR Y
.ends

* Black-box entry subcircuit for sky130_fd_sc_hd__nor4_1 abstract view
.subckt sky130_fd_sc_hd__nor4_1 A B C D VGND VNB VPB VPWR Y
.ends

* Black-box entry subcircuit for sky130_fd_sc_hd__or4_1 abstract view
.subckt sky130_fd_sc_hd__or4_1 A B C D VGND VNB VPB VPWR X
.ends

* Black-box entry subcircuit for sky130_fd_sc_hd__and4_4 abstract view
.subckt sky130_fd_sc_hd__and4_4 A B C D VGND VNB VPB VPWR X
.ends

* Black-box entry subcircuit for sky130_fd_sc_hd__nand3_4 abstract view
.subckt sky130_fd_sc_hd__nand3_4 A B C VGND VNB VPB VPWR Y
.ends

* Black-box entry subcircuit for sky130_fd_sc_hd__nor4_4 abstract view
.subckt sky130_fd_sc_hd__nor4_4 A B C D VGND VNB VPB VPWR Y
.ends

* Black-box entry subcircuit for sky130_fd_sc_hd__or3b_2 abstract view
.subckt sky130_fd_sc_hd__or3b_2 A B C_N VGND VNB VPB VPWR X
.ends

* Black-box entry subcircuit for sky130_fd_sc_hd__a22o_2 abstract view
.subckt sky130_fd_sc_hd__a22o_2 A1 A2 B1 B2 VGND VNB VPB VPWR X
.ends

* Black-box entry subcircuit for sky130_fd_sc_hd__o22a_1 abstract view
.subckt sky130_fd_sc_hd__o22a_1 A1 A2 B1 B2 VGND VNB VPB VPWR X
.ends

* Black-box entry subcircuit for sky130_fd_sc_hd__clkinv_2 abstract view
.subckt sky130_fd_sc_hd__clkinv_2 A VGND VNB VPB VPWR Y
.ends

* Black-box entry subcircuit for sky130_fd_sc_hd__o211ai_1 abstract view
.subckt sky130_fd_sc_hd__o211ai_1 A1 A2 B1 C1 VGND VNB VPB VPWR Y
.ends

* Black-box entry subcircuit for sky130_fd_sc_hd__o211ai_4 abstract view
.subckt sky130_fd_sc_hd__o211ai_4 A1 A2 B1 C1 VGND VNB VPB VPWR Y
.ends

* Black-box entry subcircuit for sky130_fd_sc_hd__and2_2 abstract view
.subckt sky130_fd_sc_hd__and2_2 A B VGND VNB VPB VPWR X
.ends

* Black-box entry subcircuit for sky130_fd_sc_hd__buf_6 abstract view
.subckt sky130_fd_sc_hd__buf_6 A VGND VNB VPB VPWR X
.ends

* Black-box entry subcircuit for sky130_fd_sc_hd__and4b_1 abstract view
.subckt sky130_fd_sc_hd__and4b_1 A_N B C D VGND VNB VPB VPWR X
.ends

* Black-box entry subcircuit for sky130_fd_sc_hd__clkinvlp_2 abstract view
.subckt sky130_fd_sc_hd__clkinvlp_2 A VGND VNB VPB VPWR Y
.ends

* Black-box entry subcircuit for sky130_fd_sc_hd__o21ai_2 abstract view
.subckt sky130_fd_sc_hd__o21ai_2 A1 A2 B1 VGND VNB VPB VPWR Y
.ends

* Black-box entry subcircuit for sky130_fd_sc_hd__o21bai_1 abstract view
.subckt sky130_fd_sc_hd__o21bai_1 A1 A2 B1_N VGND VNB VPB VPWR Y
.ends

* Black-box entry subcircuit for sky130_fd_sc_hd__nand2_2 abstract view
.subckt sky130_fd_sc_hd__nand2_2 A B VGND VNB VPB VPWR Y
.ends

* Black-box entry subcircuit for sky130_fd_sc_hd__clkinv_4 abstract view
.subckt sky130_fd_sc_hd__clkinv_4 A VGND VNB VPB VPWR Y
.ends

* Black-box entry subcircuit for sky130_fd_sc_hd__nor3_1 abstract view
.subckt sky130_fd_sc_hd__nor3_1 A B C VGND VNB VPB VPWR Y
.ends

* Black-box entry subcircuit for sky130_fd_sc_hd__o22ai_1 abstract view
.subckt sky130_fd_sc_hd__o22ai_1 A1 A2 B1 B2 VGND VNB VPB VPWR Y
.ends

* Black-box entry subcircuit for sky130_fd_sc_hd__clkinv_1 abstract view
.subckt sky130_fd_sc_hd__clkinv_1 A VGND VNB VPB VPWR Y
.ends

* Black-box entry subcircuit for sky130_fd_sc_hd__or2_2 abstract view
.subckt sky130_fd_sc_hd__or2_2 A B VGND VNB VPB VPWR X
.ends

* Black-box entry subcircuit for sky130_fd_sc_hd__o21ai_4 abstract view
.subckt sky130_fd_sc_hd__o21ai_4 A1 A2 B1 VGND VNB VPB VPWR Y
.ends

* Black-box entry subcircuit for sky130_fd_sc_hd__o22ai_4 abstract view
.subckt sky130_fd_sc_hd__o22ai_4 A1 A2 B1 B2 VGND VNB VPB VPWR Y
.ends

* Black-box entry subcircuit for sky130_fd_sc_hd__and2_4 abstract view
.subckt sky130_fd_sc_hd__and2_4 A B VGND VNB VPB VPWR X
.ends

* Black-box entry subcircuit for sky130_fd_sc_hd__or4_2 abstract view
.subckt sky130_fd_sc_hd__or4_2 A B C D VGND VNB VPB VPWR X
.ends

* Black-box entry subcircuit for sky130_fd_sc_hd__nor3_4 abstract view
.subckt sky130_fd_sc_hd__nor3_4 A B C VGND VNB VPB VPWR Y
.ends

* Black-box entry subcircuit for sky130_fd_sc_hd__or4bb_4 abstract view
.subckt sky130_fd_sc_hd__or4bb_4 A B C_N D_N VGND VNB VPB VPWR X
.ends

* Black-box entry subcircuit for sky130_fd_sc_hd__a221oi_2 abstract view
.subckt sky130_fd_sc_hd__a221oi_2 A1 A2 B1 B2 C1 VGND VNB VPB VPWR Y
.ends

* Black-box entry subcircuit for sky130_fd_sc_hd__o22ai_2 abstract view
.subckt sky130_fd_sc_hd__o22ai_2 A1 A2 B1 B2 VGND VNB VPB VPWR Y
.ends

* Black-box entry subcircuit for sky130_fd_sc_hd__nand3b_2 abstract view
.subckt sky130_fd_sc_hd__nand3b_2 A_N B C VGND VNB VPB VPWR Y
.ends

* Black-box entry subcircuit for sky130_fd_sc_hd__a211oi_4 abstract view
.subckt sky130_fd_sc_hd__a211oi_4 A1 A2 B1 C1 VGND VNB VPB VPWR Y
.ends

* Black-box entry subcircuit for sky130_fd_sc_hd__o2bb2a_2 abstract view
.subckt sky130_fd_sc_hd__o2bb2a_2 A1_N A2_N B1 B2 VGND VNB VPB VPWR X
.ends

* Black-box entry subcircuit for sky130_fd_sc_hd__o22a_4 abstract view
.subckt sky130_fd_sc_hd__o22a_4 A1 A2 B1 B2 VGND VNB VPB VPWR X
.ends

* Black-box entry subcircuit for sky130_fd_sc_hd__and4bb_2 abstract view
.subckt sky130_fd_sc_hd__and4bb_2 A_N B_N C D VGND VNB VPB VPWR X
.ends

* Black-box entry subcircuit for sky130_fd_sc_hd__xor2_2 abstract view
.subckt sky130_fd_sc_hd__xor2_2 A B VGND VNB VPB VPWR X
.ends

* Black-box entry subcircuit for sky130_fd_sc_hd__nand4_2 abstract view
.subckt sky130_fd_sc_hd__nand4_2 A B C D VGND VNB VPB VPWR Y
.ends

* Black-box entry subcircuit for sky130_fd_sc_hd__a221o_2 abstract view
.subckt sky130_fd_sc_hd__a221o_2 A1 A2 B1 B2 C1 VGND VNB VPB VPWR X
.ends

* Black-box entry subcircuit for sky130_fd_sc_hd__a221oi_1 abstract view
.subckt sky130_fd_sc_hd__a221oi_1 A1 A2 B1 B2 C1 VGND VNB VPB VPWR Y
.ends

* Black-box entry subcircuit for sky130_fd_sc_hd__nor4_2 abstract view
.subckt sky130_fd_sc_hd__nor4_2 A B C D VGND VNB VPB VPWR Y
.ends

* Black-box entry subcircuit for sky130_fd_sc_hd__o21ba_1 abstract view
.subckt sky130_fd_sc_hd__o21ba_1 A1 A2 B1_N VGND VNB VPB VPWR X
.ends

* Black-box entry subcircuit for sky130_fd_sc_hd__a21boi_2 abstract view
.subckt sky130_fd_sc_hd__a21boi_2 A1 A2 B1_N VGND VNB VPB VPWR Y
.ends

* Black-box entry subcircuit for sky130_fd_sc_hd__or2_4 abstract view
.subckt sky130_fd_sc_hd__or2_4 A B VGND VNB VPB VPWR X
.ends

* Black-box entry subcircuit for sky130_fd_sc_hd__nor4b_1 abstract view
.subckt sky130_fd_sc_hd__nor4b_1 A B C D_N VGND VNB VPB VPWR Y
.ends

* Black-box entry subcircuit for sky130_fd_sc_hd__a2bb2o_2 abstract view
.subckt sky130_fd_sc_hd__a2bb2o_2 A1_N A2_N B1 B2 VGND VNB VPB VPWR X
.ends

* Black-box entry subcircuit for sky130_fd_sc_hd__a311o_1 abstract view
.subckt sky130_fd_sc_hd__a311o_1 A1 A2 A3 B1 C1 VGND VNB VPB VPWR X
.ends

* Black-box entry subcircuit for sky130_fd_sc_hd__a311oi_1 abstract view
.subckt sky130_fd_sc_hd__a311oi_1 A1 A2 A3 B1 C1 VGND VNB VPB VPWR Y
.ends

* Black-box entry subcircuit for sky130_fd_sc_hd__diode_2 abstract view
.subckt sky130_fd_sc_hd__diode_2 DIODE VGND VNB VPB VPWR
.ends

* Black-box entry subcircuit for sky130_fd_sc_hd__a211oi_1 abstract view
.subckt sky130_fd_sc_hd__a211oi_1 A1 A2 B1 C1 VGND VNB VPB VPWR Y
.ends

* Black-box entry subcircuit for sky130_fd_sc_hd__o32a_1 abstract view
.subckt sky130_fd_sc_hd__o32a_1 A1 A2 A3 B1 B2 VGND VNB VPB VPWR X
.ends

* Black-box entry subcircuit for sky130_fd_sc_hd__a2111o_1 abstract view
.subckt sky130_fd_sc_hd__a2111o_1 A1 A2 B1 C1 D1 VGND VNB VPB VPWR X
.ends

* Black-box entry subcircuit for sky130_fd_sc_hd__and4bb_1 abstract view
.subckt sky130_fd_sc_hd__and4bb_1 A_N B_N C D VGND VNB VPB VPWR X
.ends

* Black-box entry subcircuit for sky130_fd_sc_hd__and3b_2 abstract view
.subckt sky130_fd_sc_hd__and3b_2 A_N B C VGND VNB VPB VPWR X
.ends

* Black-box entry subcircuit for sky130_fd_sc_hd__a22oi_2 abstract view
.subckt sky130_fd_sc_hd__a22oi_2 A1 A2 B1 B2 VGND VNB VPB VPWR Y
.ends

* Black-box entry subcircuit for sky130_fd_sc_hd__a2111oi_1 abstract view
.subckt sky130_fd_sc_hd__a2111oi_1 A1 A2 B1 C1 D1 VGND VNB VPB VPWR Y
.ends

.subckt CPU VGND VPWR an[0] an[1] an[2] an[3] an[4] an[5] an[6] an[7] clk control
+ reset seg[0] seg[1] seg[2] seg[3] seg[4] seg[5] seg[6]
X_2106_ _0920_ _0921_ _0903_ VGND VGND VPWR VPWR _0922_ sky130_fd_sc_hd__mux2_1
X_3155_ clknet_leaf_11_clk _0358_ VGND VGND VPWR VPWR net2 sky130_fd_sc_hd__dfxtp_1
XFILLER_0_49_314 VPWR VGND VPWR VGND sky130_ef_sc_hd__decap_12
XFILLER_0_27_60 VGND VGND VPWR VPWR sky130_fd_sc_hd__fill_1
X_2037_ _0602_ _0852_ VGND VGND VPWR VPWR _0853_ sky130_fd_sc_hd__or2_1
X_3086_ clknet_leaf_15_clk _0309_ _0145_ VGND VGND VPWR VPWR reg_file.registers\[10\]\[24\]
+ sky130_fd_sc_hd__dfrtp_1
X_2939_ _1471_ VGND VGND VPWR VPWR _0181_ sky130_fd_sc_hd__inv_2
XFILLER_0_17_222 VGND VGND VPWR VPWR sky130_fd_sc_hd__fill_2
XTAP_TAPCELL_ROW_20_312 VGND VPWR sky130_fd_sc_hd__tapvpwrvgnd_1
XFILLER_0_7_81 VPWR VGND VPWR VGND sky130_ef_sc_hd__decap_12
XTAP_TAPCELL_ROW_71_735 VGND VPWR sky130_fd_sc_hd__tapvpwrvgnd_1
XTAP_TAPCELL_ROW_71_724 VGND VPWR sky130_fd_sc_hd__tapvpwrvgnd_1
XFILLER_0_70_309 VPWR VGND VPWR VGND sky130_ef_sc_hd__decap_12
Xrebuffer7 net42 VGND VGND VPWR VPWR net23 sky130_fd_sc_hd__dlygate4sd1_1
XFILLER_0_23_225 VGND VGND VPWR VPWR sky130_fd_sc_hd__fill_1
XFILLER_0_48_15 VPWR VGND VPWR VGND sky130_ef_sc_hd__decap_12
XFILLER_0_3_39 VPWR VGND VPWR VGND sky130_ef_sc_hd__decap_12
XFILLER_0_58_122 VGND VGND VPWR VPWR sky130_fd_sc_hd__fill_2
XFILLER_0_39_391 VGND VGND VPWR VPWR sky130_fd_sc_hd__fill_1
XTAP_TAPCELL_ROW_34_426 VGND VPWR sky130_fd_sc_hd__tapvpwrvgnd_1
XFILLER_0_13_51 VGND VGND VPWR VPWR sky130_fd_sc_hd__decap_4
XTAP_TAPCELL_ROW_42_492 VGND VPWR sky130_fd_sc_hd__tapvpwrvgnd_1
X_2655_ _1145_ _1361_ _1373_ VGND VGND VPWR VPWR _1374_ sky130_fd_sc_hd__a21o_1
X_2724_ display.counter\[4\] _1424_ display.counter\[5\] VGND VGND VPWR VPWR _1427_
+ sky130_fd_sc_hd__a21oi_1
X_1606_ _0442_ VGND VGND VPWR VPWR _0305_ sky130_fd_sc_hd__clkbuf_1
X_2586_ imem.address\[30\] _1337_ VGND VGND VPWR VPWR _1338_ sky130_fd_sc_hd__nand2_1
X_1537_ reg_file.registers\[5\]\[20\] _0403_ VGND VGND VPWR VPWR _0406_ sky130_fd_sc_hd__and2_1
X_3069_ clknet_leaf_9_clk _0292_ _0128_ VGND VGND VPWR VPWR reg_file.registers\[10\]\[7\]
+ sky130_fd_sc_hd__dfrtp_1
X_3138_ clknet_leaf_14_clk _0020_ VGND VGND VPWR VPWR display.counter\[3\] sky130_fd_sc_hd__dfxtp_1
XFILLER_0_52_309 VPWR VGND VPWR VGND sky130_ef_sc_hd__decap_12
XFILLER_0_37_317 VGND VGND VPWR VPWR sky130_fd_sc_hd__decap_8
XTAP_TAPCELL_ROW_5_195 VGND VPWR sky130_fd_sc_hd__tapvpwrvgnd_1
XFILLER_0_18_29 VPWR VGND VPWR VGND sky130_ef_sc_hd__decap_12
XFILLER_0_50_49 VGND VGND VPWR VPWR sky130_fd_sc_hd__decap_3
XFILLER_0_50_27 VGND VGND VPWR VPWR sky130_fd_sc_hd__fill_1
XTAP_TAPCELL_ROW_31_407 VGND VPWR sky130_fd_sc_hd__tapvpwrvgnd_1
X_2440_ _1235_ VGND VGND VPWR VPWR _0264_ sky130_fd_sc_hd__clkbuf_1
XFILLER_0_55_169 VGND VGND VPWR VPWR sky130_fd_sc_hd__decap_4
XFILLER_0_51_353 VGND VGND VPWR VPWR sky130_fd_sc_hd__fill_1
XFILLER_0_51_320 VPWR VGND VPWR VGND sky130_ef_sc_hd__decap_12
XFILLER_0_3_417 VPWR VGND VPWR VGND sky130_ef_sc_hd__decap_12
XFILLER_0_11_217 VGND VGND VPWR VPWR sky130_fd_sc_hd__decap_6
X_2371_ _1173_ _0470_ _1167_ VGND VGND VPWR VPWR _1174_ sky130_fd_sc_hd__and3b_1
XFILLER_0_19_306 VPWR VGND VPWR VGND sky130_ef_sc_hd__decap_12
XFILLER_0_46_136 VGND VGND VPWR VPWR sky130_fd_sc_hd__decap_4
XFILLER_0_34_309 VPWR VGND VPWR VGND sky130_ef_sc_hd__decap_12
XFILLER_0_27_383 VGND VGND VPWR VPWR sky130_fd_sc_hd__decap_8
XFILLER_0_6_233 VPWR VGND VPWR VGND sky130_ef_sc_hd__decap_12
XFILLER_0_6_277 VPWR VGND VPWR VGND sky130_ef_sc_hd__decap_12
XFILLER_0_71_3 VPWR VGND VPWR VGND sky130_ef_sc_hd__decap_12
X_2569_ imem.address\[5\] imem.address\[4\] _1283_ VGND VGND VPWR VPWR _1321_ sky130_fd_sc_hd__and3_1
X_2638_ display.digit_sel\[1\] display.digit_sel\[2\] display.digit_sel\[0\] VGND
+ VGND VPWR VPWR _1360_ sky130_fd_sc_hd__and3_2
X_2707_ _1377_ _1409_ _1419_ _1406_ VGND VGND VPWR VPWR _0005_ sky130_fd_sc_hd__a31o_1
XFILLER_0_10_283 VGND VGND VPWR VPWR sky130_fd_sc_hd__fill_1
XTAP_TAPCELL_ROW_53_576 VGND VPWR sky130_fd_sc_hd__tapvpwrvgnd_1
XFILLER_0_37_158 VGND VGND VPWR VPWR sky130_fd_sc_hd__fill_1
XFILLER_0_52_139 VGND VGND VPWR VPWR sky130_fd_sc_hd__fill_1
XFILLER_0_61_15 VPWR VGND VPWR VGND sky130_ef_sc_hd__decap_12
XFILLER_0_45_27 VPWR VGND VPWR VGND sky130_ef_sc_hd__decap_12
XTAP_TAPCELL_ROW_44_510 VGND VPWR sky130_fd_sc_hd__tapvpwrvgnd_1
XFILLER_0_0_29 VPWR VGND VPWR VGND sky130_ef_sc_hd__decap_12
XFILLER_0_56_445 VGND VGND VPWR VPWR sky130_fd_sc_hd__decap_3
X_1871_ _0680_ _0686_ VGND VGND VPWR VPWR _0687_ sky130_fd_sc_hd__and2b_1
X_1940_ _0754_ _0755_ VGND VGND VPWR VPWR _0756_ sky130_fd_sc_hd__xnor2_1
XFILLER_0_9_27 VPWR VGND VPWR VGND sky130_ef_sc_hd__decap_12
XFILLER_0_16_309 VGND VGND VPWR VPWR sky130_fd_sc_hd__decap_3
X_2423_ _1220_ VGND VGND VPWR VPWR _0266_ sky130_fd_sc_hd__clkbuf_1
XFILLER_0_3_225 VPWR VGND VPWR VGND sky130_ef_sc_hd__decap_12
XFILLER_0_10_41 VPWR VGND VPWR VGND sky130_ef_sc_hd__decap_12
XFILLER_0_10_85 VPWR VGND VPWR VGND sky130_ef_sc_hd__decap_12
X_2285_ _0893_ _0955_ _1095_ VGND VGND VPWR VPWR _1096_ sky130_fd_sc_hd__a21o_1
X_2354_ _1159_ VGND VGND VPWR VPWR _0274_ sky130_fd_sc_hd__clkbuf_1
XFILLER_0_47_401 VGND VGND VPWR VPWR sky130_fd_sc_hd__fill_1
XFILLER_0_51_81 VGND VGND VPWR VPWR sky130_fd_sc_hd__decap_8
XTAP_TAPCELL_ROW_50_557 VGND VPWR sky130_fd_sc_hd__tapvpwrvgnd_1
XFILLER_0_34_139 VGND VGND VPWR VPWR sky130_fd_sc_hd__fill_1
XFILLER_0_19_169 VGND VGND VPWR VPWR sky130_fd_sc_hd__decap_6
XFILLER_0_30_378 VGND VGND VPWR VPWR sky130_fd_sc_hd__decap_6
XFILLER_0_30_334 VGND VGND VPWR VPWR sky130_fd_sc_hd__decap_8
XTAP_TAPCELL_ROW_7_213 VGND VPWR sky130_fd_sc_hd__tapvpwrvgnd_1
XFILLER_0_53_426 VGND VGND VPWR VPWR sky130_fd_sc_hd__decap_6
XFILLER_0_38_445 VGND VGND VPWR VPWR sky130_fd_sc_hd__decap_6
XTAP_TAPCELL_ROW_13_259 VGND VPWR sky130_fd_sc_hd__tapvpwrvgnd_1
XFILLER_0_56_15 VPWR VGND VPWR VGND sky130_ef_sc_hd__decap_12
X_2070_ _0884_ _0885_ _0872_ VGND VGND VPWR VPWR _0886_ sky130_fd_sc_hd__mux2_1
X_2972_ clknet_leaf_5_clk _0202_ _0038_ VGND VGND VPWR VPWR imem.address\[13\] sky130_fd_sc_hd__dfrtp_1
X_1923_ _0733_ _0735_ _0719_ _0736_ _0738_ VGND VGND VPWR VPWR _0739_ sky130_fd_sc_hd__o221ai_4
XFILLER_0_56_253 VGND VGND VPWR VPWR sky130_fd_sc_hd__decap_8
X_1854_ _0512_ _0506_ _0508_ VGND VGND VPWR VPWR _0670_ sky130_fd_sc_hd__nand3_1
XFILLER_0_44_437 VPWR VGND VPWR VGND sky130_ef_sc_hd__decap_12
XFILLER_0_31_109 VGND VGND VPWR VPWR sky130_fd_sc_hd__decap_3
X_1785_ _0596_ _0597_ _0599_ _0600_ VGND VGND VPWR VPWR _0601_ sky130_fd_sc_hd__a31o_1
XFILLER_0_21_51 VGND VGND VPWR VPWR sky130_fd_sc_hd__decap_4
XFILLER_0_21_73 VGND VGND VPWR VPWR sky130_fd_sc_hd__fill_1
X_2406_ _1205_ VGND VGND VPWR VPWR _0268_ sky130_fd_sc_hd__clkbuf_1
XFILLER_0_24_194 VGND VGND VPWR VPWR sky130_fd_sc_hd__fill_2
XFILLER_0_12_389 VGND VGND VPWR VPWR sky130_fd_sc_hd__decap_8
X_2268_ reg_file.registers\[11\]\[9\] _0683_ _0685_ reg_file.registers\[10\]\[9\]
+ VGND VGND VPWR VPWR _1080_ sky130_fd_sc_hd__a22o_1
XFILLER_0_46_92 VGND VGND VPWR VPWR sky130_fd_sc_hd__decap_6
X_2199_ _1005_ _1012_ _0910_ VGND VGND VPWR VPWR _1013_ sky130_fd_sc_hd__mux2_1
XFILLER_0_34_3 VPWR VGND VPWR VGND sky130_ef_sc_hd__decap_12
X_2337_ _0472_ _1135_ _1136_ _1144_ VGND VGND VPWR VPWR _1145_ sky130_fd_sc_hd__a31o_1
XTAP_TAPCELL_ROW_63_660 VGND VPWR sky130_fd_sc_hd__tapvpwrvgnd_1
XFILLER_0_62_80 VGND VGND VPWR VPWR sky130_fd_sc_hd__decap_4
XFILLER_0_62_256 VPWR VGND VPWR VGND sky130_ef_sc_hd__decap_12
XFILLER_0_26_29 VPWR VGND VPWR VGND sky130_ef_sc_hd__decap_12
XTAP_TAPCELL_ROW_26_362 VGND VPWR sky130_fd_sc_hd__tapvpwrvgnd_1
XFILLER_0_53_289 VGND VGND VPWR VPWR sky130_fd_sc_hd__decap_4
XFILLER_0_53_223 VGND VGND VPWR VPWR sky130_fd_sc_hd__fill_1
XFILLER_0_26_415 VGND VGND VPWR VPWR sky130_fd_sc_hd__decap_4
XTAP_TAPCELL_ROW_69_708 VGND VPWR sky130_fd_sc_hd__tapvpwrvgnd_1
X_1570_ reg_file.registers\[5\]\[4\] _0414_ VGND VGND VPWR VPWR _0423_ sky130_fd_sc_hd__and2_1
XFILLER_0_21_164 VGND VGND VPWR VPWR sky130_fd_sc_hd__decap_4
XFILLER_0_21_175 VGND VGND VPWR VPWR sky130_fd_sc_hd__fill_1
Xrebuffer17 _0536_ VGND VGND VPWR VPWR net33 sky130_fd_sc_hd__dlymetal6s2s_1
X_2122_ _0936_ VGND VGND VPWR VPWR _0937_ sky130_fd_sc_hd__clkbuf_4
X_2053_ reg_file.registers\[11\]\[16\] _0867_ _0868_ reg_file.registers\[10\]\[16\]
+ VGND VGND VPWR VPWR _0869_ sky130_fd_sc_hd__a22o_1
X_2955_ display.counter\[19\] display.digit_sel\[0\] _1444_ display.digit_sel\[1\]
+ VGND VGND VPWR VPWR _1477_ sky130_fd_sc_hd__a31o_1
XFILLER_0_32_83 VGND VGND VPWR VPWR sky130_fd_sc_hd__fill_1
XFILLER_0_32_61 VGND VGND VPWR VPWR sky130_fd_sc_hd__fill_2
X_2886_ _1465_ VGND VGND VPWR VPWR _0134_ sky130_fd_sc_hd__inv_2
X_1906_ _0652_ _0700_ _0535_ VGND VGND VPWR VPWR _0722_ sky130_fd_sc_hd__a21bo_1
X_1837_ net39 _0531_ VGND VGND VPWR VPWR _0653_ sky130_fd_sc_hd__and2_1
XFILLER_0_32_429 VGND VGND VPWR VPWR sky130_fd_sc_hd__fill_1
XFILLER_0_12_153 VPWR VGND VPWR VGND sky130_ef_sc_hd__decap_12
X_1768_ reg_file.registers\[15\]\[26\] _0569_ _0570_ reg_file.registers\[5\]\[26\]
+ VGND VGND VPWR VPWR _0584_ sky130_fd_sc_hd__a22o_1
X_1699_ _0486_ _0507_ VGND VGND VPWR VPWR _0515_ sky130_fd_sc_hd__or2_1
XFILLER_0_12_197 VPWR VGND VPWR VGND sky130_ef_sc_hd__decap_12
XFILLER_0_67_337 VPWR VGND VPWR VGND sky130_ef_sc_hd__decap_12
XFILLER_0_50_204 VGND VGND VPWR VPWR sky130_fd_sc_hd__fill_1
XFILLER_0_35_234 VGND VGND VPWR VPWR sky130_fd_sc_hd__fill_1
XFILLER_0_35_223 VGND VGND VPWR VPWR sky130_fd_sc_hd__fill_1
XTAP_TAPCELL_ROW_23_343 VGND VPWR sky130_fd_sc_hd__tapvpwrvgnd_1
Xoutput7 net7 VGND VGND VPWR VPWR an[5] sky130_fd_sc_hd__buf_1
XFILLER_0_53_27 VGND VGND VPWR VPWR sky130_fd_sc_hd__decap_8
XFILLER_0_37_39 VPWR VGND VPWR VGND sky130_ef_sc_hd__decap_12
XFILLER_0_26_212 VGND VGND VPWR VPWR sky130_fd_sc_hd__fill_2
X_1622_ reg_file.registers\[10\]\[12\] _0449_ VGND VGND VPWR VPWR _0451_ sky130_fd_sc_hd__and2_1
X_2671_ _0509_ _1219_ _1366_ _1388_ VGND VGND VPWR VPWR _1389_ sky130_fd_sc_hd__a31o_1
XFILLER_0_26_278 VGND VGND VPWR VPWR sky130_fd_sc_hd__decap_6
X_2740_ display.counter\[12\] _1434_ VGND VGND VPWR VPWR _1436_ sky130_fd_sc_hd__and2_1
XFILLER_0_14_418 VGND VGND VPWR VPWR sky130_fd_sc_hd__fill_2
X_1553_ _0392_ VGND VGND VPWR VPWR _0414_ sky130_fd_sc_hd__clkbuf_2
X_1484_ reg_file.registers\[2\]\[4\] VGND VGND VPWR VPWR _0368_ sky130_fd_sc_hd__clkbuf_1
X_2105_ _0663_ _0691_ _0889_ VGND VGND VPWR VPWR _0921_ sky130_fd_sc_hd__mux2_1
XFILLER_0_49_326 VGND VGND VPWR VPWR sky130_fd_sc_hd__decap_8
X_3154_ clknet_leaf_12_clk _0017_ VGND VGND VPWR VPWR display.counter\[19\] sky130_fd_sc_hd__dfxtp_1
X_2036_ reg_file.registers\[10\]\[30\] _0775_ _0776_ reg_file.registers\[11\]\[30\]
+ VGND VGND VPWR VPWR _0852_ sky130_fd_sc_hd__a22o_1
X_3085_ clknet_leaf_16_clk _0308_ _0144_ VGND VGND VPWR VPWR reg_file.registers\[10\]\[23\]
+ sky130_fd_sc_hd__dfrtp_1
XFILLER_0_57_381 VGND VGND VPWR VPWR sky130_fd_sc_hd__decap_8
X_2938_ _1471_ VGND VGND VPWR VPWR _0180_ sky130_fd_sc_hd__inv_2
XFILLER_0_17_256 VGND VGND VPWR VPWR sky130_fd_sc_hd__fill_1
XTAP_TAPCELL_ROW_20_313 VGND VPWR sky130_fd_sc_hd__tapvpwrvgnd_1
XFILLER_0_7_93 VPWR VGND VPWR VGND sky130_ef_sc_hd__decap_12
X_2869_ _1463_ VGND VGND VPWR VPWR _0119_ sky130_fd_sc_hd__inv_2
XTAP_TAPCELL_ROW_71_725 VGND VPWR sky130_fd_sc_hd__tapvpwrvgnd_1
Xrebuffer8 net23 VGND VGND VPWR VPWR net24 sky130_fd_sc_hd__dlygate4sd1_1
XPHY_EDGE_ROW_39_Left_111 VGND VGND VPWR VPWR sky130_fd_sc_hd__decap_3
XFILLER_0_23_204 VGND VGND VPWR VPWR sky130_fd_sc_hd__fill_2
XFILLER_0_2_109 VPWR VGND VPWR VGND sky130_ef_sc_hd__decap_12
XFILLER_0_48_27 VGND VGND VPWR VPWR sky130_fd_sc_hd__fill_1
XFILLER_0_64_15 VPWR VGND VPWR VGND sky130_ef_sc_hd__decap_12
XPHY_EDGE_ROW_48_Left_120 VGND VGND VPWR VPWR sky130_fd_sc_hd__decap_3
XFILLER_0_58_167 VGND VGND VPWR VPWR sky130_fd_sc_hd__decap_4
XTAP_TAPCELL_ROW_42_493 VGND VPWR sky130_fd_sc_hd__tapvpwrvgnd_1
XTAP_TAPCELL_ROW_34_427 VGND VPWR sky130_fd_sc_hd__tapvpwrvgnd_1
X_2723_ display.counter\[4\] display.counter\[5\] _1424_ VGND VGND VPWR VPWR _1426_
+ sky130_fd_sc_hd__and3_1
X_2585_ imem.address\[29\] imem.address\[28\] _1336_ VGND VGND VPWR VPWR _1337_ sky130_fd_sc_hd__and3_1
X_1536_ _0405_ VGND VGND VPWR VPWR _0338_ sky130_fd_sc_hd__clkbuf_1
X_2654_ _1171_ _1363_ _1364_ _1090_ _1372_ VGND VGND VPWR VPWR _1373_ sky130_fd_sc_hd__a221o_1
XFILLER_0_22_281 VGND VGND VPWR VPWR sky130_fd_sc_hd__fill_2
XFILLER_0_10_421 VPWR VGND VPWR VGND sky130_ef_sc_hd__decap_12
X_1605_ reg_file.registers\[10\]\[20\] _0438_ VGND VGND VPWR VPWR _0442_ sky130_fd_sc_hd__and2_1
XFILLER_0_38_93 VGND VGND VPWR VPWR sky130_fd_sc_hd__decap_8
X_3137_ clknet_leaf_14_clk _0019_ VGND VGND VPWR VPWR display.counter\[2\] sky130_fd_sc_hd__dfxtp_1
X_3068_ clknet_leaf_9_clk _0291_ _0127_ VGND VGND VPWR VPWR reg_file.registers\[10\]\[6\]
+ sky130_fd_sc_hd__dfrtp_1
X_2019_ _0831_ _0834_ VGND VGND VPWR VPWR _0835_ sky130_fd_sc_hd__nor2_1
XFILLER_0_60_365 VGND VGND VPWR VPWR sky130_fd_sc_hd__decap_4
XFILLER_0_60_332 VPWR VGND VPWR VGND sky130_ef_sc_hd__decap_12
XFILLER_0_60_321 VGND VGND VPWR VPWR sky130_fd_sc_hd__decap_4
XFILLER_0_9_297 VGND VGND VPWR VPWR sky130_fd_sc_hd__fill_1
XFILLER_0_13_281 VPWR VGND VPWR VGND sky130_ef_sc_hd__decap_12
XFILLER_0_20_207 VPWR VGND VPWR VGND sky130_ef_sc_hd__decap_12
XFILLER_0_68_421 VPWR VGND VPWR VGND sky130_ef_sc_hd__decap_12
XFILLER_0_34_29 VPWR VGND VPWR VGND sky130_ef_sc_hd__decap_12
XTAP_TAPCELL_ROW_5_196 VGND VPWR sky130_fd_sc_hd__tapvpwrvgnd_1
XFILLER_0_36_362 VGND VGND VPWR VPWR sky130_fd_sc_hd__fill_2
XFILLER_0_59_15 VPWR VGND VPWR VGND sky130_ef_sc_hd__decap_12
XFILLER_0_51_332 VGND VGND VPWR VPWR sky130_fd_sc_hd__decap_4
XFILLER_0_3_429 VPWR VGND VPWR VGND sky130_ef_sc_hd__decap_12
XFILLER_0_11_229 VGND VGND VPWR VPWR sky130_fd_sc_hd__fill_1
X_2370_ _0762_ _0768_ _1166_ VGND VGND VPWR VPWR _1173_ sky130_fd_sc_hd__and3_1
XTAP_TAPCELL_ROW_47_530 VGND VPWR sky130_fd_sc_hd__tapvpwrvgnd_1
XFILLER_0_24_73 VGND VGND VPWR VPWR sky130_fd_sc_hd__fill_1
XFILLER_0_19_318 VGND VGND VPWR VPWR sky130_fd_sc_hd__decap_8
XFILLER_0_42_365 VPWR VGND VPWR VGND sky130_ef_sc_hd__decap_12
XFILLER_0_42_321 VGND VGND VPWR VPWR sky130_fd_sc_hd__decap_8
X_2706_ net43 _1407_ VGND VGND VPWR VPWR _1419_ sky130_fd_sc_hd__nand2_1
XFILLER_0_6_245 VGND VGND VPWR VPWR sky130_fd_sc_hd__decap_6
XFILLER_0_6_289 VPWR VGND VPWR VGND sky130_ef_sc_hd__decap_12
XFILLER_0_64_3 VPWR VGND VPWR VGND sky130_ef_sc_hd__decap_12
X_2637_ _1284_ _1359_ VGND VGND VPWR VPWR _0191_ sky130_fd_sc_hd__nor2_1
X_2499_ net1 _1282_ _0481_ VGND VGND VPWR VPWR _1283_ sky130_fd_sc_hd__and3_1
X_2568_ _1320_ VGND VGND VPWR VPWR _0221_ sky130_fd_sc_hd__clkbuf_1
XFILLER_0_10_251 VGND VGND VPWR VPWR sky130_fd_sc_hd__fill_1
XPHY_EDGE_ROW_12_Right_12 VGND VGND VPWR VPWR sky130_fd_sc_hd__decap_3
X_1519_ _0396_ VGND VGND VPWR VPWR _0346_ sky130_fd_sc_hd__clkbuf_1
XFILLER_0_4_83 VGND VGND VPWR VPWR sky130_fd_sc_hd__fill_1
XPHY_EDGE_ROW_21_Right_21 VGND VGND VPWR VPWR sky130_fd_sc_hd__decap_3
XTAP_TAPCELL_ROW_53_577 VGND VPWR sky130_fd_sc_hd__tapvpwrvgnd_1
XFILLER_0_33_387 VGND VGND VPWR VPWR sky130_fd_sc_hd__decap_4
XPHY_EDGE_ROW_30_Right_30 VGND VGND VPWR VPWR sky130_fd_sc_hd__decap_3
XFILLER_0_68_251 VGND VGND VPWR VPWR sky130_fd_sc_hd__fill_1
XFILLER_0_61_27 VGND VGND VPWR VPWR sky130_fd_sc_hd__decap_6
XTAP_TAPCELL_ROW_44_511 VGND VPWR sky130_fd_sc_hd__tapvpwrvgnd_1
XFILLER_0_71_449 VGND VGND VPWR VPWR sky130_fd_sc_hd__fill_2
XFILLER_0_71_405 VPWR VGND VPWR VGND sky130_ef_sc_hd__decap_12
X_1870_ reg_file.registers\[11\]\[3\] _0683_ _0685_ reg_file.registers\[10\]\[3\]
+ VGND VGND VPWR VPWR _0686_ sky130_fd_sc_hd__a22o_1
XFILLER_0_36_170 VPWR VGND VPWR VGND sky130_ef_sc_hd__decap_12
XFILLER_0_9_39 VPWR VGND VPWR VGND sky130_ef_sc_hd__decap_12
X_2422_ reg_file.registers\[11\]\[13\] _1219_ _1158_ VGND VGND VPWR VPWR _1220_ sky130_fd_sc_hd__mux2_1
XFILLER_0_24_365 VGND VGND VPWR VPWR sky130_fd_sc_hd__decap_6
X_2353_ reg_file.registers\[11\]\[21\] _1157_ _1158_ VGND VGND VPWR VPWR _1159_ sky130_fd_sc_hd__mux2_1
XPHY_EDGE_ROW_24_Left_96 VGND VGND VPWR VPWR sky130_fd_sc_hd__decap_3
XFILLER_0_3_237 VPWR VGND VPWR VGND sky130_ef_sc_hd__decap_12
XFILLER_0_10_53 VPWR VGND VPWR VGND sky130_ef_sc_hd__decap_12
XFILLER_0_10_97 VPWR VGND VPWR VGND sky130_ef_sc_hd__decap_12
XFILLER_0_35_50 VGND VGND VPWR VPWR sky130_fd_sc_hd__decap_6
X_2284_ _0897_ _0943_ _0909_ VGND VGND VPWR VPWR _1095_ sky130_fd_sc_hd__a21o_1
XFILLER_0_19_51 VGND VGND VPWR VPWR sky130_fd_sc_hd__decap_4
XFILLER_0_59_273 VGND VGND VPWR VPWR sky130_fd_sc_hd__decap_6
XTAP_TAPCELL_ROW_50_558 VGND VPWR sky130_fd_sc_hd__tapvpwrvgnd_1
XFILLER_0_19_137 VPWR VGND VPWR VGND sky130_ef_sc_hd__decap_12
XFILLER_0_30_302 VGND VGND VPWR VPWR sky130_fd_sc_hd__decap_6
X_1999_ _0813_ _0814_ VGND VGND VPWR VPWR _0815_ sky130_fd_sc_hd__nor2_1
XTAP_TAPCELL_ROW_7_214 VGND VPWR sky130_fd_sc_hd__tapvpwrvgnd_1
XTAP_TAPCELL_ROW_66_680 VGND VPWR sky130_fd_sc_hd__tapvpwrvgnd_1
XFILLER_0_65_265 VGND VGND VPWR VPWR sky130_fd_sc_hd__fill_1
XFILLER_0_65_254 VGND VGND VPWR VPWR sky130_fd_sc_hd__decap_4
XFILLER_0_53_449 VGND VGND VPWR VPWR sky130_fd_sc_hd__fill_2
XFILLER_0_25_129 VGND VGND VPWR VPWR sky130_fd_sc_hd__fill_1
XFILLER_0_25_107 VGND VGND VPWR VPWR sky130_fd_sc_hd__fill_2
XFILLER_0_21_335 VGND VGND VPWR VPWR sky130_fd_sc_hd__fill_1
XFILLER_0_56_27 VGND VGND VPWR VPWR sky130_fd_sc_hd__fill_1
X_2971_ clknet_leaf_5_clk _0201_ _0037_ VGND VGND VPWR VPWR imem.address\[12\] sky130_fd_sc_hd__dfrtp_1
X_1922_ _0708_ _0737_ VGND VGND VPWR VPWR _0738_ sky130_fd_sc_hd__nand2_1
XFILLER_0_56_232 VGND VGND VPWR VPWR sky130_fd_sc_hd__fill_1
XFILLER_0_29_446 VGND VGND VPWR VPWR sky130_fd_sc_hd__fill_2
XFILLER_0_29_402 VGND VGND VPWR VPWR sky130_fd_sc_hd__fill_2
XFILLER_0_8_307 VGND VGND VPWR VPWR sky130_fd_sc_hd__fill_1
XFILLER_0_8_329 VGND VGND VPWR VPWR sky130_fd_sc_hd__fill_1
XFILLER_0_56_298 VGND VGND VPWR VPWR sky130_fd_sc_hd__decap_8
X_1853_ _0667_ _0668_ VGND VGND VPWR VPWR _0669_ sky130_fd_sc_hd__or2_1
XFILLER_0_44_449 VGND VGND VPWR VPWR sky130_fd_sc_hd__fill_2
XFILLER_0_44_416 VGND VGND VPWR VPWR sky130_fd_sc_hd__decap_4
X_1784_ _0556_ _0566_ VGND VGND VPWR VPWR _0600_ sky130_fd_sc_hd__nor2_1
X_2405_ reg_file.registers\[11\]\[15\] _1204_ _1158_ VGND VGND VPWR VPWR _1205_ sky130_fd_sc_hd__mux2_1
X_2336_ _1137_ _1139_ _1143_ VGND VGND VPWR VPWR _1144_ sky130_fd_sc_hd__a21o_1
X_2267_ _1075_ _1078_ _0891_ VGND VGND VPWR VPWR _1079_ sky130_fd_sc_hd__mux2_1
X_2198_ _1008_ _1011_ _0893_ VGND VGND VPWR VPWR _1012_ sky130_fd_sc_hd__mux2_1
XFILLER_0_27_3 VPWR VGND VPWR VGND sky130_ef_sc_hd__decap_12
XFILLER_0_1_51 VGND VGND VPWR VPWR sky130_fd_sc_hd__decap_4
XTAP_TAPCELL_ROW_63_661 VGND VPWR sky130_fd_sc_hd__tapvpwrvgnd_1
XFILLER_0_47_210 VPWR VGND VPWR VGND sky130_ef_sc_hd__decap_12
XFILLER_0_35_449 VGND VGND VPWR VPWR sky130_fd_sc_hd__fill_2
XFILLER_0_35_405 VPWR VGND VPWR VGND sky130_ef_sc_hd__decap_12
XFILLER_0_62_268 VPWR VGND VPWR VGND sky130_ef_sc_hd__decap_12
XFILLER_0_42_29 VPWR VGND VPWR VGND sky130_ef_sc_hd__decap_12
XFILLER_0_38_221 VGND VGND VPWR VPWR sky130_fd_sc_hd__decap_4
XTAP_TAPCELL_ROW_26_363 VGND VPWR sky130_fd_sc_hd__tapvpwrvgnd_1
XTAP_TAPCELL_ROW_69_709 VGND VPWR sky130_fd_sc_hd__tapvpwrvgnd_1
XFILLER_0_67_15 VPWR VGND VPWR VGND sky130_ef_sc_hd__decap_12
XFILLER_0_6_29 VPWR VGND VPWR VGND sky130_ef_sc_hd__decap_12
Xrebuffer18 _0502_ VGND VGND VPWR VPWR net34 sky130_fd_sc_hd__dlygate4sd1_1
X_2121_ reg_file.registers\[5\]\[4\] _0570_ VGND VGND VPWR VPWR _0936_ sky130_fd_sc_hd__and2_1
XFILLER_0_16_41 VPWR VGND VPWR VGND sky130_ef_sc_hd__decap_12
XFILLER_0_16_85 VPWR VGND VPWR VGND sky130_ef_sc_hd__decap_12
X_2052_ _0829_ VGND VGND VPWR VPWR _0868_ sky130_fd_sc_hd__buf_2
X_2885_ _1465_ VGND VGND VPWR VPWR _0133_ sky130_fd_sc_hd__inv_2
X_1905_ _0713_ _0720_ VGND VGND VPWR VPWR _0721_ sky130_fd_sc_hd__and2_1
X_2954_ display.digit_sel\[0\] _1446_ VGND VGND VPWR VPWR _0355_ sky130_fd_sc_hd__xnor2_1
XFILLER_0_29_221 VGND VGND VPWR VPWR sky130_fd_sc_hd__decap_3
XFILLER_0_17_427 VGND VGND VPWR VPWR sky130_fd_sc_hd__decap_4
XFILLER_0_17_449 VGND VGND VPWR VPWR sky130_fd_sc_hd__fill_2
X_1836_ net40 _0531_ VGND VGND VPWR VPWR _0652_ sky130_fd_sc_hd__nor2_1
X_1698_ _0388_ _0378_ _0481_ VGND VGND VPWR VPWR _0514_ sky130_fd_sc_hd__and3_1
XFILLER_0_44_268 VGND VGND VPWR VPWR sky130_fd_sc_hd__decap_3
XFILLER_0_32_419 VGND VGND VPWR VPWR sky130_fd_sc_hd__fill_1
XFILLER_0_4_365 VPWR VGND VPWR VGND sky130_ef_sc_hd__decap_12
XFILLER_0_4_321 VPWR VGND VPWR VGND sky130_ef_sc_hd__decap_12
XPHY_EDGE_ROW_6_Right_6 VGND VGND VPWR VPWR sky130_fd_sc_hd__decap_3
XFILLER_0_12_121 VPWR VGND VPWR VGND sky130_ef_sc_hd__decap_12
XFILLER_0_12_165 VPWR VGND VPWR VGND sky130_ef_sc_hd__decap_12
X_1767_ _0575_ _0577_ _0582_ VGND VGND VPWR VPWR _0583_ sky130_fd_sc_hd__or3_4
X_2319_ _0750_ _1126_ _0766_ VGND VGND VPWR VPWR _1127_ sky130_fd_sc_hd__a21oi_1
XFILLER_0_67_349 VPWR VGND VPWR VGND sky130_ef_sc_hd__decap_12
XPHY_EDGE_ROW_11_Left_83 VGND VGND VPWR VPWR sky130_fd_sc_hd__decap_3
XFILLER_0_7_181 VPWR VGND VPWR VGND sky130_ef_sc_hd__decap_12
Xoutput8 net8 VGND VGND VPWR VPWR an[6] sky130_fd_sc_hd__buf_1
Xoutput10 net10 VGND VGND VPWR VPWR seg[0] sky130_fd_sc_hd__buf_1
XPHY_EDGE_ROW_59_Right_59 VGND VGND VPWR VPWR sky130_fd_sc_hd__decap_3
X_1621_ _0450_ VGND VGND VPWR VPWR _0298_ sky130_fd_sc_hd__clkbuf_1
X_2670_ _1243_ _1368_ _1369_ _1387_ _1371_ VGND VGND VPWR VPWR _1388_ sky130_fd_sc_hd__a221o_1
XFILLER_0_41_205 VGND VGND VPWR VPWR sky130_fd_sc_hd__fill_1
X_1552_ _0413_ VGND VGND VPWR VPWR _0330_ sky130_fd_sc_hd__clkbuf_1
XFILLER_0_26_257 VPWR VGND VPWR VGND sky130_ef_sc_hd__decap_12
XFILLER_0_1_335 VGND VGND VPWR VPWR sky130_fd_sc_hd__fill_1
XPHY_EDGE_ROW_68_Right_68 VGND VGND VPWR VPWR sky130_fd_sc_hd__decap_3
X_2104_ _0704_ _0655_ _0889_ VGND VGND VPWR VPWR _0920_ sky130_fd_sc_hd__mux2_1
X_1483_ _0367_ VGND VGND VPWR VPWR _0353_ sky130_fd_sc_hd__clkbuf_1
X_3153_ clknet_leaf_12_clk _0016_ VGND VGND VPWR VPWR display.counter\[18\] sky130_fd_sc_hd__dfxtp_1
XFILLER_0_49_305 VGND VGND VPWR VPWR sky130_fd_sc_hd__fill_1
X_3084_ clknet_leaf_19_clk _0307_ _0143_ VGND VGND VPWR VPWR reg_file.registers\[10\]\[22\]
+ sky130_fd_sc_hd__dfrtp_1
X_2035_ _0619_ _0849_ _0850_ VGND VGND VPWR VPWR _0851_ sky130_fd_sc_hd__o21ai_1
XFILLER_0_9_446 VGND VGND VPWR VPWR sky130_fd_sc_hd__fill_2
X_2868_ _1463_ VGND VGND VPWR VPWR _0118_ sky130_fd_sc_hd__inv_2
X_2937_ _1471_ VGND VGND VPWR VPWR _0179_ sky130_fd_sc_hd__inv_2
XTAP_TAPCELL_ROW_20_314 VGND VPWR sky130_fd_sc_hd__tapvpwrvgnd_1
X_2799_ _1454_ VGND VGND VPWR VPWR _0058_ sky130_fd_sc_hd__inv_2
X_1819_ reg_file.registers\[10\]\[14\] _0507_ _0607_ reg_file.registers\[11\]\[14\]
+ VGND VGND VPWR VPWR _0635_ sky130_fd_sc_hd__a22o_1
XFILLER_0_4_195 VGND VGND VPWR VPWR sky130_fd_sc_hd__fill_1
XTAP_TAPCELL_ROW_71_726 VGND VPWR sky130_fd_sc_hd__tapvpwrvgnd_1
XFILLER_0_67_179 VPWR VGND VPWR VGND sky130_ef_sc_hd__decap_12
Xrebuffer9 net23 VGND VGND VPWR VPWR net25 sky130_fd_sc_hd__dlygate4sd1_1
XFILLER_0_31_271 VGND VGND VPWR VPWR sky130_fd_sc_hd__decap_8
XFILLER_0_64_27 VGND VGND VPWR VPWR sky130_fd_sc_hd__fill_1
XFILLER_0_58_113 VGND VGND VPWR VPWR sky130_fd_sc_hd__fill_2
XTAP_TAPCELL_ROW_34_428 VGND VPWR sky130_fd_sc_hd__tapvpwrvgnd_1
XFILLER_0_54_363 VGND VGND VPWR VPWR sky130_fd_sc_hd__fill_1
XTAP_TAPCELL_ROW_42_494 VGND VPWR sky130_fd_sc_hd__tapvpwrvgnd_1
XFILLER_0_39_393 VPWR VGND VPWR VGND sky130_ef_sc_hd__decap_12
XFILLER_0_39_371 VGND VGND VPWR VPWR sky130_fd_sc_hd__decap_8
X_2722_ display.counter\[4\] _1424_ VGND VGND VPWR VPWR _0021_ sky130_fd_sc_hd__xor2_1
X_2584_ imem.address\[27\] _1335_ VGND VGND VPWR VPWR _1336_ sky130_fd_sc_hd__and2_1
X_2653_ _1204_ _1366_ _1370_ _1371_ VGND VGND VPWR VPWR _1372_ sky130_fd_sc_hd__a211o_1
X_1535_ reg_file.registers\[5\]\[21\] _0403_ VGND VGND VPWR VPWR _0405_ sky130_fd_sc_hd__and2_1
X_1604_ _0441_ VGND VGND VPWR VPWR _0306_ sky130_fd_sc_hd__clkbuf_1
X_3067_ clknet_leaf_9_clk _0290_ _0126_ VGND VGND VPWR VPWR reg_file.registers\[10\]\[5\]
+ sky130_fd_sc_hd__dfrtp_1
X_3136_ clknet_leaf_15_clk _0018_ VGND VGND VPWR VPWR display.counter\[1\] sky130_fd_sc_hd__dfxtp_1
XFILLER_0_54_93 VPWR VGND VPWR VGND sky130_ef_sc_hd__decap_12
XFILLER_0_49_113 VGND VGND VPWR VPWR sky130_fd_sc_hd__fill_1
X_2018_ _0832_ _0833_ VGND VGND VPWR VPWR _0834_ sky130_fd_sc_hd__nand2_1
XFILLER_0_60_344 VPWR VGND VPWR VGND sky130_ef_sc_hd__decap_12
XFILLER_0_20_219 VPWR VGND VPWR VGND sky130_ef_sc_hd__decap_12
XFILLER_0_13_293 VGND VGND VPWR VPWR sky130_fd_sc_hd__decap_8
XFILLER_0_68_433 VPWR VGND VPWR VGND sky130_ef_sc_hd__decap_12
XTAP_TAPCELL_ROW_5_197 VGND VPWR sky130_fd_sc_hd__tapvpwrvgnd_1
XFILLER_0_50_29 VPWR VGND VPWR VGND sky130_ef_sc_hd__decap_12
XFILLER_0_59_27 VGND VGND VPWR VPWR sky130_fd_sc_hd__decap_4
XTAP_TAPCELL_ROW_47_531 VGND VPWR sky130_fd_sc_hd__tapvpwrvgnd_1
XFILLER_0_24_85 VGND VGND VPWR VPWR sky130_fd_sc_hd__fill_2
XFILLER_0_24_41 VPWR VGND VPWR VGND sky130_ef_sc_hd__decap_12
X_2636_ net1 _1282_ _0372_ VGND VGND VPWR VPWR _1359_ sky130_fd_sc_hd__a21oi_1
XFILLER_0_42_377 VGND VGND VPWR VPWR sky130_fd_sc_hd__fill_1
X_2705_ net43 _1402_ _1418_ _1377_ VGND VGND VPWR VPWR _0004_ sky130_fd_sc_hd__a2bb2o_1
X_2498_ prev_control VGND VGND VPWR VPWR _1282_ sky130_fd_sc_hd__inv_2
XFILLER_0_57_3 VPWR VGND VPWR VGND sky130_ef_sc_hd__decap_12
X_2567_ reg_file.registers\[15\]\[0\] _1286_ VGND VGND VPWR VPWR _1320_ sky130_fd_sc_hd__or2b_1
XFILLER_0_49_71 VPWR VGND VPWR VGND sky130_ef_sc_hd__decap_12
X_1518_ reg_file.registers\[5\]\[29\] _0393_ VGND VGND VPWR VPWR _0396_ sky130_fd_sc_hd__and2_1
X_3119_ clknet_leaf_0_clk _0342_ _0178_ VGND VGND VPWR VPWR reg_file.registers\[5\]\[25\]
+ sky130_fd_sc_hd__dfrtp_1
XPHY_EDGE_ROW_67_Left_139 VGND VGND VPWR VPWR sky130_fd_sc_hd__decap_3
XFILLER_0_65_447 VGND VGND VPWR VPWR sky130_fd_sc_hd__fill_1
XTAP_TAPCELL_ROW_53_578 VGND VPWR sky130_fd_sc_hd__tapvpwrvgnd_1
XFILLER_0_52_119 VGND VGND VPWR VPWR sky130_fd_sc_hd__fill_1
XFILLER_0_37_116 VGND VGND VPWR VPWR sky130_fd_sc_hd__decap_6
XFILLER_0_37_105 VGND VGND VPWR VPWR sky130_fd_sc_hd__decap_6
XFILLER_0_60_141 VGND VGND VPWR VPWR sky130_fd_sc_hd__decap_6
XFILLER_0_28_138 VGND VGND VPWR VPWR sky130_fd_sc_hd__fill_2
XFILLER_0_71_417 VGND VGND VPWR VPWR sky130_fd_sc_hd__decap_3
XFILLER_0_36_182 VGND VGND VPWR VPWR sky130_fd_sc_hd__decap_4
XFILLER_0_24_377 VGND VGND VPWR VPWR sky130_fd_sc_hd__fill_1
XFILLER_0_24_344 VPWR VGND VPWR VGND sky130_ef_sc_hd__decap_12
XFILLER_0_24_322 VGND VGND VPWR VPWR sky130_fd_sc_hd__decap_4
XFILLER_0_3_249 VPWR VGND VPWR VGND sky130_ef_sc_hd__decap_12
XFILLER_0_3_205 VPWR VGND VPWR VGND sky130_ef_sc_hd__decap_12
X_2421_ _0471_ _1211_ _1212_ _1056_ _1218_ VGND VGND VPWR VPWR _1219_ sky130_fd_sc_hd__a32o_1
X_2283_ _0866_ _1093_ VGND VGND VPWR VPWR _1094_ sky130_fd_sc_hd__or2_1
X_2352_ _0932_ VGND VGND VPWR VPWR _1158_ sky130_fd_sc_hd__clkbuf_4
XFILLER_0_10_65 VPWR VGND VPWR VGND sky130_ef_sc_hd__decap_12
XTAP_TAPCELL_ROW_50_559 VGND VPWR sky130_fd_sc_hd__tapvpwrvgnd_1
XFILLER_0_47_447 VGND VGND VPWR VPWR sky130_fd_sc_hd__fill_1
X_2619_ imem.address\[12\] _1325_ VGND VGND VPWR VPWR _1352_ sky130_fd_sc_hd__nor2_1
XFILLER_0_30_325 VGND VGND VPWR VPWR sky130_fd_sc_hd__fill_1
X_1998_ reg_file.registers\[10\]\[25\] _0775_ _0776_ reg_file.registers\[11\]\[25\]
+ VGND VGND VPWR VPWR _0814_ sky130_fd_sc_hd__a22o_1
XTAP_TAPCELL_ROW_7_215 VGND VPWR sky130_fd_sc_hd__tapvpwrvgnd_1
XTAP_TAPCELL_ROW_66_681 VGND VPWR sky130_fd_sc_hd__tapvpwrvgnd_1
XFILLER_0_65_200 VGND VGND VPWR VPWR sky130_fd_sc_hd__decap_3
XFILLER_0_21_303 VPWR VGND VPWR VGND sky130_ef_sc_hd__decap_12
XFILLER_0_21_369 VGND VGND VPWR VPWR sky130_fd_sc_hd__fill_2
XFILLER_0_71_225 VPWR VGND VPWR VGND sky130_ef_sc_hd__decap_12
X_2970_ clknet_leaf_5_clk _0200_ _0036_ VGND VGND VPWR VPWR imem.address\[11\] sky130_fd_sc_hd__dfrtp_1
X_1921_ reg_file.registers\[10\]\[11\] _0603_ _0608_ reg_file.registers\[11\]\[11\]
+ VGND VGND VPWR VPWR _0737_ sky130_fd_sc_hd__a22o_1
X_1852_ reg_file.registers\[10\]\[2\] _0620_ _0622_ reg_file.registers\[11\]\[2\]
+ VGND VGND VPWR VPWR _0668_ sky130_fd_sc_hd__a22o_1
XFILLER_0_29_425 VGND VGND VPWR VPWR sky130_fd_sc_hd__fill_2
X_1783_ reg_file.registers\[10\]\[30\] _0492_ _0598_ VGND VGND VPWR VPWR _0599_ sky130_fd_sc_hd__a21oi_1
XFILLER_0_24_163 VGND VGND VPWR VPWR sky130_fd_sc_hd__fill_1
XTAP_TAPCELL_ROW_12_250 VGND VPWR sky130_fd_sc_hd__tapvpwrvgnd_1
X_2266_ _1076_ _1077_ _0878_ VGND VGND VPWR VPWR _1078_ sky130_fd_sc_hd__mux2_1
X_2404_ _0471_ _1195_ _1196_ _1203_ _0940_ VGND VGND VPWR VPWR _1204_ sky130_fd_sc_hd__a32o_1
X_2335_ _0895_ _1140_ _1141_ _1142_ VGND VGND VPWR VPWR _1143_ sky130_fd_sc_hd__a22o_1
XTAP_TAPCELL_ROW_63_662 VGND VPWR sky130_fd_sc_hd__tapvpwrvgnd_1
XFILLER_0_62_60 VPWR VGND VPWR VGND sky130_ef_sc_hd__decap_12
XFILLER_0_47_222 VGND VGND VPWR VPWR sky130_fd_sc_hd__fill_2
XFILLER_0_46_83 VGND VGND VPWR VPWR sky130_fd_sc_hd__fill_1
X_2197_ _1009_ _1010_ _0902_ VGND VGND VPWR VPWR _1011_ sky130_fd_sc_hd__mux2_1
XFILLER_0_50_409 VGND VGND VPWR VPWR sky130_fd_sc_hd__decap_8
XFILLER_0_47_233 VGND VGND VPWR VPWR sky130_fd_sc_hd__decap_4
XFILLER_0_35_417 VGND VGND VPWR VPWR sky130_fd_sc_hd__fill_1
XFILLER_0_7_363 VPWR VGND VPWR VGND sky130_ef_sc_hd__decap_12
XFILLER_0_30_166 VPWR VGND VPWR VGND sky130_ef_sc_hd__decap_12
XFILLER_0_30_133 VGND VGND VPWR VPWR sky130_fd_sc_hd__fill_1
XFILLER_0_11_391 VGND VGND VPWR VPWR sky130_fd_sc_hd__fill_1
XFILLER_0_53_214 VGND VGND VPWR VPWR sky130_fd_sc_hd__decap_4
XTAP_TAPCELL_ROW_26_364 VGND VPWR sky130_fd_sc_hd__tapvpwrvgnd_1
XFILLER_0_53_225 VPWR VGND VPWR VGND sky130_ef_sc_hd__decap_12
XFILLER_0_41_409 VPWR VGND VPWR VGND sky130_ef_sc_hd__decap_12
XFILLER_0_21_111 VGND VGND VPWR VPWR sky130_fd_sc_hd__fill_1
XFILLER_0_67_27 VPWR VGND VPWR VGND sky130_ef_sc_hd__decap_12
X_2120_ _0616_ _0851_ _0854_ VGND VGND VPWR VPWR _0935_ sky130_fd_sc_hd__nand3_1
Xrebuffer19 net34 VGND VGND VPWR VPWR net35 sky130_fd_sc_hd__dlygate4sd1_1
XFILLER_0_16_53 VPWR VGND VPWR VGND sky130_ef_sc_hd__decap_12
XFILLER_0_16_97 VGND VGND VPWR VPWR sky130_fd_sc_hd__decap_3
X_2051_ _0828_ VGND VGND VPWR VPWR _0867_ sky130_fd_sc_hd__buf_2
XFILLER_0_69_391 VGND VGND VPWR VPWR sky130_fd_sc_hd__fill_1
X_2884_ _1465_ VGND VGND VPWR VPWR _0132_ sky130_fd_sc_hd__inv_2
X_1904_ reg_file.registers\[10\]\[9\] _0603_ _0608_ reg_file.registers\[11\]\[9\]
+ VGND VGND VPWR VPWR _0720_ sky130_fd_sc_hd__a22o_1
XTAP_TAPCELL_ROW_60_632 VGND VPWR sky130_fd_sc_hd__tapvpwrvgnd_1
X_1835_ _0646_ _0644_ _0637_ _0650_ VGND VGND VPWR VPWR _0651_ sky130_fd_sc_hd__or4b_4
X_2953_ _1476_ VGND VGND VPWR VPWR _0190_ sky130_fd_sc_hd__inv_2
XFILLER_0_32_41 VGND VGND VPWR VPWR sky130_fd_sc_hd__decap_6
XFILLER_0_4_333 VPWR VGND VPWR VGND sky130_ef_sc_hd__decap_12
X_1697_ _0506_ _0508_ _0512_ VGND VGND VPWR VPWR _0513_ sky130_fd_sc_hd__a21o_1
XFILLER_0_4_377 VPWR VGND VPWR VGND sky130_ef_sc_hd__decap_12
XFILLER_0_12_133 VGND VGND VPWR VPWR sky130_fd_sc_hd__decap_6
XFILLER_0_12_177 VPWR VGND VPWR VGND sky130_ef_sc_hd__decap_12
X_1766_ _0579_ _0581_ VGND VGND VPWR VPWR _0582_ sky130_fd_sc_hd__or2_1
X_2249_ reg_file.registers\[11\]\[14\] _0867_ _0868_ reg_file.registers\[10\]\[14\]
+ VGND VGND VPWR VPWR _1061_ sky130_fd_sc_hd__a22o_1
X_2318_ _0764_ _0765_ VGND VGND VPWR VPWR _1126_ sky130_fd_sc_hd__nand2_1
XFILLER_0_7_193 VPWR VGND VPWR VGND sky130_ef_sc_hd__decap_12
Xoutput9 net9 VGND VGND VPWR VPWR an[7] sky130_fd_sc_hd__buf_1
Xoutput11 net11 VGND VGND VPWR VPWR seg[1] sky130_fd_sc_hd__buf_1
XFILLER_0_9_3 VPWR VGND VPWR VGND sky130_ef_sc_hd__decap_12
XFILLER_0_66_361 VGND VGND VPWR VPWR sky130_fd_sc_hd__decap_3
XFILLER_0_26_269 VGND VGND VPWR VPWR sky130_fd_sc_hd__decap_4
X_1620_ reg_file.registers\[10\]\[13\] _0449_ VGND VGND VPWR VPWR _0450_ sky130_fd_sc_hd__and2_1
X_1551_ reg_file.registers\[5\]\[13\] _0403_ VGND VGND VPWR VPWR _0413_ sky130_fd_sc_hd__and2_1
X_1482_ reg_file.registers\[2\]\[30\] VGND VGND VPWR VPWR _0367_ sky130_fd_sc_hd__clkbuf_1
X_2103_ _0915_ _0918_ _0898_ VGND VGND VPWR VPWR _0919_ sky130_fd_sc_hd__mux2_1
X_3152_ clknet_leaf_12_clk _0015_ VGND VGND VPWR VPWR display.counter\[17\] sky130_fd_sc_hd__dfxtp_1
X_3083_ clknet_leaf_18_clk _0306_ _0142_ VGND VGND VPWR VPWR reg_file.registers\[10\]\[21\]
+ sky130_fd_sc_hd__dfrtp_1
XFILLER_0_43_51 VGND VGND VPWR VPWR sky130_fd_sc_hd__decap_4
XTAP_TAPCELL_ROW_37_448 VGND VPWR sky130_fd_sc_hd__tapvpwrvgnd_1
X_2034_ _0614_ _0615_ VGND VGND VPWR VPWR _0850_ sky130_fd_sc_hd__xor2_1
X_2798_ _1454_ VGND VGND VPWR VPWR _0057_ sky130_fd_sc_hd__inv_2
X_1818_ _0631_ _0633_ _0632_ VGND VGND VPWR VPWR _0634_ sky130_fd_sc_hd__and3b_1
X_2936_ _1471_ VGND VGND VPWR VPWR _0178_ sky130_fd_sc_hd__inv_2
XFILLER_0_4_141 VPWR VGND VPWR VGND sky130_ef_sc_hd__decap_12
X_2867_ _1463_ VGND VGND VPWR VPWR _0117_ sky130_fd_sc_hd__inv_2
XFILLER_0_13_442 VGND VGND VPWR VPWR sky130_fd_sc_hd__decap_6
XTAP_TAPCELL_ROW_20_315 VGND VPWR sky130_fd_sc_hd__tapvpwrvgnd_1
XFILLER_0_40_250 VGND VGND VPWR VPWR sky130_fd_sc_hd__fill_2
X_1749_ _0564_ _0562_ _0559_ VGND VGND VPWR VPWR _0565_ sky130_fd_sc_hd__or3_4
XFILLER_0_7_51 VGND VGND VPWR VPWR sky130_fd_sc_hd__decap_4
XTAP_TAPCELL_ROW_71_727 VGND VPWR sky130_fd_sc_hd__tapvpwrvgnd_1
XFILLER_0_67_169 VGND VGND VPWR VPWR sky130_fd_sc_hd__decap_4
XFILLER_0_63_386 VGND VGND VPWR VPWR sky130_fd_sc_hd__decap_6
XFILLER_0_48_29 VGND VGND VPWR VPWR sky130_fd_sc_hd__decap_3
XFILLER_0_31_250 VPWR VGND VPWR VGND sky130_ef_sc_hd__decap_12
XFILLER_0_46_309 VPWR VGND VPWR VGND sky130_ef_sc_hd__decap_12
XTAP_TAPCELL_ROW_34_429 VGND VPWR sky130_fd_sc_hd__tapvpwrvgnd_1
XTAP_TAPCELL_ROW_42_495 VGND VPWR sky130_fd_sc_hd__tapvpwrvgnd_1
X_2652_ display.digit_sel\[2\] _1362_ VGND VGND VPWR VPWR _1371_ sky130_fd_sc_hd__and2b_2
X_2721_ _1424_ _1425_ VGND VGND VPWR VPWR _0020_ sky130_fd_sc_hd__nor2_1
X_2583_ imem.address\[26\] imem.address\[25\] _1334_ VGND VGND VPWR VPWR _1335_ sky130_fd_sc_hd__and3_1
X_1534_ _0404_ VGND VGND VPWR VPWR _0339_ sky130_fd_sc_hd__clkbuf_1
XFILLER_0_1_111 VGND VGND VPWR VPWR sky130_fd_sc_hd__fill_1
X_1603_ reg_file.registers\[10\]\[21\] _0438_ VGND VGND VPWR VPWR _0441_ sky130_fd_sc_hd__and2_1
X_3066_ clknet_leaf_6_clk _0289_ _0125_ VGND VGND VPWR VPWR reg_file.registers\[10\]\[4\]
+ sky130_fd_sc_hd__dfrtp_2
XFILLER_0_54_83 VGND VGND VPWR VPWR sky130_fd_sc_hd__fill_1
X_3135_ clknet_leaf_15_clk _0007_ VGND VGND VPWR VPWR display.counter\[0\] sky130_fd_sc_hd__dfxtp_1
X_2017_ reg_file.registers\[10\]\[26\] _0605_ _0610_ reg_file.registers\[11\]\[26\]
+ VGND VGND VPWR VPWR _0833_ sky130_fd_sc_hd__a22o_1
XFILLER_0_64_128 VPWR VGND VPWR VGND sky130_ef_sc_hd__decap_12
XFILLER_0_49_169 VGND VGND VPWR VPWR sky130_fd_sc_hd__decap_6
X_2919_ _1468_ VGND VGND VPWR VPWR _1470_ sky130_fd_sc_hd__buf_4
XFILLER_0_60_356 VGND VGND VPWR VPWR sky130_fd_sc_hd__decap_8
XFILLER_0_45_386 VGND VGND VPWR VPWR sky130_fd_sc_hd__decap_6
XFILLER_0_68_445 VGND VGND VPWR VPWR sky130_fd_sc_hd__decap_6
XFILLER_0_68_401 VPWR VGND VPWR VGND sky130_ef_sc_hd__decap_12
XFILLER_0_28_309 VGND VGND VPWR VPWR sky130_fd_sc_hd__decap_3
XTAP_TAPCELL_ROW_5_198 VGND VPWR sky130_fd_sc_hd__tapvpwrvgnd_1
XFILLER_0_63_172 VGND VGND VPWR VPWR sky130_fd_sc_hd__decap_4
XFILLER_0_51_301 VGND VGND VPWR VPWR sky130_fd_sc_hd__decap_3
XFILLER_0_48_191 VGND VGND VPWR VPWR sky130_fd_sc_hd__decap_4
XFILLER_0_36_397 VGND VGND VPWR VPWR sky130_fd_sc_hd__decap_4
XFILLER_0_36_342 VPWR VGND VPWR VGND sky130_ef_sc_hd__decap_12
XFILLER_0_59_39 VGND VGND VPWR VPWR sky130_fd_sc_hd__decap_3
XTAP_TAPCELL_ROW_47_532 VGND VPWR sky130_fd_sc_hd__tapvpwrvgnd_1
XFILLER_0_59_445 VGND VGND VPWR VPWR sky130_fd_sc_hd__decap_3
XFILLER_0_46_128 VGND VGND VPWR VPWR sky130_fd_sc_hd__fill_1
XFILLER_0_39_180 VGND VGND VPWR VPWR sky130_fd_sc_hd__fill_2
XFILLER_0_24_97 VGND VGND VPWR VPWR sky130_fd_sc_hd__decap_8
XFILLER_0_24_53 VPWR VGND VPWR VGND sky130_ef_sc_hd__decap_12
X_2635_ _1283_ _1358_ VGND VGND VPWR VPWR _0192_ sky130_fd_sc_hd__nor2_1
XFILLER_0_42_389 VPWR VGND VPWR VGND sky130_ef_sc_hd__decap_12
XFILLER_0_40_85 VGND VGND VPWR VPWR sky130_fd_sc_hd__fill_1
X_2704_ _1382_ _1383_ _1393_ _1401_ VGND VGND VPWR VPWR _1418_ sky130_fd_sc_hd__a31o_1
X_2497_ _1281_ VGND VGND VPWR VPWR _0253_ sky130_fd_sc_hd__clkbuf_1
XFILLER_0_49_83 VGND VGND VPWR VPWR sky130_fd_sc_hd__decap_6
X_2566_ _1319_ VGND VGND VPWR VPWR _0222_ sky130_fd_sc_hd__clkbuf_1
X_1517_ _0395_ VGND VGND VPWR VPWR _0347_ sky130_fd_sc_hd__clkbuf_1
XFILLER_0_4_85 VPWR VGND VPWR VGND sky130_ef_sc_hd__decap_12
XFILLER_0_4_41 VPWR VGND VPWR VGND sky130_ef_sc_hd__decap_12
XFILLER_0_10_253 VGND VGND VPWR VPWR sky130_fd_sc_hd__decap_6
XFILLER_0_65_82 VGND VGND VPWR VPWR sky130_fd_sc_hd__decap_6
X_3049_ clknet_leaf_17_clk _0272_ _0108_ VGND VGND VPWR VPWR reg_file.registers\[11\]\[19\]
+ sky130_fd_sc_hd__dfrtp_1
XTAP_TAPCELL_ROW_2_168 VGND VPWR sky130_fd_sc_hd__tapvpwrvgnd_1
X_3118_ clknet_leaf_20_clk _0341_ _0177_ VGND VGND VPWR VPWR reg_file.registers\[5\]\[24\]
+ sky130_fd_sc_hd__dfrtp_1
XTAP_TAPCELL_ROW_53_579 VGND VPWR sky130_fd_sc_hd__tapvpwrvgnd_1
XFILLER_0_18_331 VGND VGND VPWR VPWR sky130_fd_sc_hd__decap_3
XFILLER_0_60_197 VGND VGND VPWR VPWR sky130_fd_sc_hd__fill_1
XFILLER_0_68_253 VPWR VGND VPWR VGND sky130_ef_sc_hd__decap_12
XFILLER_0_28_106 VPWR VGND VPWR VGND sky130_ef_sc_hd__decap_12
XFILLER_0_51_142 VGND VGND VPWR VPWR sky130_fd_sc_hd__decap_4
X_2420_ _1214_ _1217_ _0866_ VGND VGND VPWR VPWR _1218_ sky130_fd_sc_hd__mux2_1
XFILLER_0_36_194 VGND VGND VPWR VPWR sky130_fd_sc_hd__fill_2
XFILLER_0_24_356 VGND VGND VPWR VPWR sky130_fd_sc_hd__decap_8
XFILLER_0_3_217 VGND VGND VPWR VPWR sky130_fd_sc_hd__decap_6
XFILLER_0_10_77 VGND VGND VPWR VPWR sky130_fd_sc_hd__decap_6
X_2282_ _0974_ _0946_ _0665_ VGND VGND VPWR VPWR _1093_ sky130_fd_sc_hd__mux2_1
X_2351_ _0471_ _1153_ _1154_ _1156_ VGND VGND VPWR VPWR _1157_ sky130_fd_sc_hd__a31o_1
XFILLER_0_51_95 VGND VGND VPWR VPWR sky130_fd_sc_hd__fill_1
XFILLER_0_47_415 VPWR VGND VPWR VGND sky130_ef_sc_hd__decap_12
X_1997_ _0812_ _0581_ _0583_ VGND VGND VPWR VPWR _0813_ sky130_fd_sc_hd__a21bo_1
X_2618_ imem.address\[13\] _1326_ VGND VGND VPWR VPWR _0202_ sky130_fd_sc_hd__xor2_1
X_2549_ reg_file.registers\[15\]\[9\] _1304_ VGND VGND VPWR VPWR _1311_ sky130_fd_sc_hd__and2_1
XFILLER_0_30_359 VGND VGND VPWR VPWR sky130_fd_sc_hd__decap_4
XTAP_TAPCELL_ROW_58_616 VGND VPWR sky130_fd_sc_hd__tapvpwrvgnd_1
XTAP_TAPCELL_ROW_66_682 VGND VPWR sky130_fd_sc_hd__tapvpwrvgnd_1
XFILLER_0_0_209 VPWR VGND VPWR VGND sky130_ef_sc_hd__decap_12
XFILLER_0_21_315 VGND VGND VPWR VPWR sky130_fd_sc_hd__fill_1
XFILLER_0_21_337 VGND VGND VPWR VPWR sky130_fd_sc_hd__decap_8
XTAP_TAPCELL_ROW_29_384 VGND VPWR sky130_fd_sc_hd__tapvpwrvgnd_1
XFILLER_0_71_237 VPWR VGND VPWR VGND sky130_ef_sc_hd__decap_12
X_1920_ _0721_ _0727_ VGND VGND VPWR VPWR _0736_ sky130_fd_sc_hd__and2b_1
X_1851_ _0665_ _0666_ VGND VGND VPWR VPWR _0667_ sky130_fd_sc_hd__xnor2_1
XFILLER_0_8_309 VPWR VGND VPWR VGND sky130_ef_sc_hd__decap_12
XTAP_TAPCELL_ROW_12_251 VGND VPWR sky130_fd_sc_hd__tapvpwrvgnd_1
X_2403_ _1199_ _1202_ _0910_ VGND VGND VPWR VPWR _1203_ sky130_fd_sc_hd__mux2_1
X_1782_ reg_file.registers\[15\]\[30\] _0569_ _0494_ reg_file.registers\[2\]\[30\]
+ VGND VGND VPWR VPWR _0598_ sky130_fd_sc_hd__a22o_1
XFILLER_0_24_186 VGND VGND VPWR VPWR sky130_fd_sc_hd__decap_8
XFILLER_0_12_359 VGND VGND VPWR VPWR sky130_fd_sc_hd__decap_4
X_2265_ reg_file.registers\[11\]\[6\] _0828_ _0829_ reg_file.registers\[10\]\[6\]
+ VGND VGND VPWR VPWR _1077_ sky130_fd_sc_hd__a22o_1
X_2196_ _0963_ _0681_ _0871_ VGND VGND VPWR VPWR _1010_ sky130_fd_sc_hd__mux2_1
X_2334_ _1086_ _1063_ _0894_ VGND VGND VPWR VPWR _1142_ sky130_fd_sc_hd__mux2_1
XTAP_TAPCELL_ROW_63_663 VGND VPWR sky130_fd_sc_hd__tapvpwrvgnd_1
XFILLER_0_62_72 VGND VGND VPWR VPWR sky130_fd_sc_hd__fill_1
XFILLER_0_7_375 VPWR VGND VPWR VGND sky130_ef_sc_hd__decap_12
XFILLER_0_15_142 VGND VGND VPWR VPWR sky130_fd_sc_hd__decap_6
XFILLER_0_15_164 VGND VGND VPWR VPWR sky130_fd_sc_hd__decap_4
XFILLER_0_30_178 VPWR VGND VPWR VGND sky130_ef_sc_hd__decap_12
XFILLER_0_53_237 VGND VGND VPWR VPWR sky130_fd_sc_hd__decap_4
XTAP_TAPCELL_ROW_26_365 VGND VPWR sky130_fd_sc_hd__tapvpwrvgnd_1
XFILLER_0_67_39 VPWR VGND VPWR VGND sky130_ef_sc_hd__decap_12
XFILLER_0_21_156 VGND VGND VPWR VPWR sky130_fd_sc_hd__decap_3
X_2050_ _0657_ VGND VGND VPWR VPWR _0866_ sky130_fd_sc_hd__buf_2
X_2952_ _1476_ VGND VGND VPWR VPWR _0189_ sky130_fd_sc_hd__inv_2
XFILLER_0_16_65 VPWR VGND VPWR VGND sky130_ef_sc_hd__decap_12
X_2883_ _1465_ VGND VGND VPWR VPWR _0131_ sky130_fd_sc_hd__inv_2
XTAP_TAPCELL_ROW_60_633 VGND VPWR sky130_fd_sc_hd__tapvpwrvgnd_1
X_1903_ _0710_ _0715_ _0718_ VGND VGND VPWR VPWR _0719_ sky130_fd_sc_hd__or3b_4
XFILLER_0_52_281 VGND VGND VPWR VPWR sky130_fd_sc_hd__fill_1
XFILLER_0_44_248 VGND VGND VPWR VPWR sky130_fd_sc_hd__decap_4
XFILLER_0_44_226 VPWR VGND VPWR VGND sky130_ef_sc_hd__decap_12
X_1834_ _0648_ _0649_ VGND VGND VPWR VPWR _0650_ sky130_fd_sc_hd__xor2_1
XFILLER_0_32_53 VGND VGND VPWR VPWR sky130_fd_sc_hd__decap_8
X_1765_ net31 _0580_ VGND VGND VPWR VPWR _0581_ sky130_fd_sc_hd__and2_1
XFILLER_0_4_345 VPWR VGND VPWR VGND sky130_ef_sc_hd__decap_12
XFILLER_0_4_301 VGND VGND VPWR VPWR sky130_fd_sc_hd__decap_6
XFILLER_0_8_139 VGND VGND VPWR VPWR sky130_fd_sc_hd__fill_1
X_1696_ _0509_ _0510_ _0511_ VGND VGND VPWR VPWR _0512_ sky130_fd_sc_hd__a21o_2
XFILLER_0_4_389 VPWR VGND VPWR VGND sky130_ef_sc_hd__decap_12
XFILLER_0_12_189 VGND VGND VPWR VPWR sky130_fd_sc_hd__decap_6
XTAP_TAPCELL_ROW_68_700 VGND VPWR sky130_fd_sc_hd__tapvpwrvgnd_1
X_2248_ reg_file.registers\[11\]\[15\] _0867_ _0868_ reg_file.registers\[10\]\[15\]
+ VGND VGND VPWR VPWR _1060_ sky130_fd_sc_hd__a22o_1
X_2179_ _0866_ _0992_ VGND VGND VPWR VPWR _0993_ sky130_fd_sc_hd__or2_1
XFILLER_0_32_3 VPWR VGND VPWR VGND sky130_ef_sc_hd__decap_12
X_2317_ _1125_ VGND VGND VPWR VPWR _0277_ sky130_fd_sc_hd__clkbuf_1
XFILLER_0_35_215 VGND VGND VPWR VPWR sky130_fd_sc_hd__decap_8
XFILLER_0_35_204 VGND VGND VPWR VPWR sky130_fd_sc_hd__decap_4
XFILLER_0_43_281 VPWR VGND VPWR VGND sky130_ef_sc_hd__decap_12
XFILLER_0_7_161 VGND VGND VPWR VPWR sky130_fd_sc_hd__decap_6
Xoutput12 net12 VGND VGND VPWR VPWR seg[2] sky130_fd_sc_hd__buf_1
XFILLER_0_34_270 VPWR VGND VPWR VGND sky130_ef_sc_hd__decap_12
X_1550_ _0412_ VGND VGND VPWR VPWR _0331_ sky130_fd_sc_hd__clkbuf_1
X_1481_ _0366_ VGND VGND VPWR VPWR _0354_ sky130_fd_sc_hd__clkbuf_1
XFILLER_0_1_337 VPWR VGND VPWR VGND sky130_ef_sc_hd__decap_12
X_2102_ _0916_ _0917_ _0903_ VGND VGND VPWR VPWR _0918_ sky130_fd_sc_hd__mux2_1
X_3151_ clknet_leaf_12_clk _0014_ VGND VGND VPWR VPWR display.counter\[16\] sky130_fd_sc_hd__dfxtp_1
X_3082_ clknet_leaf_19_clk _0305_ _0141_ VGND VGND VPWR VPWR reg_file.registers\[10\]\[20\]
+ sky130_fd_sc_hd__dfrtp_1
X_2033_ _0824_ _0841_ _0846_ _0848_ VGND VGND VPWR VPWR _0849_ sky130_fd_sc_hd__o211a_1
XFILLER_0_43_85 VPWR VGND VPWR VGND sky130_ef_sc_hd__decap_12
XTAP_TAPCELL_ROW_37_449 VGND VPWR sky130_fd_sc_hd__tapvpwrvgnd_1
XFILLER_0_9_426 VGND VGND VPWR VPWR sky130_fd_sc_hd__fill_1
X_2935_ _1471_ VGND VGND VPWR VPWR _0177_ sky130_fd_sc_hd__inv_2
X_2797_ _1450_ VGND VGND VPWR VPWR _1454_ sky130_fd_sc_hd__buf_4
X_1817_ net20 _0551_ _0625_ VGND VGND VPWR VPWR _0633_ sky130_fd_sc_hd__nand3_1
X_1748_ _0478_ _0563_ VGND VGND VPWR VPWR _0564_ sky130_fd_sc_hd__and2_1
XFILLER_0_4_197 VPWR VGND VPWR VGND sky130_ef_sc_hd__decap_12
XFILLER_0_4_153 VPWR VGND VPWR VGND sky130_ef_sc_hd__decap_12
XFILLER_0_17_248 VGND VGND VPWR VPWR sky130_fd_sc_hd__decap_8
X_2866_ _1463_ VGND VGND VPWR VPWR _0116_ sky130_fd_sc_hd__inv_2
XTAP_TAPCELL_ROW_20_316 VGND VPWR sky130_fd_sc_hd__tapvpwrvgnd_1
X_1679_ reg_file.registers\[15\]\[3\] _0484_ _0494_ reg_file.registers\[2\]\[3\] VGND
+ VGND VPWR VPWR _0495_ sky130_fd_sc_hd__a22o_1
XFILLER_0_40_284 VGND VGND VPWR VPWR sky130_fd_sc_hd__fill_1
XTAP_TAPCELL_ROW_71_728 VGND VPWR sky130_fd_sc_hd__tapvpwrvgnd_1
XFILLER_0_48_362 VGND VGND VPWR VPWR sky130_fd_sc_hd__fill_2
XFILLER_0_31_262 VGND VGND VPWR VPWR sky130_fd_sc_hd__decap_4
XFILLER_0_64_29 VPWR VGND VPWR VGND sky130_ef_sc_hd__decap_12
XFILLER_0_13_55 VGND VGND VPWR VPWR sky130_fd_sc_hd__fill_1
X_2582_ imem.address\[24\] _1333_ VGND VGND VPWR VPWR _1334_ sky130_fd_sc_hd__and2_1
XFILLER_0_54_343 VPWR VGND VPWR VGND sky130_ef_sc_hd__decap_12
X_2651_ _1233_ _1368_ _1369_ _1251_ VGND VGND VPWR VPWR _1370_ sky130_fd_sc_hd__a22o_1
X_2720_ display.counter\[3\] _1422_ VGND VGND VPWR VPWR _1425_ sky130_fd_sc_hd__nor2_1
X_1602_ _0440_ VGND VGND VPWR VPWR _0307_ sky130_fd_sc_hd__clkbuf_1
X_1533_ reg_file.registers\[5\]\[22\] _0403_ VGND VGND VPWR VPWR _0404_ sky130_fd_sc_hd__and2_1
XFILLER_0_22_273 VGND VGND VPWR VPWR sky130_fd_sc_hd__fill_2
XFILLER_0_1_167 VGND VGND VPWR VPWR sky130_fd_sc_hd__fill_1
X_3065_ clknet_leaf_7_clk _0288_ _0124_ VGND VGND VPWR VPWR reg_file.registers\[10\]\[3\]
+ sky130_fd_sc_hd__dfrtp_2
X_3134_ clknet_leaf_12_clk _0357_ VGND VGND VPWR VPWR display.digit_sel\[2\] sky130_fd_sc_hd__dfxtp_2
X_2016_ _0583_ _0586_ VGND VGND VPWR VPWR _0832_ sky130_fd_sc_hd__xnor2_1
XFILLER_0_70_83 VGND VGND VPWR VPWR sky130_fd_sc_hd__fill_1
XFILLER_0_57_181 VGND VGND VPWR VPWR sky130_fd_sc_hd__decap_4
X_2918_ _1469_ VGND VGND VPWR VPWR _0162_ sky130_fd_sc_hd__inv_2
XFILLER_0_9_223 VGND VGND VPWR VPWR sky130_fd_sc_hd__fill_1
XFILLER_0_60_379 VGND VGND VPWR VPWR sky130_fd_sc_hd__decap_4
X_2849_ _1461_ VGND VGND VPWR VPWR _0101_ sky130_fd_sc_hd__inv_2
XTAP_TAPCELL_ROW_5_199 VGND VPWR sky130_fd_sc_hd__tapvpwrvgnd_1
XFILLER_0_68_413 VGND VGND VPWR VPWR sky130_fd_sc_hd__decap_6
XFILLER_0_51_368 VGND VGND VPWR VPWR sky130_fd_sc_hd__decap_6
XFILLER_0_51_357 VGND VGND VPWR VPWR sky130_fd_sc_hd__decap_4
XFILLER_0_36_365 VPWR VGND VPWR VGND sky130_ef_sc_hd__decap_12
XFILLER_0_36_354 VGND VGND VPWR VPWR sky130_fd_sc_hd__decap_8
Xclkbuf_leaf_21_clk clknet_1_0__leaf_clk VGND VGND VPWR VPWR clknet_leaf_21_clk sky130_fd_sc_hd__clkbuf_8
XFILLER_0_59_413 VPWR VGND VPWR VGND sky130_ef_sc_hd__decap_12
XTAP_TAPCELL_ROW_47_533 VGND VPWR sky130_fd_sc_hd__tapvpwrvgnd_1
Xclkbuf_leaf_12_clk clknet_1_1__leaf_clk VGND VGND VPWR VPWR clknet_leaf_12_clk sky130_fd_sc_hd__clkbuf_8
XFILLER_0_24_65 VGND VGND VPWR VPWR sky130_fd_sc_hd__decap_8
X_2634_ imem.address\[3\] _1284_ VGND VGND VPWR VPWR _1358_ sky130_fd_sc_hd__nor2_1
XFILLER_0_49_62 VGND VGND VPWR VPWR sky130_fd_sc_hd__fill_1
X_2565_ reg_file.registers\[15\]\[1\] _1286_ VGND VGND VPWR VPWR _1319_ sky130_fd_sc_hd__or2b_1
XFILLER_0_42_357 VGND VGND VPWR VPWR sky130_fd_sc_hd__decap_6
X_1516_ reg_file.registers\[5\]\[30\] _0393_ VGND VGND VPWR VPWR _0395_ sky130_fd_sc_hd__and2_1
XFILLER_0_2_421 VPWR VGND VPWR VGND sky130_ef_sc_hd__decap_12
XFILLER_0_10_221 VPWR VGND VPWR VGND sky130_ef_sc_hd__decap_12
X_2703_ _1417_ VGND VGND VPWR VPWR _0003_ sky130_fd_sc_hd__clkbuf_1
X_2496_ reg_file.registers\[11\]\[0\] _1280_ _0932_ VGND VGND VPWR VPWR _1281_ sky130_fd_sc_hd__mux2_1
XFILLER_0_4_97 VPWR VGND VPWR VGND sky130_ef_sc_hd__decap_12
XFILLER_0_4_53 VPWR VGND VPWR VGND sky130_ef_sc_hd__decap_12
XFILLER_0_10_287 VGND VGND VPWR VPWR sky130_fd_sc_hd__fill_1
X_3117_ clknet_leaf_20_clk _0340_ _0176_ VGND VGND VPWR VPWR reg_file.registers\[5\]\[23\]
+ sky130_fd_sc_hd__dfrtp_1
XFILLER_0_65_449 VGND VGND VPWR VPWR sky130_fd_sc_hd__fill_2
XFILLER_0_65_405 VPWR VGND VPWR VGND sky130_ef_sc_hd__decap_12
X_3048_ clknet_leaf_17_clk _0271_ _0107_ VGND VGND VPWR VPWR reg_file.registers\[11\]\[18\]
+ sky130_fd_sc_hd__dfrtp_1
XTAP_TAPCELL_ROW_2_169 VGND VPWR sky130_fd_sc_hd__tapvpwrvgnd_1
XFILLER_0_60_132 VGND VGND VPWR VPWR sky130_fd_sc_hd__decap_8
XFILLER_0_45_162 VGND VGND VPWR VPWR sky130_fd_sc_hd__fill_2
XFILLER_0_33_346 VGND VGND VPWR VPWR sky130_fd_sc_hd__decap_6
XFILLER_0_33_335 VGND VGND VPWR VPWR sky130_fd_sc_hd__fill_1
XFILLER_0_33_313 VGND VGND VPWR VPWR sky130_fd_sc_hd__fill_2
XFILLER_0_5_281 VPWR VGND VPWR VGND sky130_ef_sc_hd__decap_12
XFILLER_0_41_390 VGND VGND VPWR VPWR sky130_fd_sc_hd__fill_2
XFILLER_0_68_221 VPWR VGND VPWR VGND sky130_ef_sc_hd__decap_12
XFILLER_0_68_265 VPWR VGND VPWR VGND sky130_ef_sc_hd__decap_12
XFILLER_0_28_118 VPWR VGND VPWR VGND sky130_ef_sc_hd__decap_12
Xclkbuf_leaf_1_clk clknet_1_0__leaf_clk VGND VGND VPWR VPWR clknet_leaf_1_clk sky130_fd_sc_hd__clkbuf_8
X_2350_ _0992_ _1042_ _1139_ _1012_ _1155_ VGND VGND VPWR VPWR _1156_ sky130_fd_sc_hd__a221o_1
X_2281_ _0824_ _0840_ _1050_ VGND VGND VPWR VPWR _1092_ sky130_fd_sc_hd__or3b_1
XFILLER_0_59_254 VGND VGND VPWR VPWR sky130_fd_sc_hd__decap_4
XFILLER_0_47_427 VPWR VGND VPWR VGND sky130_ef_sc_hd__decap_12
XFILLER_0_35_97 VGND VGND VPWR VPWR sky130_fd_sc_hd__decap_6
XFILLER_0_47_449 VGND VGND VPWR VPWR sky130_fd_sc_hd__fill_2
XFILLER_0_15_335 VGND VGND VPWR VPWR sky130_fd_sc_hd__fill_1
X_1996_ _0575_ _0577_ _0811_ VGND VGND VPWR VPWR _0812_ sky130_fd_sc_hd__or3_1
X_2617_ _1327_ _1351_ VGND VGND VPWR VPWR _0203_ sky130_fd_sc_hd__nor2_1
XFILLER_0_62_3 VPWR VGND VPWR VGND sky130_ef_sc_hd__decap_12
X_2548_ _1310_ VGND VGND VPWR VPWR _0231_ sky130_fd_sc_hd__clkbuf_1
XFILLER_0_2_251 VGND VGND VPWR VPWR sky130_fd_sc_hd__fill_1
XTAP_TAPCELL_ROW_58_617 VGND VPWR sky130_fd_sc_hd__tapvpwrvgnd_1
X_2479_ reg_file.registers\[11\]\[3\] _1266_ _1234_ VGND VGND VPWR VPWR _1267_ sky130_fd_sc_hd__mux2_1
XTAP_TAPCELL_ROW_66_683 VGND VPWR sky130_fd_sc_hd__tapvpwrvgnd_1
XFILLER_0_61_441 VGND VGND VPWR VPWR sky130_fd_sc_hd__decap_4
Xclkload0 clknet_1_1__leaf_clk VGND VGND VPWR VPWR clkload0/Y sky130_fd_sc_hd__inv_6
XFILLER_0_21_349 VPWR VGND VPWR VGND sky130_ef_sc_hd__decap_12
XFILLER_0_56_202 VGND VGND VPWR VPWR sky130_fd_sc_hd__fill_1
XTAP_TAPCELL_ROW_29_385 VGND VPWR sky130_fd_sc_hd__tapvpwrvgnd_1
XFILLER_0_71_249 VGND VGND VPWR VPWR sky130_fd_sc_hd__decap_3
XFILLER_0_56_246 VGND VGND VPWR VPWR sky130_fd_sc_hd__decap_6
X_1850_ _0506_ _0508_ _0512_ VGND VGND VPWR VPWR _0666_ sky130_fd_sc_hd__a21oi_2
XFILLER_0_29_449 VGND VGND VPWR VPWR sky130_fd_sc_hd__fill_2
X_1781_ reg_file.registers\[5\]\[30\] _0570_ VGND VGND VPWR VPWR _0597_ sky130_fd_sc_hd__nand2_1
XFILLER_0_24_154 VGND VGND VPWR VPWR sky130_fd_sc_hd__decap_3
XTAP_TAPCELL_ROW_12_252 VGND VPWR sky130_fd_sc_hd__tapvpwrvgnd_1
XFILLER_0_21_55 VGND VGND VPWR VPWR sky130_fd_sc_hd__fill_1
X_2402_ _1200_ _1201_ _0898_ VGND VGND VPWR VPWR _1202_ sky130_fd_sc_hd__mux2_1
X_2333_ _0910_ _1056_ VGND VGND VPWR VPWR _1141_ sky130_fd_sc_hd__and2_1
XFILLER_0_12_305 VGND VGND VPWR VPWR sky130_fd_sc_hd__decap_3
XFILLER_0_12_316 VGND VGND VPWR VPWR sky130_fd_sc_hd__fill_1
X_2264_ reg_file.registers\[11\]\[7\] _0828_ _0829_ reg_file.registers\[10\]\[7\]
+ VGND VGND VPWR VPWR _1076_ sky130_fd_sc_hd__a22o_1
X_2195_ _0957_ _0960_ _0879_ VGND VGND VPWR VPWR _1009_ sky130_fd_sc_hd__mux2_1
XFILLER_0_46_85 VGND VGND VPWR VPWR sky130_fd_sc_hd__decap_4
XFILLER_0_62_205 VPWR VGND VPWR VGND sky130_ef_sc_hd__decap_12
XFILLER_0_47_268 VPWR VGND VPWR VGND sky130_ef_sc_hd__decap_12
XFILLER_0_47_246 VPWR VGND VPWR VGND sky130_ef_sc_hd__decap_12
X_1979_ _0756_ _0762_ VGND VGND VPWR VPWR _0795_ sky130_fd_sc_hd__nor2_1
XFILLER_0_7_387 VGND VGND VPWR VPWR sky130_fd_sc_hd__decap_4
XFILLER_0_15_121 VGND VGND VPWR VPWR sky130_fd_sc_hd__fill_2
XFILLER_0_11_393 VGND VGND VPWR VPWR sky130_fd_sc_hd__decap_8
XFILLER_0_26_419 VGND VGND VPWR VPWR sky130_fd_sc_hd__fill_1
XTAP_TAPCELL_ROW_26_366 VGND VPWR sky130_fd_sc_hd__tapvpwrvgnd_1
XFILLER_0_69_393 VPWR VGND VPWR VGND sky130_ef_sc_hd__decap_12
X_1902_ _0716_ _0717_ VGND VGND VPWR VPWR _0718_ sky130_fd_sc_hd__xnor2_1
XTAP_TAPCELL_ROW_60_634 VGND VPWR sky130_fd_sc_hd__tapvpwrvgnd_1
X_2951_ _1472_ VGND VGND VPWR VPWR _1476_ sky130_fd_sc_hd__buf_1
XFILLER_0_29_279 VGND VGND VPWR VPWR sky130_fd_sc_hd__fill_1
XFILLER_0_16_77 VGND VGND VPWR VPWR sky130_fd_sc_hd__decap_6
XFILLER_0_44_238 VGND VGND VPWR VPWR sky130_fd_sc_hd__decap_3
X_1833_ reg_file.registers\[10\]\[13\] _0641_ _0642_ reg_file.registers\[11\]\[13\]
+ VGND VGND VPWR VPWR _0649_ sky130_fd_sc_hd__a22o_1
X_2882_ _1462_ VGND VGND VPWR VPWR _1465_ sky130_fd_sc_hd__buf_4
X_1764_ reg_file.registers\[15\]\[25\] _0569_ _0468_ reg_file.registers\[5\]\[25\]
+ _0519_ VGND VGND VPWR VPWR _0580_ sky130_fd_sc_hd__a221o_1
XFILLER_0_4_357 VGND VGND VPWR VPWR sky130_fd_sc_hd__decap_6
XTAP_TAPCELL_ROW_68_701 VGND VPWR sky130_fd_sc_hd__tapvpwrvgnd_1
XFILLER_0_57_51 VGND VGND VPWR VPWR sky130_fd_sc_hd__decap_4
X_1695_ reg_file.registers\[15\]\[1\] _0484_ _0486_ reg_file.registers\[5\]\[1\] VGND
+ VGND VPWR VPWR _0511_ sky130_fd_sc_hd__a22o_1
X_2316_ reg_file.registers\[11\]\[24\] _1124_ _0933_ VGND VGND VPWR VPWR _1125_ sky130_fd_sc_hd__mux2_1
XFILLER_0_67_308 VPWR VGND VPWR VGND sky130_ef_sc_hd__decap_12
X_2247_ _1057_ _1058_ _0871_ VGND VGND VPWR VPWR _1059_ sky130_fd_sc_hd__mux2_1
X_2178_ _0988_ _0991_ _0897_ VGND VGND VPWR VPWR _0992_ sky130_fd_sc_hd__mux2_1
XFILLER_0_25_3 VPWR VGND VPWR VGND sky130_ef_sc_hd__decap_12
XFILLER_0_35_249 VGND VGND VPWR VPWR sky130_fd_sc_hd__fill_2
XTAP_TAPCELL_ROW_23_336 VGND VPWR sky130_fd_sc_hd__tapvpwrvgnd_1
XFILLER_0_50_208 VPWR VGND VPWR VGND sky130_ef_sc_hd__decap_12
Xoutput13 net13 VGND VGND VPWR VPWR seg[3] sky130_fd_sc_hd__buf_1
XFILLER_0_66_341 VPWR VGND VPWR VGND sky130_ef_sc_hd__decap_12
XPHY_EDGE_ROW_19_Right_19 VGND VGND VPWR VPWR sky130_fd_sc_hd__decap_3
XFILLER_0_34_282 VPWR VGND VPWR VGND sky130_ef_sc_hd__decap_12
XFILLER_0_26_205 VGND VGND VPWR VPWR sky130_fd_sc_hd__fill_1
XFILLER_0_1_305 VPWR VGND VPWR VGND sky130_ef_sc_hd__decap_12
X_1480_ reg_file.registers\[2\]\[31\] VGND VGND VPWR VPWR _0366_ sky130_fd_sc_hd__clkbuf_1
XPHY_EDGE_ROW_28_Right_28 VGND VGND VPWR VPWR sky130_fd_sc_hd__decap_3
XFILLER_0_1_349 VPWR VGND VPWR VGND sky130_ef_sc_hd__decap_12
X_3150_ clknet_leaf_13_clk _0013_ VGND VGND VPWR VPWR display.counter\[15\] sky130_fd_sc_hd__dfxtp_1
X_2101_ _0714_ _0724_ _0889_ VGND VGND VPWR VPWR _0917_ sky130_fd_sc_hd__mux2_1
XPHY_EDGE_ROW_37_Right_37 VGND VGND VPWR VPWR sky130_fd_sc_hd__decap_3
X_3081_ clknet_leaf_17_clk _0304_ _0140_ VGND VGND VPWR VPWR reg_file.registers\[10\]\[19\]
+ sky130_fd_sc_hd__dfrtp_1
X_2032_ _0847_ _0619_ VGND VGND VPWR VPWR _0848_ sky130_fd_sc_hd__nor2_1
XFILLER_0_57_341 VGND VGND VPWR VPWR sky130_fd_sc_hd__fill_1
XFILLER_0_43_97 VGND VGND VPWR VPWR sky130_fd_sc_hd__decap_8
XFILLER_0_9_416 VGND VGND VPWR VPWR sky130_fd_sc_hd__decap_4
XFILLER_0_9_449 VGND VGND VPWR VPWR sky130_fd_sc_hd__fill_2
X_2865_ _1463_ VGND VGND VPWR VPWR _0115_ sky130_fd_sc_hd__inv_2
X_2934_ _1471_ VGND VGND VPWR VPWR _0176_ sky130_fd_sc_hd__inv_2
XTAP_TAPCELL_ROW_20_317 VGND VPWR sky130_fd_sc_hd__tapvpwrvgnd_1
X_1678_ _0381_ net22 _0479_ _0379_ VGND VGND VPWR VPWR _0494_ sky130_fd_sc_hd__and4_2
X_2796_ _1453_ VGND VGND VPWR VPWR _0056_ sky130_fd_sc_hd__inv_2
XPHY_EDGE_ROW_46_Right_46 VGND VGND VPWR VPWR sky130_fd_sc_hd__decap_3
X_1816_ net17 _0551_ _0625_ VGND VGND VPWR VPWR _0632_ sky130_fd_sc_hd__a21o_1
XFILLER_0_32_219 VGND VGND VPWR VPWR sky130_fd_sc_hd__fill_1
X_1747_ reg_file.registers\[15\]\[19\] _0543_ _0537_ reg_file.registers\[5\]\[19\]
+ VGND VGND VPWR VPWR _0563_ sky130_fd_sc_hd__a22o_1
XFILLER_0_4_165 VPWR VGND VPWR VGND sky130_ef_sc_hd__decap_12
XFILLER_0_4_121 VPWR VGND VPWR VGND sky130_ef_sc_hd__decap_12
XPHY_EDGE_ROW_15_Left_87 VGND VGND VPWR VPWR sky130_fd_sc_hd__decap_3
XFILLER_0_68_83 VGND VGND VPWR VPWR sky130_fd_sc_hd__fill_1
XPHY_EDGE_ROW_55_Right_55 VGND VGND VPWR VPWR sky130_fd_sc_hd__decap_3
XFILLER_0_0_393 VPWR VGND VPWR VGND sky130_ef_sc_hd__decap_12
XTAP_TAPCELL_ROW_71_729 VGND VPWR sky130_fd_sc_hd__tapvpwrvgnd_1
XPHY_EDGE_ROW_64_Right_64 VGND VGND VPWR VPWR sky130_fd_sc_hd__decap_3
XFILLER_0_48_374 VGND VGND VPWR VPWR sky130_fd_sc_hd__fill_1
XFILLER_0_16_271 VPWR VGND VPWR VGND sky130_ef_sc_hd__decap_12
XFILLER_0_58_138 VGND VGND VPWR VPWR sky130_fd_sc_hd__fill_2
XFILLER_0_54_355 VGND VGND VPWR VPWR sky130_fd_sc_hd__decap_8
XFILLER_0_39_385 VGND VGND VPWR VPWR sky130_fd_sc_hd__decap_6
XFILLER_0_39_352 VGND VGND VPWR VPWR sky130_fd_sc_hd__fill_1
XFILLER_0_6_419 VGND VGND VPWR VPWR sky130_fd_sc_hd__fill_1
X_2581_ imem.address\[23\] imem.address\[22\] _1332_ VGND VGND VPWR VPWR _1333_ sky130_fd_sc_hd__and3_1
X_2650_ display.digit_sel\[1\] display.digit_sel\[2\] display.digit_sel\[0\] VGND
+ VGND VPWR VPWR _1369_ sky130_fd_sc_hd__nor3b_2
X_1532_ _0392_ VGND VGND VPWR VPWR _0403_ sky130_fd_sc_hd__clkbuf_2
XFILLER_0_1_113 VPWR VGND VPWR VGND sky130_ef_sc_hd__decap_12
X_1601_ reg_file.registers\[10\]\[22\] _0438_ VGND VGND VPWR VPWR _0440_ sky130_fd_sc_hd__and2_1
XFILLER_0_38_75 VGND VGND VPWR VPWR sky130_fd_sc_hd__decap_6
X_3133_ clknet_leaf_12_clk _0356_ VGND VGND VPWR VPWR display.digit_sel\[1\] sky130_fd_sc_hd__dfxtp_2
X_3064_ clknet_leaf_7_clk _0287_ _0123_ VGND VGND VPWR VPWR reg_file.registers\[10\]\[2\]
+ sky130_fd_sc_hd__dfrtp_2
XFILLER_0_54_41 VPWR VGND VPWR VGND sky130_ef_sc_hd__decap_12
XTAP_TAPCELL_ROW_33_420 VGND VPWR sky130_fd_sc_hd__tapvpwrvgnd_1
X_2015_ _0589_ _0830_ _0825_ VGND VGND VPWR VPWR _0831_ sky130_fd_sc_hd__and3_1
XFILLER_0_57_160 VGND VGND VPWR VPWR sky130_fd_sc_hd__decap_8
X_2917_ _1469_ VGND VGND VPWR VPWR _0161_ sky130_fd_sc_hd__inv_2
XFILLER_0_45_355 VGND VGND VPWR VPWR sky130_fd_sc_hd__decap_4
X_2848_ _1458_ VGND VGND VPWR VPWR _1461_ sky130_fd_sc_hd__buf_4
XFILLER_0_5_441 VGND VGND VPWR VPWR sky130_fd_sc_hd__decap_6
XFILLER_0_9_279 VGND VGND VPWR VPWR sky130_fd_sc_hd__fill_1
X_2779_ _1452_ VGND VGND VPWR VPWR _0040_ sky130_fd_sc_hd__inv_2
XFILLER_0_60_369 VGND VGND VPWR VPWR sky130_fd_sc_hd__fill_1
XFILLER_0_36_322 VGND VGND VPWR VPWR sky130_fd_sc_hd__fill_2
XFILLER_0_36_377 VGND VGND VPWR VPWR sky130_fd_sc_hd__decap_8
XFILLER_0_59_425 VPWR VGND VPWR VGND sky130_ef_sc_hd__decap_12
XTAP_TAPCELL_ROW_47_534 VGND VPWR sky130_fd_sc_hd__tapvpwrvgnd_1
XFILLER_0_42_303 VGND VGND VPWR VPWR sky130_fd_sc_hd__decap_4
XFILLER_0_27_333 VGND VGND VPWR VPWR sky130_fd_sc_hd__decap_3
X_2702_ _1414_ _1416_ _1377_ VGND VGND VPWR VPWR _1417_ sky130_fd_sc_hd__mux2_4
X_2633_ imem.address\[4\] _1283_ VGND VGND VPWR VPWR _0193_ sky130_fd_sc_hd__xor2_1
X_2495_ _1042_ _1121_ _1279_ _0472_ VGND VGND VPWR VPWR _1280_ sky130_fd_sc_hd__a22o_1
X_2564_ _1318_ VGND VGND VPWR VPWR _0223_ sky130_fd_sc_hd__clkbuf_1
X_1515_ _0394_ VGND VGND VPWR VPWR _0348_ sky130_fd_sc_hd__clkbuf_1
XFILLER_0_2_433 VPWR VGND VPWR VGND sky130_ef_sc_hd__decap_12
XFILLER_0_10_233 VPWR VGND VPWR VGND sky130_ef_sc_hd__decap_12
XFILLER_0_65_95 VPWR VGND VPWR VGND sky130_ef_sc_hd__decap_12
XFILLER_0_65_51 VGND VGND VPWR VPWR sky130_fd_sc_hd__fill_2
X_3116_ clknet_leaf_21_clk _0339_ _0175_ VGND VGND VPWR VPWR reg_file.registers\[5\]\[22\]
+ sky130_fd_sc_hd__dfrtp_1
XFILLER_0_4_65 VPWR VGND VPWR VGND sky130_ef_sc_hd__decap_12
XFILLER_0_65_417 VPWR VGND VPWR VGND sky130_ef_sc_hd__decap_12
X_3047_ clknet_leaf_17_clk _0270_ _0106_ VGND VGND VPWR VPWR reg_file.registers\[11\]\[17\]
+ sky130_fd_sc_hd__dfrtp_1
XFILLER_0_60_155 VPWR VGND VPWR VGND sky130_ef_sc_hd__decap_12
XPHY_EDGE_ROW_36_Left_108 VGND VGND VPWR VPWR sky130_fd_sc_hd__decap_3
XFILLER_0_5_293 VPWR VGND VPWR VGND sky130_ef_sc_hd__decap_12
XPHY_EDGE_ROW_45_Left_117 VGND VGND VPWR VPWR sky130_fd_sc_hd__decap_3
XPHY_EDGE_ROW_18_Left_90 VGND VGND VPWR VPWR sky130_fd_sc_hd__decap_3
XFILLER_0_68_233 VPWR VGND VPWR VGND sky130_ef_sc_hd__decap_12
XTAP_TAPCELL_ROW_44_504 VGND VPWR sky130_fd_sc_hd__tapvpwrvgnd_1
XFILLER_0_68_277 VPWR VGND VPWR VGND sky130_ef_sc_hd__decap_12
XPHY_EDGE_ROW_54_Left_126 VGND VGND VPWR VPWR sky130_fd_sc_hd__decap_3
XTAP_TAPCELL_ROW_52_570 VGND VPWR sky130_fd_sc_hd__tapvpwrvgnd_1
XFILLER_0_36_141 VGND VGND VPWR VPWR sky130_fd_sc_hd__fill_1
XPHY_EDGE_ROW_63_Left_135 VGND VGND VPWR VPWR sky130_fd_sc_hd__decap_3
XFILLER_0_35_43 VGND VGND VPWR VPWR sky130_fd_sc_hd__fill_1
X_2280_ _1091_ VGND VGND VPWR VPWR _0280_ sky130_fd_sc_hd__clkbuf_1
XFILLER_0_19_55 VGND VGND VPWR VPWR sky130_fd_sc_hd__fill_1
XFILLER_0_59_288 VGND VGND VPWR VPWR sky130_fd_sc_hd__decap_6
XFILLER_0_51_53 VGND VGND VPWR VPWR sky130_fd_sc_hd__decap_3
XFILLER_0_47_439 VGND VGND VPWR VPWR sky130_fd_sc_hd__decap_8
X_2616_ imem.address\[13\] _1326_ imem.address\[14\] VGND VGND VPWR VPWR _1351_ sky130_fd_sc_hd__a21oi_1
XTAP_TAPCELL_ROW_15_272 VGND VPWR sky130_fd_sc_hd__tapvpwrvgnd_1
XFILLER_0_15_314 VGND VGND VPWR VPWR sky130_fd_sc_hd__fill_1
X_1995_ _0519_ _0579_ VGND VGND VPWR VPWR _0811_ sky130_fd_sc_hd__or2_1
XFILLER_0_55_3 VPWR VGND VPWR VGND sky130_ef_sc_hd__decap_12
X_2478_ _1140_ _1072_ _1265_ _0472_ VGND VGND VPWR VPWR _1266_ sky130_fd_sc_hd__a22o_1
X_2547_ reg_file.registers\[15\]\[10\] _1304_ VGND VGND VPWR VPWR _1310_ sky130_fd_sc_hd__and2_1
XTAP_TAPCELL_ROW_66_684 VGND VPWR sky130_fd_sc_hd__tapvpwrvgnd_1
XTAP_TAPCELL_ROW_58_618 VGND VPWR sky130_fd_sc_hd__tapvpwrvgnd_1
XFILLER_0_38_406 VPWR VGND VPWR VGND sky130_ef_sc_hd__decap_12
XFILLER_0_33_111 VGND VGND VPWR VPWR sky130_fd_sc_hd__fill_1
Xclkload1 clknet_leaf_0_clk VGND VGND VPWR VPWR clkload1/Y sky130_fd_sc_hd__inv_6
XFILLER_0_33_177 VGND VGND VPWR VPWR sky130_fd_sc_hd__decap_4
XFILLER_0_33_166 VGND VGND VPWR VPWR sky130_fd_sc_hd__fill_2
XFILLER_0_14_391 VGND VGND VPWR VPWR sky130_fd_sc_hd__decap_6
XPHY_EDGE_ROW_3_Left_75 VGND VGND VPWR VPWR sky130_fd_sc_hd__decap_3
XFILLER_0_29_406 VPWR VGND VPWR VGND sky130_ef_sc_hd__decap_12
XTAP_TAPCELL_ROW_29_386 VGND VPWR sky130_fd_sc_hd__tapvpwrvgnd_1
X_1780_ _0388_ _0378_ _0481_ VGND VGND VPWR VPWR _0596_ sky130_fd_sc_hd__nand3_2
XTAP_TAPCELL_ROW_12_253 VGND VPWR sky130_fd_sc_hd__tapvpwrvgnd_1
X_2401_ _1007_ _1010_ _0882_ VGND VGND VPWR VPWR _1201_ sky130_fd_sc_hd__mux2_1
X_2332_ _0866_ _1056_ VGND VGND VPWR VPWR _1140_ sky130_fd_sc_hd__and2_1
XFILLER_0_20_372 VGND VGND VPWR VPWR sky130_fd_sc_hd__decap_8
XFILLER_0_20_383 VPWR VGND VPWR VGND sky130_ef_sc_hd__decap_12
X_2263_ _1073_ _1074_ _0878_ VGND VGND VPWR VPWR _1075_ sky130_fd_sc_hd__mux2_1
X_2194_ _0882_ _1007_ VGND VGND VPWR VPWR _1008_ sky130_fd_sc_hd__and2_1
XFILLER_0_1_55 VGND VGND VPWR VPWR sky130_fd_sc_hd__fill_1
XFILLER_0_62_217 VGND VGND VPWR VPWR sky130_fd_sc_hd__decap_3
XFILLER_0_62_85 VGND VGND VPWR VPWR sky130_fd_sc_hd__decap_6
XFILLER_0_47_258 VGND VGND VPWR VPWR sky130_fd_sc_hd__fill_1
XFILLER_0_47_225 VGND VGND VPWR VPWR sky130_fd_sc_hd__fill_2
XFILLER_0_47_203 VGND VGND VPWR VPWR sky130_fd_sc_hd__decap_3
XFILLER_0_7_344 VGND VGND VPWR VPWR sky130_fd_sc_hd__decap_3
XFILLER_0_55_291 VGND VGND VPWR VPWR sky130_fd_sc_hd__fill_1
XFILLER_0_30_158 VGND VGND VPWR VPWR sky130_fd_sc_hd__fill_1
X_1978_ reg_file.registers\[10\]\[19\] _0605_ _0610_ reg_file.registers\[11\]\[19\]
+ VGND VGND VPWR VPWR _0794_ sky130_fd_sc_hd__a22o_1
XFILLER_0_11_383 VGND VGND VPWR VPWR sky130_fd_sc_hd__fill_1
XFILLER_0_38_203 VGND VGND VPWR VPWR sky130_fd_sc_hd__fill_1
XTAP_TAPCELL_ROW_26_367 VGND VPWR sky130_fd_sc_hd__tapvpwrvgnd_1
XFILLER_0_21_169 VGND VGND VPWR VPWR sky130_fd_sc_hd__decap_6
XFILLER_0_69_361 VPWR VGND VPWR VGND sky130_ef_sc_hd__decap_12
X_2881_ _1464_ VGND VGND VPWR VPWR _0130_ sky130_fd_sc_hd__inv_2
X_1901_ reg_file.registers\[10\]\[10\] _0620_ _0622_ reg_file.registers\[11\]\[10\]
+ VGND VGND VPWR VPWR _0717_ sky130_fd_sc_hd__a22o_1
XTAP_TAPCELL_ROW_60_635 VGND VPWR sky130_fd_sc_hd__tapvpwrvgnd_1
X_1832_ net26 _0551_ _0647_ VGND VGND VPWR VPWR _0648_ sky130_fd_sc_hd__a21bo_1
X_2950_ _1475_ VGND VGND VPWR VPWR _0188_ sky130_fd_sc_hd__inv_2
XFILLER_0_29_225 VGND VGND VPWR VPWR sky130_fd_sc_hd__decap_4
X_1694_ _0467_ _0490_ VGND VGND VPWR VPWR _0510_ sky130_fd_sc_hd__nor2_1
XFILLER_0_32_99 VGND VGND VPWR VPWR sky130_fd_sc_hd__fill_1
X_1763_ _0566_ _0578_ VGND VGND VPWR VPWR _0579_ sky130_fd_sc_hd__and2_1
XTAP_TAPCELL_ROW_68_702 VGND VPWR sky130_fd_sc_hd__tapvpwrvgnd_1
X_2246_ reg_file.registers\[11\]\[13\] _0828_ _0829_ reg_file.registers\[10\]\[13\]
+ VGND VGND VPWR VPWR _1058_ sky130_fd_sc_hd__a22o_1
X_2315_ _0471_ _1103_ _1115_ _1123_ VGND VGND VPWR VPWR _1124_ sky130_fd_sc_hd__a31o_1
X_2177_ _0989_ _0990_ _0902_ VGND VGND VPWR VPWR _0991_ sky130_fd_sc_hd__mux2_1
XFILLER_0_18_3 VPWR VGND VPWR VGND sky130_ef_sc_hd__decap_12
XTAP_TAPCELL_ROW_23_337 VGND VPWR sky130_fd_sc_hd__tapvpwrvgnd_1
XFILLER_0_3_391 VGND VGND VPWR VPWR sky130_fd_sc_hd__fill_1
Xoutput14 net14 VGND VGND VPWR VPWR seg[4] sky130_fd_sc_hd__buf_1
XTAP_TAPCELL_ROW_39_470 VGND VPWR sky130_fd_sc_hd__tapvpwrvgnd_1
XFILLER_0_66_353 VGND VGND VPWR VPWR sky130_fd_sc_hd__decap_8
XFILLER_0_34_294 VPWR VGND VPWR VGND sky130_ef_sc_hd__decap_12
XFILLER_0_34_250 VGND VGND VPWR VPWR sky130_fd_sc_hd__fill_2
XFILLER_0_26_239 VGND VGND VPWR VPWR sky130_fd_sc_hd__decap_6
XFILLER_0_1_317 VPWR VGND VPWR VGND sky130_ef_sc_hd__decap_12
X_2100_ _0709_ _0717_ _0889_ VGND VGND VPWR VPWR _0916_ sky130_fd_sc_hd__mux2_1
X_3080_ clknet_leaf_17_clk _0303_ _0139_ VGND VGND VPWR VPWR reg_file.registers\[10\]\[18\]
+ sky130_fd_sc_hd__dfrtp_1
XFILLER_0_27_88 VPWR VGND VPWR VGND sky130_ef_sc_hd__decap_12
X_2031_ _0617_ _0618_ VGND VGND VPWR VPWR _0847_ sky130_fd_sc_hd__nor2_1
XFILLER_0_69_191 VPWR VGND VPWR VGND sky130_ef_sc_hd__decap_12
X_2795_ _1453_ VGND VGND VPWR VPWR _0055_ sky130_fd_sc_hd__inv_2
X_1815_ reg_file.registers\[10\]\[14\] _0620_ _0622_ reg_file.registers\[11\]\[14\]
+ VGND VGND VPWR VPWR _0631_ sky130_fd_sc_hd__a22o_1
X_2933_ _1471_ VGND VGND VPWR VPWR _0175_ sky130_fd_sc_hd__inv_2
XFILLER_0_4_133 VGND VGND VPWR VPWR sky130_fd_sc_hd__decap_6
X_2864_ _1463_ VGND VGND VPWR VPWR _0114_ sky130_fd_sc_hd__inv_2
XTAP_TAPCELL_ROW_20_318 VGND VPWR sky130_fd_sc_hd__tapvpwrvgnd_1
X_1677_ reg_file.registers\[10\]\[3\] _0492_ VGND VGND VPWR VPWR _0493_ sky130_fd_sc_hd__and2_1
XFILLER_0_40_253 VPWR VGND VPWR VGND sky130_ef_sc_hd__decap_12
X_1746_ _0561_ VGND VGND VPWR VPWR _0562_ sky130_fd_sc_hd__inv_2
XFILLER_0_4_177 VPWR VGND VPWR VGND sky130_ef_sc_hd__decap_12
XFILLER_0_0_361 VGND VGND VPWR VPWR sky130_fd_sc_hd__decap_3
X_2229_ _1041_ VGND VGND VPWR VPWR _1042_ sky130_fd_sc_hd__clkbuf_4
XFILLER_0_48_342 VGND VGND VPWR VPWR sky130_fd_sc_hd__decap_6
XTAP_TAPCELL_ROW_36_440 VGND VPWR sky130_fd_sc_hd__tapvpwrvgnd_1
XFILLER_0_63_334 VGND VGND VPWR VPWR sky130_fd_sc_hd__fill_2
XFILLER_0_23_209 VGND VGND VPWR VPWR sky130_fd_sc_hd__decap_8
XFILLER_0_7_3 VPWR VGND VPWR VGND sky130_ef_sc_hd__decap_12
XFILLER_0_54_323 VGND VGND VPWR VPWR sky130_fd_sc_hd__fill_1
XFILLER_0_13_57 VPWR VGND VPWR VGND sky130_ef_sc_hd__decap_12
X_2580_ imem.address\[21\] _1331_ VGND VGND VPWR VPWR _1332_ sky130_fd_sc_hd__and2_1
XFILLER_0_22_253 VPWR VGND VPWR VGND sky130_ef_sc_hd__decap_12
XFILLER_0_1_125 VPWR VGND VPWR VGND sky130_ef_sc_hd__decap_12
XFILLER_0_1_169 VPWR VGND VPWR VGND sky130_ef_sc_hd__decap_12
X_1600_ _0439_ VGND VGND VPWR VPWR _0308_ sky130_fd_sc_hd__clkbuf_1
X_1531_ _0402_ VGND VGND VPWR VPWR _0340_ sky130_fd_sc_hd__clkbuf_1
X_3063_ clknet_leaf_7_clk _0286_ _0122_ VGND VGND VPWR VPWR reg_file.registers\[10\]\[1\]
+ sky130_fd_sc_hd__dfrtp_1
X_3132_ clknet_leaf_12_clk _0355_ VGND VGND VPWR VPWR display.digit_sel\[0\] sky130_fd_sc_hd__dfxtp_2
XFILLER_0_70_41 VPWR VGND VPWR VGND sky130_ef_sc_hd__decap_12
XFILLER_0_54_53 VPWR VGND VPWR VGND sky130_ef_sc_hd__decap_12
XFILLER_0_49_106 VGND VGND VPWR VPWR sky130_fd_sc_hd__decap_6
XTAP_TAPCELL_ROW_33_421 VGND VPWR sky130_fd_sc_hd__tapvpwrvgnd_1
XFILLER_0_9_225 VPWR VGND VPWR VGND sky130_ef_sc_hd__decap_12
X_2014_ reg_file.registers\[11\]\[27\] _0828_ _0829_ reg_file.registers\[10\]\[27\]
+ VGND VGND VPWR VPWR _0830_ sky130_fd_sc_hd__a22oi_1
XFILLER_0_70_85 VPWR VGND VPWR VGND sky130_ef_sc_hd__decap_12
X_2778_ _1452_ VGND VGND VPWR VPWR _0039_ sky130_fd_sc_hd__inv_2
X_2847_ _1460_ VGND VGND VPWR VPWR _0100_ sky130_fd_sc_hd__inv_2
X_2916_ _1469_ VGND VGND VPWR VPWR _0160_ sky130_fd_sc_hd__inv_2
XFILLER_0_45_367 VPWR VGND VPWR VGND sky130_ef_sc_hd__decap_12
X_1729_ reg_file.registers\[15\]\[15\] _0485_ _0468_ reg_file.registers\[5\]\[15\]
+ VGND VGND VPWR VPWR _0545_ sky130_fd_sc_hd__a22o_1
XFILLER_0_63_197 VPWR VGND VPWR VGND sky130_ef_sc_hd__decap_12
XFILLER_0_51_337 VPWR VGND VPWR VGND sky130_ef_sc_hd__decap_12
XFILLER_0_59_437 VGND VGND VPWR VPWR sky130_fd_sc_hd__decap_8
XTAP_TAPCELL_ROW_47_535 VGND VPWR sky130_fd_sc_hd__tapvpwrvgnd_1
XFILLER_0_39_150 VGND VGND VPWR VPWR sky130_fd_sc_hd__decap_6
XTAP_TAPCELL_ROW_4_190 VGND VPWR sky130_fd_sc_hd__tapvpwrvgnd_1
X_2632_ _1321_ _1357_ VGND VGND VPWR VPWR _0194_ sky130_fd_sc_hd__nor2_1
XFILLER_0_54_131 VGND VGND VPWR VPWR sky130_fd_sc_hd__decap_8
XFILLER_0_40_77 VGND VGND VPWR VPWR sky130_fd_sc_hd__fill_2
XFILLER_0_27_367 VGND VGND VPWR VPWR sky130_fd_sc_hd__fill_2
XFILLER_0_2_401 VPWR VGND VPWR VGND sky130_ef_sc_hd__decap_12
X_2701_ net43 _1407_ _1409_ _1415_ VGND VGND VPWR VPWR _1416_ sky130_fd_sc_hd__a31oi_1
X_2494_ _1006_ _0968_ VGND VGND VPWR VPWR _1279_ sky130_fd_sc_hd__nand2_1
XFILLER_0_49_42 VPWR VGND VPWR VGND sky130_ef_sc_hd__decap_12
X_2563_ reg_file.registers\[15\]\[2\] _1286_ VGND VGND VPWR VPWR _1318_ sky130_fd_sc_hd__or2b_1
X_1514_ reg_file.registers\[5\]\[31\] _0393_ VGND VGND VPWR VPWR _0394_ sky130_fd_sc_hd__and2_1
XFILLER_0_2_445 VGND VGND VPWR VPWR sky130_fd_sc_hd__decap_6
XFILLER_0_10_245 VGND VGND VPWR VPWR sky130_fd_sc_hd__decap_6
X_3046_ clknet_leaf_17_clk _0269_ _0105_ VGND VGND VPWR VPWR reg_file.registers\[11\]\[16\]
+ sky130_fd_sc_hd__dfrtp_1
X_3115_ clknet_leaf_20_clk _0338_ _0174_ VGND VGND VPWR VPWR reg_file.registers\[5\]\[21\]
+ sky130_fd_sc_hd__dfrtp_1
XFILLER_0_4_77 VGND VGND VPWR VPWR sky130_fd_sc_hd__decap_6
XFILLER_0_65_429 VPWR VGND VPWR VGND sky130_ef_sc_hd__decap_12
XFILLER_0_18_323 VGND VGND VPWR VPWR sky130_fd_sc_hd__decap_8
XFILLER_0_60_167 VGND VGND VPWR VPWR sky130_fd_sc_hd__decap_3
XFILLER_0_41_370 VPWR VGND VPWR VGND sky130_ef_sc_hd__decap_12
XFILLER_0_33_359 VPWR VGND VPWR VGND sky130_ef_sc_hd__decap_12
XFILLER_0_5_261 VPWR VGND VPWR VGND sky130_ef_sc_hd__decap_12
XFILLER_0_68_289 VPWR VGND VPWR VGND sky130_ef_sc_hd__decap_12
XFILLER_0_68_245 VGND VGND VPWR VPWR sky130_fd_sc_hd__decap_6
XFILLER_0_56_407 VPWR VGND VPWR VGND sky130_ef_sc_hd__decap_12
XTAP_TAPCELL_ROW_44_505 VGND VPWR sky130_fd_sc_hd__tapvpwrvgnd_1
XTAP_TAPCELL_ROW_1_160 VGND VPWR sky130_fd_sc_hd__tapvpwrvgnd_1
XTAP_TAPCELL_ROW_52_571 VGND VPWR sky130_fd_sc_hd__tapvpwrvgnd_1
XFILLER_0_36_197 VGND VGND VPWR VPWR sky130_fd_sc_hd__fill_2
XFILLER_0_59_234 VGND VGND VPWR VPWR sky130_fd_sc_hd__fill_2
XTAP_TAPCELL_ROW_15_273 VGND VPWR sky130_fd_sc_hd__tapvpwrvgnd_1
X_1994_ _0792_ _0800_ _0803_ _0804_ _0809_ VGND VGND VPWR VPWR _0810_ sky130_fd_sc_hd__o221a_1
XFILLER_0_70_421 VPWR VGND VPWR VGND sky130_ef_sc_hd__decap_12
X_2615_ _1328_ _1350_ VGND VGND VPWR VPWR _0204_ sky130_fd_sc_hd__nor2_1
XFILLER_0_2_253 VPWR VGND VPWR VGND sky130_ef_sc_hd__decap_12
XTAP_TAPCELL_ROW_58_619 VGND VPWR sky130_fd_sc_hd__tapvpwrvgnd_1
X_2477_ _0679_ _0682_ VGND VGND VPWR VPWR _1265_ sky130_fd_sc_hd__xor2_1
XFILLER_0_48_3 VPWR VGND VPWR VGND sky130_ef_sc_hd__decap_12
X_2546_ _1309_ VGND VGND VPWR VPWR _0232_ sky130_fd_sc_hd__clkbuf_1
XTAP_TAPCELL_ROW_7_208 VGND VPWR sky130_fd_sc_hd__tapvpwrvgnd_1
XTAP_TAPCELL_ROW_66_685 VGND VPWR sky130_fd_sc_hd__tapvpwrvgnd_1
XFILLER_0_38_418 VGND VGND VPWR VPWR sky130_fd_sc_hd__fill_2
X_3029_ clknet_leaf_0_clk _0252_ _0088_ VGND VGND VPWR VPWR reg_file.registers\[15\]\[31\]
+ sky130_fd_sc_hd__dfrtp_1
Xclkload2 clknet_leaf_1_clk VGND VGND VPWR VPWR clkload2/Y sky130_fd_sc_hd__clkinv_8
XFILLER_0_18_164 VPWR VGND VPWR VGND sky130_ef_sc_hd__decap_12
XFILLER_0_18_197 VGND VGND VPWR VPWR sky130_fd_sc_hd__decap_3
XTAP_TAPCELL_ROW_29_387 VGND VPWR sky130_fd_sc_hd__tapvpwrvgnd_1
X_2400_ _1003_ _1009_ _0902_ VGND VGND VPWR VPWR _1200_ sky130_fd_sc_hd__mux2_1
XTAP_TAPCELL_ROW_12_254 VGND VPWR sky130_fd_sc_hd__tapvpwrvgnd_1
XFILLER_0_21_57 VPWR VGND VPWR VGND sky130_ef_sc_hd__decap_12
X_2262_ reg_file.registers\[11\]\[4\] _0683_ _0685_ reg_file.registers\[10\]\[4\]
+ VGND VGND VPWR VPWR _1074_ sky130_fd_sc_hd__a22o_1
X_2331_ _0909_ _1138_ VGND VGND VPWR VPWR _1139_ sky130_fd_sc_hd__nor2_2
XFILLER_0_20_395 VPWR VGND VPWR VGND sky130_ef_sc_hd__decap_12
X_2193_ _0879_ _0964_ _1006_ VGND VGND VPWR VPWR _1007_ sky130_fd_sc_hd__o21a_1
XFILLER_0_46_98 VGND VGND VPWR VPWR sky130_fd_sc_hd__fill_1
XFILLER_0_55_281 VGND VGND VPWR VPWR sky130_fd_sc_hd__fill_2
XFILLER_0_28_440 VGND VGND VPWR VPWR sky130_fd_sc_hd__decap_8
X_1977_ _0752_ _0792_ _0771_ VGND VGND VPWR VPWR _0793_ sky130_fd_sc_hd__or3_4
XFILLER_0_70_251 VGND VGND VPWR VPWR sky130_fd_sc_hd__fill_1
XFILLER_0_30_137 VGND VGND VPWR VPWR sky130_fd_sc_hd__decap_3
X_2529_ _1300_ VGND VGND VPWR VPWR _0240_ sky130_fd_sc_hd__clkbuf_1
XFILLER_0_11_351 VPWR VGND VPWR VGND sky130_ef_sc_hd__decap_12
XFILLER_0_38_259 VGND VGND VPWR VPWR sky130_fd_sc_hd__decap_8
XFILLER_0_61_295 VPWR VGND VPWR VGND sky130_ef_sc_hd__decap_12
XFILLER_0_53_218 VGND VGND VPWR VPWR sky130_fd_sc_hd__fill_1
XFILLER_0_34_421 VGND VGND VPWR VPWR sky130_fd_sc_hd__decap_3
XFILLER_0_69_373 VPWR VGND VPWR VGND sky130_ef_sc_hd__decap_12
X_2880_ _1464_ VGND VGND VPWR VPWR _0129_ sky130_fd_sc_hd__inv_2
XTAP_TAPCELL_ROW_60_636 VGND VPWR sky130_fd_sc_hd__tapvpwrvgnd_1
X_1900_ _0711_ _0541_ VGND VGND VPWR VPWR _0716_ sky130_fd_sc_hd__xnor2_2
X_1831_ _0638_ net18 _0548_ _0550_ VGND VGND VPWR VPWR _0647_ sky130_fd_sc_hd__a31o_1
XFILLER_0_8_109 VPWR VGND VPWR VGND sky130_ef_sc_hd__decap_12
XFILLER_0_52_273 VGND VGND VPWR VPWR sky130_fd_sc_hd__fill_2
X_1693_ _0378_ _0379_ _0388_ VGND VGND VPWR VPWR _0509_ sky130_fd_sc_hd__o21a_2
XFILLER_0_40_424 VGND VGND VPWR VPWR sky130_fd_sc_hd__fill_1
XFILLER_0_40_413 VGND VGND VPWR VPWR sky130_fd_sc_hd__decap_6
X_1762_ reg_file.registers\[15\]\[24\] _0569_ _0468_ reg_file.registers\[5\]\[24\]
+ VGND VGND VPWR VPWR _0578_ sky130_fd_sc_hd__a22o_1
XTAP_TAPCELL_ROW_68_703 VGND VPWR sky130_fd_sc_hd__tapvpwrvgnd_1
X_2245_ reg_file.registers\[11\]\[12\] _0828_ _0829_ reg_file.registers\[10\]\[12\]
+ VGND VGND VPWR VPWR _1057_ sky130_fd_sc_hd__a22o_1
X_2176_ _0629_ _0635_ _0879_ VGND VGND VPWR VPWR _0990_ sky130_fd_sc_hd__mux2_1
X_2314_ _0940_ _1117_ _1119_ _1122_ _0937_ VGND VGND VPWR VPWR _1123_ sky130_fd_sc_hd__a32o_1
XTAP_TAPCELL_ROW_23_338 VGND VPWR sky130_fd_sc_hd__tapvpwrvgnd_1
XFILLER_0_31_402 VPWR VGND VPWR VGND sky130_ef_sc_hd__decap_12
XFILLER_0_28_270 VGND VGND VPWR VPWR sky130_fd_sc_hd__decap_3
XFILLER_0_16_421 VGND VGND VPWR VPWR sky130_fd_sc_hd__fill_1
XPHY_EDGE_ROW_1_Right_1 VGND VGND VPWR VPWR sky130_fd_sc_hd__decap_3
Xoutput15 net15 VGND VGND VPWR VPWR seg[5] sky130_fd_sc_hd__buf_1
XFILLER_0_11_181 VPWR VGND VPWR VGND sky130_ef_sc_hd__decap_12
XTAP_TAPCELL_ROW_39_471 VGND VPWR sky130_fd_sc_hd__tapvpwrvgnd_1
XFILLER_0_66_365 VPWR VGND VPWR VGND sky130_ef_sc_hd__decap_12
XFILLER_0_26_229 VGND VGND VPWR VPWR sky130_fd_sc_hd__decap_3
XFILLER_0_19_270 VGND VGND VPWR VPWR sky130_fd_sc_hd__decap_8
XFILLER_0_19_281 VGND VGND VPWR VPWR sky130_fd_sc_hd__decap_3
XFILLER_0_1_329 VGND VGND VPWR VPWR sky130_fd_sc_hd__decap_6
X_2030_ _0826_ _0827_ _0835_ _0845_ VGND VGND VPWR VPWR _0846_ sky130_fd_sc_hd__a211o_1
XFILLER_0_57_332 VGND VGND VPWR VPWR sky130_fd_sc_hd__decap_4
XFILLER_0_43_55 VGND VGND VPWR VPWR sky130_fd_sc_hd__fill_1
X_2932_ _1471_ VGND VGND VPWR VPWR _0174_ sky130_fd_sc_hd__inv_2
X_2794_ _1453_ VGND VGND VPWR VPWR _0054_ sky130_fd_sc_hd__inv_2
X_1814_ _0627_ _0626_ _0629_ VGND VGND VPWR VPWR _0630_ sky130_fd_sc_hd__a21boi_1
X_1745_ net31 _0560_ VGND VGND VPWR VPWR _0561_ sky130_fd_sc_hd__nand2_1
XFILLER_0_25_273 VGND VGND VPWR VPWR sky130_fd_sc_hd__fill_2
X_2863_ _1463_ VGND VGND VPWR VPWR _0113_ sky130_fd_sc_hd__inv_2
XTAP_TAPCELL_ROW_20_319 VGND VPWR sky130_fd_sc_hd__tapvpwrvgnd_1
XFILLER_0_68_41 VPWR VGND VPWR VGND sky130_ef_sc_hd__decap_12
X_1676_ _0381_ _0386_ _0491_ VGND VGND VPWR VPWR _0492_ sky130_fd_sc_hd__and3_1
XFILLER_0_40_265 VGND VGND VPWR VPWR sky130_fd_sc_hd__decap_4
XFILLER_0_7_55 VGND VGND VPWR VPWR sky130_fd_sc_hd__fill_1
XFILLER_0_4_189 VGND VGND VPWR VPWR sky130_fd_sc_hd__decap_6
X_2159_ _0972_ _0973_ _0901_ VGND VGND VPWR VPWR _0974_ sky130_fd_sc_hd__mux2_1
X_2228_ _0657_ _0939_ VGND VGND VPWR VPWR _1041_ sky130_fd_sc_hd__and2_1
XFILLER_0_30_3 VPWR VGND VPWR VGND sky130_ef_sc_hd__decap_12
XFILLER_0_67_118 VGND VGND VPWR VPWR sky130_fd_sc_hd__decap_4
XTAP_TAPCELL_ROW_36_441 VGND VPWR sky130_fd_sc_hd__tapvpwrvgnd_1
XFILLER_0_8_440 VGND VGND VPWR VPWR sky130_fd_sc_hd__decap_8
XFILLER_0_31_221 VGND VGND VPWR VPWR sky130_fd_sc_hd__decap_3
XTAP_TAPCELL_ROW_42_488 VGND VPWR sky130_fd_sc_hd__tapvpwrvgnd_1
XFILLER_0_13_69 VPWR VGND VPWR VGND sky130_ef_sc_hd__decap_12
XFILLER_0_22_265 VGND VGND VPWR VPWR sky130_fd_sc_hd__decap_8
XFILLER_0_1_137 VPWR VGND VPWR VGND sky130_ef_sc_hd__decap_12
XFILLER_0_10_438 VPWR VGND VPWR VGND sky130_ef_sc_hd__decap_12
X_1530_ reg_file.registers\[5\]\[23\] _0393_ VGND VGND VPWR VPWR _0402_ sky130_fd_sc_hd__and2_1
X_3062_ clknet_leaf_6_clk _0285_ _0121_ VGND VGND VPWR VPWR reg_file.registers\[10\]\[0\]
+ sky130_fd_sc_hd__dfrtp_1
X_2013_ _0685_ VGND VGND VPWR VPWR _0829_ sky130_fd_sc_hd__clkbuf_4
XFILLER_0_54_65 VPWR VGND VPWR VGND sky130_ef_sc_hd__decap_12
X_3131_ clknet_leaf_21_clk _0354_ _0190_ VGND VGND VPWR VPWR reg_file.registers\[2\]\[31\]
+ sky130_fd_sc_hd__dfrtp_1
XFILLER_0_70_53 VPWR VGND VPWR VGND sky130_ef_sc_hd__decap_12
X_2915_ _1469_ VGND VGND VPWR VPWR _0159_ sky130_fd_sc_hd__inv_2
XFILLER_0_45_335 VGND VGND VPWR VPWR sky130_fd_sc_hd__fill_1
XTAP_TAPCELL_ROW_33_422 VGND VPWR sky130_fd_sc_hd__tapvpwrvgnd_1
XFILLER_0_9_237 VPWR VGND VPWR VGND sky130_ef_sc_hd__decap_12
Xclkbuf_leaf_15_clk clknet_1_1__leaf_clk VGND VGND VPWR VPWR clknet_leaf_15_clk sky130_fd_sc_hd__clkbuf_8
XFILLER_0_70_97 VGND VGND VPWR VPWR sky130_fd_sc_hd__decap_3
X_2777_ _1452_ VGND VGND VPWR VPWR _0038_ sky130_fd_sc_hd__inv_2
X_2846_ _1460_ VGND VGND VPWR VPWR _0099_ sky130_fd_sc_hd__inv_2
XFILLER_0_60_305 VGND VGND VPWR VPWR sky130_fd_sc_hd__decap_3
X_1728_ reg_file.registers\[15\]\[14\] _0543_ _0468_ reg_file.registers\[5\]\[14\]
+ VGND VGND VPWR VPWR _0544_ sky130_fd_sc_hd__a22oi_1
X_1659_ _0372_ _0381_ _0386_ _0379_ VGND VGND VPWR VPWR _0475_ sky130_fd_sc_hd__and4_1
XFILLER_0_0_181 VPWR VGND VPWR VGND sky130_ef_sc_hd__decap_12
XFILLER_0_63_176 VGND VGND VPWR VPWR sky130_fd_sc_hd__fill_1
XFILLER_0_48_195 VGND VGND VPWR VPWR sky130_fd_sc_hd__fill_1
XFILLER_0_51_349 VGND VGND VPWR VPWR sky130_fd_sc_hd__decap_4
XTAP_TAPCELL_ROW_4_191 VGND VPWR sky130_fd_sc_hd__tapvpwrvgnd_1
XFILLER_0_59_449 VGND VGND VPWR VPWR sky130_fd_sc_hd__fill_2
XFILLER_0_39_173 VGND VGND VPWR VPWR sky130_fd_sc_hd__fill_1
X_2631_ imem.address\[4\] _1283_ imem.address\[5\] VGND VGND VPWR VPWR _1357_ sky130_fd_sc_hd__a21oi_1
X_2562_ _1317_ VGND VGND VPWR VPWR _0224_ sky130_fd_sc_hd__clkbuf_1
XFILLER_0_40_45 VGND VGND VPWR VPWR sky130_fd_sc_hd__decap_4
X_2700_ _1382_ _1383_ _1393_ _1401_ VGND VGND VPWR VPWR _1415_ sky130_fd_sc_hd__a22oi_1
XFILLER_0_2_413 VGND VGND VPWR VPWR sky130_fd_sc_hd__decap_6
X_2493_ _1278_ VGND VGND VPWR VPWR _0254_ sky130_fd_sc_hd__clkbuf_1
Xclkbuf_leaf_4_clk clknet_1_0__leaf_clk VGND VGND VPWR VPWR clknet_leaf_4_clk sky130_fd_sc_hd__clkbuf_8
XFILLER_0_49_54 VGND VGND VPWR VPWR sky130_fd_sc_hd__fill_2
X_1513_ _0392_ VGND VGND VPWR VPWR _0393_ sky130_fd_sc_hd__clkbuf_2
X_3045_ clknet_leaf_1_clk _0268_ _0104_ VGND VGND VPWR VPWR reg_file.registers\[11\]\[15\]
+ sky130_fd_sc_hd__dfrtp_1
X_3114_ clknet_leaf_20_clk _0337_ _0173_ VGND VGND VPWR VPWR reg_file.registers\[5\]\[20\]
+ sky130_fd_sc_hd__dfrtp_1
XFILLER_0_41_393 VPWR VGND VPWR VGND sky130_ef_sc_hd__decap_12
XFILLER_0_41_382 VGND VGND VPWR VPWR sky130_fd_sc_hd__decap_8
XFILLER_0_5_273 VGND VGND VPWR VPWR sky130_fd_sc_hd__decap_6
X_2829_ _1456_ VGND VGND VPWR VPWR _0086_ sky130_fd_sc_hd__inv_2
XFILLER_0_56_419 VGND VGND VPWR VPWR sky130_fd_sc_hd__fill_1
XTAP_TAPCELL_ROW_44_506 VGND VPWR sky130_fd_sc_hd__tapvpwrvgnd_1
XTAP_TAPCELL_ROW_1_161 VGND VPWR sky130_fd_sc_hd__tapvpwrvgnd_1
XTAP_TAPCELL_ROW_52_572 VGND VPWR sky130_fd_sc_hd__tapvpwrvgnd_1
XFILLER_0_10_15 VPWR VGND VPWR VGND sky130_ef_sc_hd__decap_12
XFILLER_0_19_57 VPWR VGND VPWR VGND sky130_ef_sc_hd__decap_12
XFILLER_0_59_279 VGND VGND VPWR VPWR sky130_fd_sc_hd__fill_1
XFILLER_0_47_408 VGND VGND VPWR VPWR sky130_fd_sc_hd__fill_1
XFILLER_0_27_143 VPWR VGND VPWR VGND sky130_ef_sc_hd__decap_12
XTAP_TAPCELL_ROW_15_274 VGND VPWR sky130_fd_sc_hd__tapvpwrvgnd_1
X_1993_ _0778_ _0782_ _0805_ _0808_ VGND VGND VPWR VPWR _0809_ sky130_fd_sc_hd__or4bb_1
XFILLER_0_70_433 VPWR VGND VPWR VGND sky130_ef_sc_hd__decap_12
X_2614_ imem.address\[15\] _1327_ VGND VGND VPWR VPWR _1350_ sky130_fd_sc_hd__nor2_1
X_2545_ reg_file.registers\[15\]\[11\] _1304_ VGND VGND VPWR VPWR _1309_ sky130_fd_sc_hd__and2_1
XFILLER_0_27_198 VGND VGND VPWR VPWR sky130_fd_sc_hd__fill_1
XFILLER_0_23_393 VGND VGND VPWR VPWR sky130_fd_sc_hd__decap_8
XFILLER_0_2_265 VPWR VGND VPWR VGND sky130_ef_sc_hd__decap_12
XFILLER_0_2_221 VPWR VGND VPWR VGND sky130_ef_sc_hd__decap_12
XTAP_TAPCELL_ROW_7_209 VGND VPWR sky130_fd_sc_hd__tapvpwrvgnd_1
X_2476_ _1264_ VGND VGND VPWR VPWR _0257_ sky130_fd_sc_hd__clkbuf_1
XTAP_TAPCELL_ROW_66_686 VGND VPWR sky130_fd_sc_hd__tapvpwrvgnd_1
X_3028_ clknet_leaf_0_clk _0251_ _0087_ VGND VGND VPWR VPWR reg_file.registers\[15\]\[30\]
+ sky130_fd_sc_hd__dfrtp_1
Xclkload3 clknet_leaf_2_clk VGND VGND VPWR VPWR clkload3/Y sky130_fd_sc_hd__bufinv_16
XFILLER_0_33_113 VGND VGND VPWR VPWR sky130_fd_sc_hd__fill_2
XFILLER_0_33_124 VGND VGND VPWR VPWR sky130_fd_sc_hd__decap_3
XFILLER_0_18_176 VGND VGND VPWR VPWR sky130_fd_sc_hd__decap_4
XFILLER_0_21_319 VPWR VGND VPWR VGND sky130_ef_sc_hd__decap_12
XFILLER_0_41_190 VGND VGND VPWR VPWR sky130_fd_sc_hd__fill_2
XFILLER_0_14_360 VGND VGND VPWR VPWR sky130_fd_sc_hd__decap_4
XTAP_TAPCELL_ROW_29_388 VGND VPWR sky130_fd_sc_hd__tapvpwrvgnd_1
XFILLER_0_24_146 VGND VGND VPWR VPWR sky130_fd_sc_hd__decap_8
XTAP_TAPCELL_ROW_12_255 VGND VPWR sky130_fd_sc_hd__tapvpwrvgnd_1
XFILLER_0_20_341 VGND VGND VPWR VPWR sky130_fd_sc_hd__decap_8
XFILLER_0_21_69 VGND VGND VPWR VPWR sky130_fd_sc_hd__decap_4
X_2261_ reg_file.registers\[11\]\[5\] _0828_ _0829_ reg_file.registers\[10\]\[5\]
+ VGND VGND VPWR VPWR _1073_ sky130_fd_sc_hd__a22o_1
X_2192_ _0871_ _0967_ VGND VGND VPWR VPWR _1006_ sky130_fd_sc_hd__or2_1
XFILLER_0_46_77 VGND VGND VPWR VPWR sky130_fd_sc_hd__decap_6
X_2330_ reg_file.registers\[5\]\[4\] _0570_ VGND VGND VPWR VPWR _1138_ sky130_fd_sc_hd__nand2_1
XFILLER_0_20_363 VGND VGND VPWR VPWR sky130_fd_sc_hd__fill_1
XTAP_TAPCELL_ROW_63_656 VGND VPWR sky130_fd_sc_hd__tapvpwrvgnd_1
XFILLER_0_62_76 VGND VGND VPWR VPWR sky130_fd_sc_hd__fill_1
XFILLER_0_1_57 VPWR VGND VPWR VGND sky130_ef_sc_hd__decap_12
XFILLER_0_7_335 VGND VGND VPWR VPWR sky130_fd_sc_hd__fill_1
X_1976_ _0791_ _0782_ _0787_ _0778_ VGND VGND VPWR VPWR _0792_ sky130_fd_sc_hd__or4_4
XFILLER_0_60_3 VPWR VGND VPWR VGND sky130_ef_sc_hd__decap_12
XFILLER_0_30_127 VGND VGND VPWR VPWR sky130_fd_sc_hd__decap_6
X_2528_ reg_file.registers\[15\]\[19\] _1293_ VGND VGND VPWR VPWR _1300_ sky130_fd_sc_hd__and2_1
XFILLER_0_11_363 VPWR VGND VPWR VGND sky130_ef_sc_hd__decap_12
X_2459_ _0471_ _1249_ _1250_ _1202_ _1042_ VGND VGND VPWR VPWR _1251_ sky130_fd_sc_hd__a32o_1
XFILLER_0_53_208 VGND VGND VPWR VPWR sky130_fd_sc_hd__fill_1
XFILLER_0_61_241 VGND VGND VPWR VPWR sky130_fd_sc_hd__fill_1
XFILLER_0_46_282 VGND VGND VPWR VPWR sky130_fd_sc_hd__decap_4
XFILLER_0_69_385 VGND VGND VPWR VPWR sky130_fd_sc_hd__decap_6
XTAP_TAPCELL_ROW_60_637 VGND VPWR sky130_fd_sc_hd__tapvpwrvgnd_1
X_1830_ _0640_ _0645_ VGND VGND VPWR VPWR _0646_ sky130_fd_sc_hd__and2_1
X_1761_ _0566_ _0576_ VGND VGND VPWR VPWR _0577_ sky130_fd_sc_hd__and2_1
X_2313_ _1120_ _1121_ _0909_ VGND VGND VPWR VPWR _1122_ sky130_fd_sc_hd__mux2_1
X_1692_ _0372_ _0507_ _0389_ VGND VGND VPWR VPWR _0508_ sky130_fd_sc_hd__or3_4
XPHY_EDGE_ROW_69_Left_141 VGND VGND VPWR VPWR sky130_fd_sc_hd__decap_3
X_2244_ net32 _1055_ _0606_ VGND VGND VPWR VPWR _1056_ sky130_fd_sc_hd__a21oi_4
X_2175_ _0796_ _0767_ _0872_ VGND VGND VPWR VPWR _0989_ sky130_fd_sc_hd__mux2_1
XFILLER_0_35_208 VGND VGND VPWR VPWR sky130_fd_sc_hd__fill_1
XTAP_TAPCELL_ROW_23_339 VGND VPWR sky130_fd_sc_hd__tapvpwrvgnd_1
X_1959_ _0641_ VGND VGND VPWR VPWR _0775_ sky130_fd_sc_hd__clkbuf_4
XFILLER_0_31_447 VGND VGND VPWR VPWR sky130_fd_sc_hd__fill_1
XFILLER_0_31_414 VPWR VGND VPWR VGND sky130_ef_sc_hd__decap_12
XFILLER_0_22_90 VGND VGND VPWR VPWR sky130_fd_sc_hd__fill_2
XFILLER_0_3_393 VPWR VGND VPWR VGND sky130_ef_sc_hd__decap_12
Xoutput16 net16 VGND VGND VPWR VPWR seg[6] sky130_fd_sc_hd__buf_1
XFILLER_0_11_193 VPWR VGND VPWR VGND sky130_ef_sc_hd__decap_12
XFILLER_0_66_377 VPWR VGND VPWR VGND sky130_ef_sc_hd__decap_12
Xclkbuf_0_clk clk VGND VGND VPWR VPWR clknet_0_clk sky130_fd_sc_hd__clkbuf_16
X_2931_ _1471_ VGND VGND VPWR VPWR _0173_ sky130_fd_sc_hd__inv_2
X_2793_ _1453_ VGND VGND VPWR VPWR _0053_ sky130_fd_sc_hd__inv_2
X_1813_ reg_file.registers\[10\]\[15\] _0507_ _0607_ reg_file.registers\[11\]\[15\]
+ VGND VGND VPWR VPWR _0629_ sky130_fd_sc_hd__a22o_1
X_1744_ reg_file.registers\[15\]\[18\] _0543_ _0537_ reg_file.registers\[5\]\[18\]
+ _0529_ VGND VGND VPWR VPWR _0560_ sky130_fd_sc_hd__a221o_1
X_2862_ _1463_ VGND VGND VPWR VPWR _0112_ sky130_fd_sc_hd__inv_2
XFILLER_0_68_53 VPWR VGND VPWR VGND sky130_ef_sc_hd__decap_12
X_1675_ _0375_ _0376_ _0479_ VGND VGND VPWR VPWR _0491_ sky130_fd_sc_hd__nor3b_1
XPHY_EDGE_ROW_15_Right_15 VGND VGND VPWR VPWR sky130_fd_sc_hd__decap_3
X_2158_ _0645_ _0737_ _0877_ VGND VGND VPWR VPWR _0973_ sky130_fd_sc_hd__mux2_1
XTAP_TAPCELL_ROW_36_442 VGND VPWR sky130_fd_sc_hd__tapvpwrvgnd_1
X_2227_ _0941_ _0954_ _0882_ VGND VGND VPWR VPWR _1040_ sky130_fd_sc_hd__mux2_1
XPHY_EDGE_ROW_24_Right_24 VGND VGND VPWR VPWR sky130_fd_sc_hd__decap_3
X_2089_ _0615_ _0618_ _0889_ VGND VGND VPWR VPWR _0905_ sky130_fd_sc_hd__mux2_1
XFILLER_0_23_3 VPWR VGND VPWR VGND sky130_ef_sc_hd__decap_12
XFILLER_0_63_303 VGND VGND VPWR VPWR sky130_fd_sc_hd__decap_4
XFILLER_0_48_388 VGND VGND VPWR VPWR sky130_fd_sc_hd__fill_2
XPHY_EDGE_ROW_33_Right_33 VGND VGND VPWR VPWR sky130_fd_sc_hd__decap_3
XFILLER_0_66_141 VPWR VGND VPWR VGND sky130_ef_sc_hd__decap_12
XPHY_EDGE_ROW_42_Right_42 VGND VGND VPWR VPWR sky130_fd_sc_hd__decap_3
XFILLER_0_39_311 VPWR VGND VPWR VGND sky130_ef_sc_hd__decap_12
XFILLER_0_13_15 VPWR VGND VPWR VGND sky130_ef_sc_hd__decap_12
XPHY_EDGE_ROW_51_Right_51 VGND VGND VPWR VPWR sky130_fd_sc_hd__decap_3
XTAP_TAPCELL_ROW_42_489 VGND VPWR sky130_fd_sc_hd__tapvpwrvgnd_1
XFILLER_0_1_105 VGND VGND VPWR VPWR sky130_fd_sc_hd__decap_6
XFILLER_0_38_45 VGND VGND VPWR VPWR sky130_fd_sc_hd__decap_4
X_3130_ clknet_leaf_21_clk _0353_ _0189_ VGND VGND VPWR VPWR reg_file.registers\[2\]\[30\]
+ sky130_fd_sc_hd__dfrtp_1
XFILLER_0_1_149 VPWR VGND VPWR VGND sky130_ef_sc_hd__decap_12
XPHY_EDGE_ROW_60_Right_60 VGND VGND VPWR VPWR sky130_fd_sc_hd__decap_3
X_2012_ _0683_ VGND VGND VPWR VPWR _0828_ sky130_fd_sc_hd__clkbuf_4
XFILLER_0_54_77 VGND VGND VPWR VPWR sky130_fd_sc_hd__decap_6
X_3061_ clknet_leaf_16_clk _0284_ _0120_ VGND VGND VPWR VPWR reg_file.registers\[11\]\[31\]
+ sky130_fd_sc_hd__dfrtp_1
XFILLER_0_70_65 VPWR VGND VPWR VGND sky130_ef_sc_hd__decap_12
X_2845_ _1460_ VGND VGND VPWR VPWR _0098_ sky130_fd_sc_hd__inv_2
X_2914_ _1469_ VGND VGND VPWR VPWR _0158_ sky130_fd_sc_hd__inv_2
XTAP_TAPCELL_ROW_33_423 VGND VPWR sky130_fd_sc_hd__tapvpwrvgnd_1
XFILLER_0_9_205 VPWR VGND VPWR VGND sky130_ef_sc_hd__decap_12
XFILLER_0_9_249 VPWR VGND VPWR VGND sky130_ef_sc_hd__decap_12
X_2776_ _1452_ VGND VGND VPWR VPWR _0037_ sky130_fd_sc_hd__inv_2
X_1658_ imem.address\[3\] _0473_ VGND VGND VPWR VPWR _0474_ sky130_fd_sc_hd__and2_1
X_1727_ _0485_ VGND VGND VPWR VPWR _0543_ sky130_fd_sc_hd__clkbuf_4
XFILLER_0_13_222 VGND VGND VPWR VPWR sky130_fd_sc_hd__fill_2
XFILLER_0_0_193 VGND VGND VPWR VPWR sky130_fd_sc_hd__decap_3
X_1589_ _0433_ VGND VGND VPWR VPWR _0313_ sky130_fd_sc_hd__clkbuf_1
XFILLER_0_48_152 VGND VGND VPWR VPWR sky130_fd_sc_hd__fill_1
XFILLER_0_36_314 VGND VGND VPWR VPWR sky130_fd_sc_hd__decap_8
XTAP_TAPCELL_ROW_55_592 VGND VPWR sky130_fd_sc_hd__tapvpwrvgnd_1
XFILLER_0_27_314 VGND VGND VPWR VPWR sky130_fd_sc_hd__decap_4
X_2630_ _1322_ _1356_ VGND VGND VPWR VPWR _0195_ sky130_fd_sc_hd__nor2_1
X_1512_ _0372_ _0373_ _0391_ VGND VGND VPWR VPWR _0392_ sky130_fd_sc_hd__or3_2
X_2492_ reg_file.registers\[11\]\[1\] _1277_ _0932_ VGND VGND VPWR VPWR _1278_ sky130_fd_sc_hd__mux2_1
XFILLER_0_50_394 VGND VGND VPWR VPWR sky130_fd_sc_hd__decap_6
X_2561_ reg_file.registers\[15\]\[3\] _1286_ VGND VGND VPWR VPWR _1317_ sky130_fd_sc_hd__or2b_1
XFILLER_0_42_339 VPWR VGND VPWR VGND sky130_ef_sc_hd__decap_12
XFILLER_0_35_391 VGND VGND VPWR VPWR sky130_fd_sc_hd__fill_1
X_3113_ clknet_leaf_21_clk _0336_ _0172_ VGND VGND VPWR VPWR reg_file.registers\[5\]\[19\]
+ sky130_fd_sc_hd__dfrtp_1
X_3044_ clknet_leaf_1_clk _0267_ _0103_ VGND VGND VPWR VPWR reg_file.registers\[11\]\[14\]
+ sky130_fd_sc_hd__dfrtp_1
XFILLER_0_60_147 VGND VGND VPWR VPWR sky130_fd_sc_hd__fill_1
XFILLER_0_60_103 VPWR VGND VPWR VGND sky130_ef_sc_hd__decap_12
XFILLER_0_45_199 VGND VGND VPWR VPWR sky130_fd_sc_hd__decap_8
X_2828_ _1456_ VGND VGND VPWR VPWR _0085_ sky130_fd_sc_hd__inv_2
X_2759_ _1446_ _1447_ VGND VGND VPWR VPWR _1448_ sky130_fd_sc_hd__and2_1
XTAP_TAPCELL_ROW_52_573 VGND VPWR sky130_fd_sc_hd__tapvpwrvgnd_1
XTAP_TAPCELL_ROW_44_507 VGND VPWR sky130_fd_sc_hd__tapvpwrvgnd_1
XTAP_TAPCELL_ROW_1_162 VGND VPWR sky130_fd_sc_hd__tapvpwrvgnd_1
XFILLER_0_51_169 VPWR VGND VPWR VGND sky130_ef_sc_hd__decap_12
XFILLER_0_10_27 VGND VGND VPWR VPWR sky130_fd_sc_hd__fill_1
XFILLER_0_17_391 VGND VGND VPWR VPWR sky130_fd_sc_hd__fill_1
XFILLER_0_19_69 VPWR VGND VPWR VGND sky130_ef_sc_hd__decap_12
XFILLER_0_59_258 VGND VGND VPWR VPWR sky130_fd_sc_hd__fill_1
XFILLER_0_59_225 VGND VGND VPWR VPWR sky130_fd_sc_hd__decap_3
XPHY_EDGE_ROW_32_Left_104 VGND VGND VPWR VPWR sky130_fd_sc_hd__decap_3
XFILLER_0_70_445 VGND VGND VPWR VPWR sky130_fd_sc_hd__decap_6
XFILLER_0_70_401 VPWR VGND VPWR VGND sky130_ef_sc_hd__decap_12
XFILLER_0_51_89 VGND VGND VPWR VPWR sky130_fd_sc_hd__decap_3
XPHY_EDGE_ROW_41_Left_113 VGND VGND VPWR VPWR sky130_fd_sc_hd__decap_3
XFILLER_0_27_177 VGND VGND VPWR VPWR sky130_fd_sc_hd__fill_1
XFILLER_0_27_166 VGND VGND VPWR VPWR sky130_fd_sc_hd__fill_2
XFILLER_0_27_155 VGND VGND VPWR VPWR sky130_fd_sc_hd__decap_3
XFILLER_0_27_100 VPWR VGND VPWR VGND sky130_ef_sc_hd__decap_12
X_1992_ _0789_ _0806_ _0807_ VGND VGND VPWR VPWR _0808_ sky130_fd_sc_hd__a21bo_1
XTAP_TAPCELL_ROW_15_275 VGND VPWR sky130_fd_sc_hd__tapvpwrvgnd_1
Xclkload10 clknet_leaf_19_clk VGND VGND VPWR VPWR clkload10/Y sky130_fd_sc_hd__inv_8
X_2613_ imem.address\[16\] _1328_ VGND VGND VPWR VPWR _0205_ sky130_fd_sc_hd__xor2_1
X_2475_ reg_file.registers\[11\]\[4\] _1263_ _1234_ VGND VGND VPWR VPWR _1264_ sky130_fd_sc_hd__mux2_1
XFILLER_0_50_180 VGND VGND VPWR VPWR sky130_fd_sc_hd__decap_4
X_2544_ _1308_ VGND VGND VPWR VPWR _0233_ sky130_fd_sc_hd__clkbuf_1
XFILLER_0_30_309 VPWR VGND VPWR VGND sky130_ef_sc_hd__decap_12
XFILLER_0_2_277 VPWR VGND VPWR VGND sky130_ef_sc_hd__decap_12
XFILLER_0_2_233 VPWR VGND VPWR VGND sky130_ef_sc_hd__decap_12
XPHY_EDGE_ROW_50_Left_122 VGND VGND VPWR VPWR sky130_fd_sc_hd__decap_3
XTAP_TAPCELL_ROW_66_687 VGND VPWR sky130_fd_sc_hd__tapvpwrvgnd_1
X_3027_ clknet_leaf_18_clk _0250_ _0086_ VGND VGND VPWR VPWR reg_file.registers\[15\]\[29\]
+ sky130_fd_sc_hd__dfrtp_1
Xclkload4 clknet_leaf_3_clk VGND VGND VPWR VPWR clkload4/Y sky130_fd_sc_hd__clkinvlp_4
XFILLER_0_33_147 VPWR VGND VPWR VGND sky130_ef_sc_hd__decap_12
XFILLER_0_14_350 VGND VGND VPWR VPWR sky130_fd_sc_hd__fill_1
XTAP_TAPCELL_ROW_57_610 VGND VPWR sky130_fd_sc_hd__tapvpwrvgnd_1
XTAP_TAPCELL_ROW_29_389 VGND VPWR sky130_fd_sc_hd__tapvpwrvgnd_1
XFILLER_0_71_209 VPWR VGND VPWR VGND sky130_ef_sc_hd__decap_12
XFILLER_0_21_15 VPWR VGND VPWR VGND sky130_ef_sc_hd__decap_12
XFILLER_0_12_309 VGND VGND VPWR VPWR sky130_fd_sc_hd__fill_2
X_2191_ _1001_ _1004_ _0897_ VGND VGND VPWR VPWR _1005_ sky130_fd_sc_hd__mux2_1
X_2260_ _0894_ _1071_ VGND VGND VPWR VPWR _1072_ sky130_fd_sc_hd__and2_1
XTAP_TAPCELL_ROW_63_657 VGND VPWR sky130_fd_sc_hd__tapvpwrvgnd_1
XFILLER_0_1_69 VPWR VGND VPWR VGND sky130_ef_sc_hd__decap_12
XFILLER_0_70_253 VPWR VGND VPWR VGND sky130_ef_sc_hd__decap_12
XFILLER_0_43_412 VPWR VGND VPWR VGND sky130_ef_sc_hd__decap_12
XFILLER_0_43_401 VGND VGND VPWR VPWR sky130_fd_sc_hd__fill_2
X_1975_ _0789_ _0790_ VGND VGND VPWR VPWR _0791_ sky130_fd_sc_hd__xnor2_1
XFILLER_0_11_81 VPWR VGND VPWR VGND sky130_ef_sc_hd__decap_12
XFILLER_0_15_169 VPWR VGND VPWR VGND sky130_ef_sc_hd__decap_12
X_2458_ _0656_ _0698_ _1248_ _0705_ VGND VGND VPWR VPWR _1250_ sky130_fd_sc_hd__a211o_1
XFILLER_0_53_3 VPWR VGND VPWR VGND sky130_ef_sc_hd__decap_12
XFILLER_0_11_375 VGND VGND VPWR VPWR sky130_fd_sc_hd__decap_8
X_2527_ _1299_ VGND VGND VPWR VPWR _0241_ sky130_fd_sc_hd__clkbuf_1
X_2389_ _0719_ _0721_ _0728_ _0706_ VGND VGND VPWR VPWR _1189_ sky130_fd_sc_hd__nor4_1
XPHY_EDGE_ROW_7_Left_79 VGND VGND VPWR VPWR sky130_fd_sc_hd__decap_3
XFILLER_0_19_420 VGND VGND VPWR VPWR sky130_fd_sc_hd__decap_8
XFILLER_0_21_106 VGND VGND VPWR VPWR sky130_fd_sc_hd__fill_2
XFILLER_0_16_15 VPWR VGND VPWR VGND sky130_ef_sc_hd__decap_12
XTAP_TAPCELL_ROW_60_638 VGND VPWR sky130_fd_sc_hd__tapvpwrvgnd_1
X_1691_ _0381_ _0386_ _0377_ _0474_ VGND VGND VPWR VPWR _0507_ sky130_fd_sc_hd__and4_2
XFILLER_0_52_253 VPWR VGND VPWR VGND sky130_ef_sc_hd__decap_12
XFILLER_0_25_423 VGND VGND VPWR VPWR sky130_fd_sc_hd__fill_1
X_1760_ reg_file.registers\[15\]\[23\] _0569_ _0570_ reg_file.registers\[5\]\[23\]
+ VGND VGND VPWR VPWR _0576_ sky130_fd_sc_hd__a22o_1
XFILLER_0_57_55 VGND VGND VPWR VPWR sky130_fd_sc_hd__fill_1
X_2312_ _0665_ _0666_ _0967_ VGND VGND VPWR VPWR _1121_ sky130_fd_sc_hd__and3_1
XFILLER_0_12_139 VGND VGND VPWR VPWR sky130_fd_sc_hd__fill_1
XFILLER_0_57_88 VGND VGND VPWR VPWR sky130_fd_sc_hd__decap_4
X_2243_ _0556_ _0523_ _0521_ _1054_ VGND VGND VPWR VPWR _1055_ sky130_fd_sc_hd__or4_1
X_2174_ _0986_ _0987_ _0902_ VGND VGND VPWR VPWR _0988_ sky130_fd_sc_hd__mux2_1
XFILLER_0_28_250 VGND VGND VPWR VPWR sky130_fd_sc_hd__fill_2
XFILLER_0_7_111 VGND VGND VPWR VPWR sky130_fd_sc_hd__fill_1
XFILLER_0_16_401 VGND VGND VPWR VPWR sky130_fd_sc_hd__decap_6
X_1889_ _0701_ _0704_ VGND VGND VPWR VPWR _0705_ sky130_fd_sc_hd__nor2_1
XFILLER_0_31_426 VGND VGND VPWR VPWR sky130_fd_sc_hd__fill_2
XFILLER_0_3_361 VPWR VGND VPWR VGND sky130_ef_sc_hd__decap_12
X_1958_ _0772_ _0773_ _0575_ VGND VGND VPWR VPWR _0774_ sky130_fd_sc_hd__mux2_4
XFILLER_0_11_161 VGND VGND VPWR VPWR sky130_fd_sc_hd__decap_6
XFILLER_0_66_389 VPWR VGND VPWR VGND sky130_ef_sc_hd__decap_12
XFILLER_0_57_345 VPWR VGND VPWR VGND sky130_ef_sc_hd__decap_12
XFILLER_0_43_57 VGND VGND VPWR VPWR sky130_fd_sc_hd__decap_3
X_2930_ _1468_ VGND VGND VPWR VPWR _1471_ sky130_fd_sc_hd__buf_4
X_2861_ _1463_ VGND VGND VPWR VPWR _0111_ sky130_fd_sc_hd__inv_2
X_1674_ _0381_ _0386_ _0378_ _0474_ VGND VGND VPWR VPWR _0490_ sky130_fd_sc_hd__and4_4
X_2792_ _1453_ VGND VGND VPWR VPWR _0052_ sky130_fd_sc_hd__inv_2
XFILLER_0_40_234 VGND VGND VPWR VPWR sky130_fd_sc_hd__fill_2
X_1812_ _0623_ _0626_ _0627_ VGND VGND VPWR VPWR _0628_ sky130_fd_sc_hd__and3b_1
X_1743_ net17 _0552_ _0558_ VGND VGND VPWR VPWR _0559_ sky130_fd_sc_hd__nand3_4
XFILLER_0_25_297 VGND VGND VPWR VPWR sky130_fd_sc_hd__decap_8
XFILLER_0_25_264 VGND VGND VPWR VPWR sky130_fd_sc_hd__decap_3
XFILLER_0_7_57 VPWR VGND VPWR VGND sky130_ef_sc_hd__decap_12
XFILLER_0_68_65 VPWR VGND VPWR VGND sky130_ef_sc_hd__decap_12
X_2226_ _1038_ VGND VGND VPWR VPWR _1039_ sky130_fd_sc_hd__inv_2
X_2157_ _0635_ _0741_ _0877_ VGND VGND VPWR VPWR _0972_ sky130_fd_sc_hd__mux2_1
XTAP_TAPCELL_ROW_36_443 VGND VPWR sky130_fd_sc_hd__tapvpwrvgnd_1
X_2088_ _0899_ _0900_ _0903_ VGND VGND VPWR VPWR _0904_ sky130_fd_sc_hd__mux2_1
XFILLER_0_16_3 VPWR VGND VPWR VGND sky130_ef_sc_hd__decap_12
XFILLER_0_63_315 VPWR VGND VPWR VGND sky130_ef_sc_hd__decap_12
XFILLER_0_66_197 VGND VGND VPWR VPWR sky130_fd_sc_hd__decap_8
XFILLER_0_66_153 VGND VGND VPWR VPWR sky130_fd_sc_hd__fill_2
XFILLER_0_54_315 VGND VGND VPWR VPWR sky130_fd_sc_hd__decap_8
XFILLER_0_39_323 VPWR VGND VPWR VGND sky130_ef_sc_hd__decap_12
XFILLER_0_13_27 VPWR VGND VPWR VGND sky130_ef_sc_hd__decap_12
XFILLER_0_10_407 VPWR VGND VPWR VGND sky130_ef_sc_hd__decap_12
XFILLER_0_38_35 VGND VGND VPWR VPWR sky130_fd_sc_hd__fill_1
X_3060_ clknet_leaf_13_clk _0283_ _0119_ VGND VGND VPWR VPWR reg_file.registers\[11\]\[30\]
+ sky130_fd_sc_hd__dfrtp_1
X_2011_ reg_file.registers\[10\]\[27\] _0605_ _0610_ reg_file.registers\[11\]\[27\]
+ VGND VGND VPWR VPWR _0827_ sky130_fd_sc_hd__a22o_1
XFILLER_0_70_77 VGND VGND VPWR VPWR sky130_fd_sc_hd__decap_6
X_2844_ _1460_ VGND VGND VPWR VPWR _0097_ sky130_fd_sc_hd__inv_2
X_2913_ _1469_ VGND VGND VPWR VPWR _0157_ sky130_fd_sc_hd__inv_2
XFILLER_0_9_217 VGND VGND VPWR VPWR sky130_fd_sc_hd__decap_6
X_2775_ _1450_ VGND VGND VPWR VPWR _1452_ sky130_fd_sc_hd__buf_4
X_1657_ _0372_ VGND VGND VPWR VPWR _0473_ sky130_fd_sc_hd__inv_2
X_1726_ _0488_ _0541_ _0539_ _0536_ VGND VGND VPWR VPWR _0542_ sky130_fd_sc_hd__nor4_4
X_1588_ reg_file.registers\[10\]\[28\] _0429_ VGND VGND VPWR VPWR _0433_ sky130_fd_sc_hd__and2_1
X_2209_ _0824_ _0845_ _1021_ _0848_ VGND VGND VPWR VPWR _1022_ sky130_fd_sc_hd__a211o_1
XFILLER_0_48_131 VGND VGND VPWR VPWR sky130_fd_sc_hd__fill_1
XFILLER_0_48_197 VGND VGND VPWR VPWR sky130_fd_sc_hd__fill_2
XFILLER_0_44_381 VGND VGND VPWR VPWR sky130_fd_sc_hd__fill_2
XFILLER_0_5_3 VPWR VGND VPWR VGND sky130_ef_sc_hd__decap_12
XFILLER_0_24_15 VPWR VGND VPWR VGND sky130_ef_sc_hd__decap_12
XTAP_TAPCELL_ROW_55_593 VGND VPWR sky130_fd_sc_hd__tapvpwrvgnd_1
XFILLER_0_54_167 VGND VGND VPWR VPWR sky130_fd_sc_hd__decap_6
XFILLER_0_54_156 VGND VGND VPWR VPWR sky130_fd_sc_hd__fill_2
XFILLER_0_42_329 VGND VGND VPWR VPWR sky130_fd_sc_hd__fill_1
XFILLER_0_42_307 VGND VGND VPWR VPWR sky130_fd_sc_hd__fill_1
XFILLER_0_40_69 VGND VGND VPWR VPWR sky130_fd_sc_hd__decap_8
XFILLER_0_27_359 VGND VGND VPWR VPWR sky130_fd_sc_hd__decap_8
XFILLER_0_27_337 VGND VGND VPWR VPWR sky130_fd_sc_hd__fill_2
XFILLER_0_6_209 VPWR VGND VPWR VGND sky130_ef_sc_hd__decap_12
X_1511_ prev_control net38 net1 VGND VGND VPWR VPWR _0391_ sky130_fd_sc_hd__or3b_2
X_2491_ _1140_ _1107_ _1276_ _0472_ VGND VGND VPWR VPWR _1277_ sky130_fd_sc_hd__a22o_2
X_2560_ _1316_ VGND VGND VPWR VPWR _0225_ sky130_fd_sc_hd__clkbuf_1
XFILLER_0_35_370 VGND VGND VPWR VPWR sky130_fd_sc_hd__decap_3
XFILLER_0_10_259 VGND VGND VPWR VPWR sky130_fd_sc_hd__fill_1
XFILLER_0_65_88 VGND VGND VPWR VPWR sky130_fd_sc_hd__fill_1
X_3043_ clknet_1_0__leaf_clk _0266_ _0102_ VGND VGND VPWR VPWR reg_file.registers\[11\]\[13\]
+ sky130_fd_sc_hd__dfrtp_1
X_3112_ clknet_leaf_21_clk _0335_ _0171_ VGND VGND VPWR VPWR reg_file.registers\[5\]\[18\]
+ sky130_fd_sc_hd__dfrtp_1
XFILLER_0_18_315 VGND VGND VPWR VPWR sky130_fd_sc_hd__fill_1
XFILLER_0_60_115 VPWR VGND VPWR VGND sky130_ef_sc_hd__decap_12
XFILLER_0_45_178 VGND VGND VPWR VPWR sky130_fd_sc_hd__decap_4
XFILLER_0_45_156 VGND VGND VPWR VPWR sky130_fd_sc_hd__fill_1
X_2758_ display.counter\[19\] _1444_ VGND VGND VPWR VPWR _1447_ sky130_fd_sc_hd__or2_1
X_2827_ _1456_ VGND VGND VPWR VPWR _0084_ sky130_fd_sc_hd__inv_2
XFILLER_0_18_348 VGND VGND VPWR VPWR sky130_fd_sc_hd__decap_4
X_1709_ _0390_ _0515_ _0521_ _0524_ VGND VGND VPWR VPWR _0525_ sky130_fd_sc_hd__o22a_1
X_2689_ _1393_ _1403_ VGND VGND VPWR VPWR _1407_ sky130_fd_sc_hd__or2_1
XTAP_TAPCELL_ROW_44_508 VGND VPWR sky130_fd_sc_hd__tapvpwrvgnd_1
XTAP_TAPCELL_ROW_1_163 VGND VPWR sky130_fd_sc_hd__tapvpwrvgnd_1
XFILLER_0_64_421 VPWR VGND VPWR VGND sky130_ef_sc_hd__decap_12
XTAP_TAPCELL_ROW_52_574 VGND VPWR sky130_fd_sc_hd__tapvpwrvgnd_1
XFILLER_0_51_104 VGND VGND VPWR VPWR sky130_fd_sc_hd__decap_8
XTAP_TAPCELL_ROW_9_230 VGND VPWR sky130_fd_sc_hd__tapvpwrvgnd_1
XFILLER_0_19_15 VPWR VGND VPWR VGND sky130_ef_sc_hd__decap_12
XFILLER_0_67_270 VGND VGND VPWR VPWR sky130_fd_sc_hd__fill_1
XFILLER_0_70_413 VGND VGND VPWR VPWR sky130_fd_sc_hd__decap_6
XFILLER_0_67_281 VGND VGND VPWR VPWR sky130_fd_sc_hd__decap_8
X_2612_ _1329_ _1349_ VGND VGND VPWR VPWR _0206_ sky130_fd_sc_hd__nor2_1
XFILLER_0_51_57 VGND VGND VPWR VPWR sky130_fd_sc_hd__fill_1
X_1991_ _0784_ _0785_ VGND VGND VPWR VPWR _0807_ sky130_fd_sc_hd__or2b_1
XTAP_TAPCELL_ROW_15_276 VGND VPWR sky130_fd_sc_hd__tapvpwrvgnd_1
XFILLER_0_15_329 VGND VGND VPWR VPWR sky130_fd_sc_hd__decap_6
Xclkload11 clknet_leaf_20_clk VGND VGND VPWR VPWR clkload11/Y sky130_fd_sc_hd__bufinv_16
X_2474_ _0469_ _1256_ _1262_ _1041_ _1161_ VGND VGND VPWR VPWR _1263_ sky130_fd_sc_hd__a32o_1
X_2543_ reg_file.registers\[15\]\[12\] _1304_ VGND VGND VPWR VPWR _1308_ sky130_fd_sc_hd__and2_1
XFILLER_0_23_384 VGND VGND VPWR VPWR sky130_fd_sc_hd__decap_8
XFILLER_0_2_289 VPWR VGND VPWR VGND sky130_ef_sc_hd__decap_12
XFILLER_0_2_245 VGND VGND VPWR VPWR sky130_fd_sc_hd__decap_6
X_3026_ clknet_leaf_19_clk _0249_ _0085_ VGND VGND VPWR VPWR reg_file.registers\[15\]\[28\]
+ sky130_fd_sc_hd__dfrtp_1
Xclkload5 clknet_leaf_4_clk VGND VGND VPWR VPWR clkload5/Y sky130_fd_sc_hd__clkinv_2
XFILLER_0_14_340 VGND VGND VPWR VPWR sky130_fd_sc_hd__fill_1
XTAP_TAPCELL_ROW_57_611 VGND VPWR sky130_fd_sc_hd__tapvpwrvgnd_1
XTAP_TAPCELL_ROW_6_200 VGND VPWR sky130_fd_sc_hd__tapvpwrvgnd_1
XFILLER_0_49_281 VPWR VGND VPWR VGND sky130_ef_sc_hd__decap_12
XFILLER_0_37_421 VGND VGND VPWR VPWR sky130_fd_sc_hd__decap_3
XFILLER_0_21_27 VPWR VGND VPWR VGND sky130_ef_sc_hd__decap_12
X_2190_ _1002_ _1003_ _0902_ VGND VGND VPWR VPWR _1004_ sky130_fd_sc_hd__mux2_1
XFILLER_0_1_15 VPWR VGND VPWR VGND sky130_ef_sc_hd__decap_12
XTAP_TAPCELL_ROW_63_658 VGND VPWR sky130_fd_sc_hd__tapvpwrvgnd_1
XFILLER_0_55_240 VGND VGND VPWR VPWR sky130_fd_sc_hd__fill_2
X_1974_ reg_file.registers\[10\]\[21\] _0775_ _0776_ reg_file.registers\[11\]\[21\]
+ VGND VGND VPWR VPWR _0790_ sky130_fd_sc_hd__a22o_1
XPHY_EDGE_ROW_23_Left_95 VGND VGND VPWR VPWR sky130_fd_sc_hd__decap_3
XFILLER_0_70_265 VPWR VGND VPWR VGND sky130_ef_sc_hd__decap_12
XFILLER_0_70_221 VPWR VGND VPWR VGND sky130_ef_sc_hd__decap_12
XFILLER_0_55_295 VGND VGND VPWR VPWR sky130_fd_sc_hd__fill_2
XFILLER_0_43_424 VPWR VGND VPWR VGND sky130_ef_sc_hd__decap_12
XFILLER_0_23_192 VPWR VGND VPWR VGND sky130_ef_sc_hd__decap_12
XFILLER_0_11_93 VPWR VGND VPWR VGND sky130_ef_sc_hd__decap_12
XFILLER_0_11_332 VGND VGND VPWR VPWR sky130_fd_sc_hd__decap_4
X_2457_ _0705_ _1248_ _0698_ _0656_ VGND VGND VPWR VPWR _1249_ sky130_fd_sc_hd__o211ai_1
XFILLER_0_46_3 VPWR VGND VPWR VGND sky130_ef_sc_hd__decap_12
X_2388_ _1188_ VGND VGND VPWR VPWR _0269_ sky130_fd_sc_hd__clkbuf_1
X_2526_ reg_file.registers\[15\]\[20\] _1293_ VGND VGND VPWR VPWR _1299_ sky130_fd_sc_hd__and2_1
X_3009_ clknet_leaf_3_clk _0232_ _0068_ VGND VGND VPWR VPWR reg_file.registers\[15\]\[11\]
+ sky130_fd_sc_hd__dfrtp_1
XFILLER_0_14_181 VPWR VGND VPWR VGND sky130_ef_sc_hd__decap_12
XFILLER_0_21_118 VGND VGND VPWR VPWR sky130_fd_sc_hd__decap_3
XFILLER_0_16_27 VGND VGND VPWR VPWR sky130_fd_sc_hd__fill_1
XTAP_TAPCELL_ROW_60_639 VGND VPWR sky130_fd_sc_hd__tapvpwrvgnd_1
XFILLER_0_32_15 VPWR VGND VPWR VGND sky130_ef_sc_hd__decap_12
XFILLER_0_29_229 VGND VGND VPWR VPWR sky130_fd_sc_hd__fill_1
XFILLER_0_52_265 VGND VGND VPWR VPWR sky130_fd_sc_hd__decap_8
XFILLER_0_52_243 VGND VGND VPWR VPWR sky130_fd_sc_hd__fill_2
XFILLER_0_52_221 VGND VGND VPWR VPWR sky130_fd_sc_hd__decap_6
X_1690_ _0390_ _0476_ _0503_ _0505_ VGND VGND VPWR VPWR _0506_ sky130_fd_sc_hd__o211ai_4
XFILLER_0_40_405 VGND VGND VPWR VPWR sky130_fd_sc_hd__decap_3
XFILLER_0_4_307 VGND VGND VPWR VPWR sky130_fd_sc_hd__fill_1
X_2311_ _1034_ _1032_ _0665_ VGND VGND VPWR VPWR _1120_ sky130_fd_sc_hd__mux2_1
X_2242_ reg_file.registers\[2\]\[4\] _0494_ _0937_ VGND VGND VPWR VPWR _1054_ sky130_fd_sc_hd__a21o_1
X_2173_ _0794_ _0760_ _0879_ VGND VGND VPWR VPWR _0987_ sky130_fd_sc_hd__mux2_1
XFILLER_0_7_167 VGND VGND VPWR VPWR sky130_fd_sc_hd__fill_1
XFILLER_0_16_413 VGND VGND VPWR VPWR sky130_fd_sc_hd__decap_6
XFILLER_0_16_446 VGND VGND VPWR VPWR sky130_fd_sc_hd__fill_2
X_1957_ _0556_ _0577_ VGND VGND VPWR VPWR _0773_ sky130_fd_sc_hd__or2_1
X_1888_ reg_file.registers\[10\]\[7\] _0641_ _0642_ reg_file.registers\[11\]\[7\]
+ VGND VGND VPWR VPWR _0704_ sky130_fd_sc_hd__a22o_1
XFILLER_0_31_449 VGND VGND VPWR VPWR sky130_fd_sc_hd__fill_2
XFILLER_0_3_373 VPWR VGND VPWR VGND sky130_ef_sc_hd__decap_12
X_2509_ reg_file.registers\[15\]\[28\] _1286_ VGND VGND VPWR VPWR _1290_ sky130_fd_sc_hd__and2_1
XFILLER_0_66_302 VGND VGND VPWR VPWR sky130_fd_sc_hd__decap_3
XFILLER_0_34_232 VPWR VGND VPWR VGND sky130_ef_sc_hd__decap_12
XTAP_TAPCELL_ROW_22_330 VGND VPWR sky130_fd_sc_hd__tapvpwrvgnd_1
XFILLER_0_27_15 VPWR VGND VPWR VGND sky130_ef_sc_hd__decap_12
XFILLER_0_69_151 VGND VGND VPWR VPWR sky130_fd_sc_hd__decap_4
XFILLER_0_69_173 VGND VGND VPWR VPWR sky130_fd_sc_hd__decap_3
XFILLER_0_57_357 VPWR VGND VPWR VGND sky130_ef_sc_hd__decap_12
XFILLER_0_57_313 VGND VGND VPWR VPWR sky130_fd_sc_hd__fill_1
X_2791_ _1453_ VGND VGND VPWR VPWR _0051_ sky130_fd_sc_hd__inv_2
X_1811_ net17 _0552_ VGND VGND VPWR VPWR _0627_ sky130_fd_sc_hd__nand2_1
X_2860_ _1462_ VGND VGND VPWR VPWR _1463_ sky130_fd_sc_hd__buf_4
XFILLER_0_68_77 VGND VGND VPWR VPWR sky130_fd_sc_hd__decap_6
X_1673_ _0388_ _0378_ VGND VGND VPWR VPWR _0489_ sky130_fd_sc_hd__nand2_1
X_1742_ _0554_ _0557_ VGND VGND VPWR VPWR _0558_ sky130_fd_sc_hd__and2_1
XFILLER_0_25_287 VGND VGND VPWR VPWR sky130_fd_sc_hd__decap_3
XFILLER_0_7_69 VPWR VGND VPWR VGND sky130_ef_sc_hd__decap_12
XFILLER_0_0_321 VPWR VGND VPWR VGND sky130_ef_sc_hd__decap_12
XFILLER_0_13_449 VGND VGND VPWR VPWR sky130_fd_sc_hd__fill_2
X_2225_ _0909_ _1033_ _1037_ VGND VGND VPWR VPWR _1038_ sky130_fd_sc_hd__o21ai_1
XFILLER_0_0_365 VPWR VGND VPWR VGND sky130_ef_sc_hd__decap_12
X_2156_ _0962_ _0970_ net34 VGND VGND VPWR VPWR _0971_ sky130_fd_sc_hd__mux2_1
XTAP_TAPCELL_ROW_36_444 VGND VPWR sky130_fd_sc_hd__tapvpwrvgnd_1
X_2087_ _0902_ VGND VGND VPWR VPWR _0903_ sky130_fd_sc_hd__clkbuf_4
XPHY_EDGE_ROW_5_Right_5 VGND VGND VPWR VPWR sky130_fd_sc_hd__decap_3
XFILLER_0_17_81 VGND VGND VPWR VPWR sky130_fd_sc_hd__decap_6
Xclkbuf_leaf_18_clk clknet_1_0__leaf_clk VGND VGND VPWR VPWR clknet_leaf_18_clk sky130_fd_sc_hd__clkbuf_8
XFILLER_0_71_393 VPWR VGND VPWR VGND sky130_ef_sc_hd__decap_12
XFILLER_0_63_327 VGND VGND VPWR VPWR sky130_fd_sc_hd__decap_4
X_2989_ clknet_leaf_4_clk _0219_ _0055_ VGND VGND VPWR VPWR imem.address\[30\] sky130_fd_sc_hd__dfrtp_1
XFILLER_0_31_202 VGND VGND VPWR VPWR sky130_fd_sc_hd__decap_3
XFILLER_0_16_210 VGND VGND VPWR VPWR sky130_fd_sc_hd__fill_1
XFILLER_0_31_279 VGND VGND VPWR VPWR sky130_fd_sc_hd__fill_1
XFILLER_0_3_181 VPWR VGND VPWR VGND sky130_ef_sc_hd__decap_12
XPHY_EDGE_ROW_10_Left_82 VGND VGND VPWR VPWR sky130_fd_sc_hd__decap_3
XTAP_TAPCELL_ROW_70_712 VGND VPWR sky130_fd_sc_hd__tapvpwrvgnd_1
XFILLER_0_39_379 VGND VGND VPWR VPWR sky130_fd_sc_hd__decap_3
XFILLER_0_39_346 VGND VGND VPWR VPWR sky130_fd_sc_hd__decap_6
XFILLER_0_39_335 VGND VGND VPWR VPWR sky130_fd_sc_hd__fill_1
XFILLER_0_13_39 VPWR VGND VPWR VGND sky130_ef_sc_hd__decap_12
XFILLER_0_10_419 VGND VGND VPWR VPWR sky130_fd_sc_hd__fill_1
XFILLER_0_30_290 VGND VGND VPWR VPWR sky130_fd_sc_hd__decap_3
X_2010_ _0589_ _0825_ VGND VGND VPWR VPWR _0826_ sky130_fd_sc_hd__nand2_1
X_2912_ _1469_ VGND VGND VPWR VPWR _0156_ sky130_fd_sc_hd__inv_2
X_2774_ _1451_ VGND VGND VPWR VPWR _0036_ sky130_fd_sc_hd__inv_2
X_2843_ _1460_ VGND VGND VPWR VPWR _0096_ sky130_fd_sc_hd__inv_2
XFILLER_0_57_198 VGND VGND VPWR VPWR sky130_fd_sc_hd__fill_2
XFILLER_0_45_305 VPWR VGND VPWR VGND sky130_ef_sc_hd__decap_12
X_1725_ net29 _0540_ VGND VGND VPWR VPWR _0541_ sky130_fd_sc_hd__and2_2
XTAP_TAPCELL_ROW_41_480 VGND VPWR sky130_fd_sc_hd__tapvpwrvgnd_1
Xclkbuf_leaf_7_clk clknet_1_0__leaf_clk VGND VGND VPWR VPWR clknet_leaf_7_clk sky130_fd_sc_hd__clkbuf_8
X_1656_ _0471_ VGND VGND VPWR VPWR _0472_ sky130_fd_sc_hd__clkbuf_4
X_1587_ _0432_ VGND VGND VPWR VPWR _0314_ sky130_fd_sc_hd__clkbuf_1
XFILLER_0_13_246 VGND VGND VPWR VPWR sky130_fd_sc_hd__fill_2
XFILLER_0_13_279 VGND VGND VPWR VPWR sky130_fd_sc_hd__fill_1
XFILLER_0_68_419 VGND VGND VPWR VPWR sky130_fd_sc_hd__fill_1
X_2139_ _0801_ _0838_ _0871_ VGND VGND VPWR VPWR _0954_ sky130_fd_sc_hd__mux2_1
X_2208_ _0826_ _1018_ _0845_ _1019_ _1020_ VGND VGND VPWR VPWR _1021_ sky130_fd_sc_hd__a221o_1
XFILLER_0_8_251 VGND VGND VPWR VPWR sky130_fd_sc_hd__fill_1
XFILLER_0_67_441 VGND VGND VPWR VPWR sky130_fd_sc_hd__decap_6
XTAP_TAPCELL_ROW_55_594 VGND VPWR sky130_fd_sc_hd__tapvpwrvgnd_1
XTAP_TAPCELL_ROW_47_528 VGND VPWR sky130_fd_sc_hd__tapvpwrvgnd_1
XFILLER_0_39_143 VGND VGND VPWR VPWR sky130_fd_sc_hd__fill_1
XFILLER_0_24_27 VGND VGND VPWR VPWR sky130_fd_sc_hd__fill_1
XFILLER_0_40_15 VPWR VGND VPWR VGND sky130_ef_sc_hd__decap_12
XFILLER_0_35_393 VPWR VGND VPWR VGND sky130_ef_sc_hd__decap_12
XFILLER_0_50_385 VGND VGND VPWR VPWR sky130_fd_sc_hd__fill_1
XFILLER_0_50_352 VPWR VGND VPWR VGND sky130_ef_sc_hd__decap_12
XFILLER_0_49_57 VGND VGND VPWR VPWR sky130_fd_sc_hd__fill_2
X_2490_ _1273_ _1274_ _1275_ VGND VGND VPWR VPWR _1276_ sky130_fd_sc_hd__a21oi_1
X_1510_ _0389_ VGND VGND VPWR VPWR _0390_ sky130_fd_sc_hd__buf_6
XFILLER_0_4_15 VPWR VGND VPWR VGND sky130_ef_sc_hd__decap_12
X_3042_ clknet_leaf_1_clk _0265_ _0101_ VGND VGND VPWR VPWR reg_file.registers\[11\]\[12\]
+ sky130_fd_sc_hd__dfrtp_1
X_3111_ clknet_leaf_21_clk _0334_ _0170_ VGND VGND VPWR VPWR reg_file.registers\[5\]\[17\]
+ sky130_fd_sc_hd__dfrtp_1
XTAP_TAPCELL_ROW_18_296 VGND VPWR sky130_fd_sc_hd__tapvpwrvgnd_1
XFILLER_0_18_305 VGND VGND VPWR VPWR sky130_fd_sc_hd__decap_3
XFILLER_0_60_127 VGND VGND VPWR VPWR sky130_fd_sc_hd__fill_2
X_1708_ reg_file.registers\[5\]\[4\] _0467_ _0522_ reg_file.registers\[2\]\[4\] _0523_
+ VGND VGND VPWR VPWR _0524_ sky130_fd_sc_hd__a221o_1
X_2757_ display.counter\[19\] _1444_ VGND VGND VPWR VPWR _1446_ sky130_fd_sc_hd__nand2_1
XFILLER_0_30_81 VGND VGND VPWR VPWR sky130_fd_sc_hd__decap_3
XFILLER_0_30_70 VGND VGND VPWR VPWR sky130_fd_sc_hd__fill_1
X_2688_ _1402_ _1376_ _1375_ _1385_ VGND VGND VPWR VPWR _1406_ sky130_fd_sc_hd__and4b_1
X_2826_ _1456_ VGND VGND VPWR VPWR _0083_ sky130_fd_sc_hd__inv_2
X_1639_ _0459_ VGND VGND VPWR VPWR _0289_ sky130_fd_sc_hd__clkbuf_1
XFILLER_0_39_90 VPWR VGND VPWR VGND sky130_ef_sc_hd__decap_12
XTAP_TAPCELL_ROW_44_509 VGND VPWR sky130_fd_sc_hd__tapvpwrvgnd_1
XTAP_TAPCELL_ROW_1_164 VGND VPWR sky130_fd_sc_hd__tapvpwrvgnd_1
XFILLER_0_64_433 VPWR VGND VPWR VGND sky130_ef_sc_hd__decap_12
XTAP_TAPCELL_ROW_52_575 VGND VPWR sky130_fd_sc_hd__tapvpwrvgnd_1
XFILLER_0_36_146 VPWR VGND VPWR VGND sky130_ef_sc_hd__decap_12
XFILLER_0_32_363 VGND VGND VPWR VPWR sky130_fd_sc_hd__fill_1
XTAP_TAPCELL_ROW_9_231 VGND VPWR sky130_fd_sc_hd__tapvpwrvgnd_1
XFILLER_0_10_29 VPWR VGND VPWR VGND sky130_ef_sc_hd__decap_12
XFILLER_0_19_27 VPWR VGND VPWR VGND sky130_ef_sc_hd__decap_12
XFILLER_0_35_15 VPWR VGND VPWR VGND sky130_ef_sc_hd__decap_12
XFILLER_0_27_124 VGND VGND VPWR VPWR sky130_fd_sc_hd__decap_8
X_1990_ reg_file.registers\[10\]\[21\] _0604_ _0609_ reg_file.registers\[11\]\[21\]
+ VGND VGND VPWR VPWR _0806_ sky130_fd_sc_hd__a22o_1
XTAP_TAPCELL_ROW_15_277 VGND VPWR sky130_fd_sc_hd__tapvpwrvgnd_1
Xclkload12 clknet_leaf_9_clk VGND VGND VPWR VPWR clkload12/Y sky130_fd_sc_hd__clkinvlp_2
X_2611_ imem.address\[16\] _1328_ imem.address\[17\] VGND VGND VPWR VPWR _1349_ sky130_fd_sc_hd__a21oi_1
X_2542_ _1307_ VGND VGND VPWR VPWR _0234_ sky130_fd_sc_hd__clkbuf_1
XFILLER_0_15_308 VGND VGND VPWR VPWR sky130_fd_sc_hd__decap_6
X_2473_ _0688_ _0692_ VGND VGND VPWR VPWR _1262_ sky130_fd_sc_hd__nand2_1
XFILLER_0_25_81 VGND VGND VPWR VPWR sky130_fd_sc_hd__decap_6
X_3025_ clknet_leaf_19_clk _0248_ _0084_ VGND VGND VPWR VPWR reg_file.registers\[15\]\[27\]
+ sky130_fd_sc_hd__dfrtp_1
Xclkload6 clknet_leaf_5_clk VGND VGND VPWR VPWR clkload6/Y sky130_fd_sc_hd__clkinvlp_4
X_2809_ _1455_ VGND VGND VPWR VPWR _0067_ sky130_fd_sc_hd__inv_2
XTAP_TAPCELL_ROW_6_201 VGND VPWR sky130_fd_sc_hd__tapvpwrvgnd_1
XTAP_TAPCELL_ROW_57_612 VGND VPWR sky130_fd_sc_hd__tapvpwrvgnd_1
XFILLER_0_49_293 VPWR VGND VPWR VGND sky130_ef_sc_hd__decap_12
XFILLER_0_49_271 VGND VGND VPWR VPWR sky130_fd_sc_hd__decap_3
XFILLER_0_24_116 VPWR VGND VPWR VGND sky130_ef_sc_hd__decap_12
XFILLER_0_24_105 VGND VGND VPWR VPWR sky130_fd_sc_hd__decap_3
XFILLER_0_21_39 VPWR VGND VPWR VGND sky130_ef_sc_hd__decap_12
XFILLER_0_1_27 VPWR VGND VPWR VGND sky130_ef_sc_hd__decap_12
XTAP_TAPCELL_ROW_63_659 VGND VPWR sky130_fd_sc_hd__tapvpwrvgnd_1
XFILLER_0_43_436 VPWR VGND VPWR VGND sky130_ef_sc_hd__decap_12
XTAP_TAPCELL_ROW_28_380 VGND VPWR sky130_fd_sc_hd__tapvpwrvgnd_1
X_1973_ _0574_ _0788_ _0779_ VGND VGND VPWR VPWR _0789_ sky130_fd_sc_hd__o21ai_2
XFILLER_0_7_305 VPWR VGND VPWR VGND sky130_ef_sc_hd__decap_12
XFILLER_0_70_277 VPWR VGND VPWR VGND sky130_ef_sc_hd__decap_12
XFILLER_0_70_233 VPWR VGND VPWR VGND sky130_ef_sc_hd__decap_12
X_2525_ _1298_ VGND VGND VPWR VPWR _0242_ sky130_fd_sc_hd__clkbuf_1
XFILLER_0_23_160 VGND VGND VPWR VPWR sky130_fd_sc_hd__decap_8
X_2456_ _0701_ _0702_ VGND VGND VPWR VPWR _1248_ sky130_fd_sc_hd__and2_1
XFILLER_0_39_3 VPWR VGND VPWR VGND sky130_ef_sc_hd__decap_12
X_2387_ reg_file.registers\[11\]\[16\] _1187_ _1158_ VGND VGND VPWR VPWR _1188_ sky130_fd_sc_hd__mux2_1
X_3008_ clknet_leaf_2_clk _0231_ _0067_ VGND VGND VPWR VPWR reg_file.registers\[15\]\[10\]
+ sky130_fd_sc_hd__dfrtp_1
XFILLER_0_19_433 VPWR VGND VPWR VGND sky130_ef_sc_hd__decap_12
XFILLER_0_61_277 VGND VGND VPWR VPWR sky130_fd_sc_hd__decap_3
XFILLER_0_34_436 VPWR VGND VPWR VGND sky130_ef_sc_hd__decap_12
XFILLER_0_14_193 VGND VGND VPWR VPWR sky130_fd_sc_hd__decap_3
XFILLER_0_32_27 VGND VGND VPWR VPWR sky130_fd_sc_hd__fill_1
XFILLER_0_20_141 VPWR VGND VPWR VGND sky130_ef_sc_hd__decap_12
X_2310_ _0898_ _1023_ _1118_ VGND VGND VPWR VPWR _1119_ sky130_fd_sc_hd__a21o_1
XPHY_EDGE_ROW_29_Left_101 VGND VGND VPWR VPWR sky130_fd_sc_hd__decap_3
X_2172_ _0785_ _0806_ _0872_ VGND VGND VPWR VPWR _0986_ sky130_fd_sc_hd__mux2_1
X_2241_ _0834_ _1051_ _1049_ VGND VGND VPWR VPWR _1053_ sky130_fd_sc_hd__a21o_1
XPHY_EDGE_ROW_38_Left_110 VGND VGND VPWR VPWR sky130_fd_sc_hd__decap_3
X_1887_ _0701_ _0702_ VGND VGND VPWR VPWR _0703_ sky130_fd_sc_hd__nand2_1
XFILLER_0_7_113 VPWR VGND VPWR VGND sky130_ef_sc_hd__decap_12
X_1956_ _0577_ VGND VGND VPWR VPWR _0772_ sky130_fd_sc_hd__inv_2
XFILLER_0_3_385 VGND VGND VPWR VPWR sky130_fd_sc_hd__decap_6
X_2508_ _1289_ VGND VGND VPWR VPWR _0250_ sky130_fd_sc_hd__clkbuf_1
X_2439_ reg_file.registers\[11\]\[11\] _1233_ _1234_ VGND VGND VPWR VPWR _1235_ sky130_fd_sc_hd__mux2_1
XTAP_TAPCELL_ROW_39_464 VGND VPWR sky130_fd_sc_hd__tapvpwrvgnd_1
XFILLER_0_34_200 VGND VGND VPWR VPWR sky130_fd_sc_hd__decap_3
XTAP_TAPCELL_ROW_22_331 VGND VPWR sky130_fd_sc_hd__tapvpwrvgnd_1
XFILLER_0_19_241 VGND VGND VPWR VPWR sky130_fd_sc_hd__decap_3
XFILLER_0_34_244 VGND VGND VPWR VPWR sky130_fd_sc_hd__decap_3
XFILLER_0_22_439 VPWR VGND VPWR VGND sky130_ef_sc_hd__decap_12
XFILLER_0_27_27 VPWR VGND VPWR VGND sky130_ef_sc_hd__decap_12
XFILLER_0_43_15 VPWR VGND VPWR VGND sky130_ef_sc_hd__decap_12
XFILLER_0_65_391 VGND VGND VPWR VPWR sky130_fd_sc_hd__fill_1
XFILLER_0_57_369 VPWR VGND VPWR VGND sky130_ef_sc_hd__decap_12
X_2790_ _1453_ VGND VGND VPWR VPWR _0050_ sky130_fd_sc_hd__inv_2
X_1810_ net19 _0551_ _0625_ _0546_ VGND VGND VPWR VPWR _0626_ sky130_fd_sc_hd__a31o_1
X_1741_ _0478_ _0555_ _0556_ VGND VGND VPWR VPWR _0557_ sky130_fd_sc_hd__a21oi_1
XFILLER_0_25_200 VGND VGND VPWR VPWR sky130_fd_sc_hd__fill_1
X_1672_ _0478_ _0487_ VGND VGND VPWR VPWR _0488_ sky130_fd_sc_hd__and2_2
XFILLER_0_40_269 VGND VGND VPWR VPWR sky130_fd_sc_hd__fill_1
XFILLER_0_7_15 VPWR VGND VPWR VGND sky130_ef_sc_hd__decap_12
XFILLER_0_0_377 VPWR VGND VPWR VGND sky130_ef_sc_hd__decap_12
XFILLER_0_0_333 VGND VGND VPWR VPWR sky130_fd_sc_hd__decap_3
X_2155_ _0969_ VGND VGND VPWR VPWR _0970_ sky130_fd_sc_hd__inv_2
X_2224_ _0909_ _1036_ VGND VGND VPWR VPWR _1037_ sky130_fd_sc_hd__nand2_1
XTAP_TAPCELL_ROW_36_445 VGND VPWR sky130_fd_sc_hd__tapvpwrvgnd_1
X_2086_ _0901_ VGND VGND VPWR VPWR _0902_ sky130_fd_sc_hd__clkbuf_4
XFILLER_0_71_361 VGND VGND VPWR VPWR sky130_fd_sc_hd__decap_3
X_2988_ clknet_leaf_4_clk _0218_ _0054_ VGND VGND VPWR VPWR imem.address\[29\] sky130_fd_sc_hd__dfrtp_1
XFILLER_0_31_225 VGND VGND VPWR VPWR sky130_fd_sc_hd__decap_4
X_1939_ reg_file.registers\[10\]\[19\] _0641_ _0642_ reg_file.registers\[11\]\[19\]
+ VGND VGND VPWR VPWR _0755_ sky130_fd_sc_hd__a22o_1
XFILLER_0_3_193 VPWR VGND VPWR VGND sky130_ef_sc_hd__decap_12
XFILLER_0_66_100 VGND VGND VPWR VPWR sky130_fd_sc_hd__decap_4
XTAP_TAPCELL_ROW_70_713 VGND VPWR sky130_fd_sc_hd__tapvpwrvgnd_1
XPHY_EDGE_ROW_11_Right_11 VGND VGND VPWR VPWR sky130_fd_sc_hd__decap_3
XFILLER_0_38_15 VPWR VGND VPWR VGND sky130_ef_sc_hd__decap_12
XPHY_EDGE_ROW_20_Right_20 VGND VGND VPWR VPWR sky130_fd_sc_hd__decap_3
X_2911_ _1469_ VGND VGND VPWR VPWR _0155_ sky130_fd_sc_hd__inv_2
XFILLER_0_45_317 VPWR VGND VPWR VGND sky130_ef_sc_hd__decap_12
X_2773_ _1451_ VGND VGND VPWR VPWR _0035_ sky130_fd_sc_hd__inv_2
X_2842_ _1460_ VGND VGND VPWR VPWR _0095_ sky130_fd_sc_hd__inv_2
XFILLER_0_60_309 VPWR VGND VPWR VGND sky130_ef_sc_hd__decap_12
X_1724_ reg_file.registers\[15\]\[10\] _0485_ _0486_ reg_file.registers\[5\]\[10\]
+ _0529_ VGND VGND VPWR VPWR _0540_ sky130_fd_sc_hd__a221o_1
XTAP_TAPCELL_ROW_41_481 VGND VPWR sky130_fd_sc_hd__tapvpwrvgnd_1
XFILLER_0_5_447 VGND VGND VPWR VPWR sky130_fd_sc_hd__fill_1
X_1655_ _0470_ VGND VGND VPWR VPWR _0471_ sky130_fd_sc_hd__clkbuf_4
XFILLER_0_0_141 VPWR VGND VPWR VGND sky130_ef_sc_hd__decap_12
X_1586_ reg_file.registers\[10\]\[29\] _0429_ VGND VGND VPWR VPWR _0432_ sky130_fd_sc_hd__and2_1
XFILLER_0_48_111 VPWR VGND VPWR VGND sky130_ef_sc_hd__decap_12
XFILLER_0_28_70 VGND VGND VPWR VPWR sky130_fd_sc_hd__fill_1
X_2138_ _0836_ _0833_ _0871_ VGND VGND VPWR VPWR _0953_ sky130_fd_sc_hd__mux2_1
X_2069_ reg_file.registers\[11\]\[21\] _0867_ _0868_ reg_file.registers\[10\]\[21\]
+ VGND VGND VPWR VPWR _0885_ sky130_fd_sc_hd__a22o_1
X_2207_ _0831_ _0832_ _0843_ VGND VGND VPWR VPWR _1020_ sky130_fd_sc_hd__and3b_1
XFILLER_0_21_3 VPWR VGND VPWR VGND sky130_ef_sc_hd__decap_12
XFILLER_0_44_350 VGND VGND VPWR VPWR sky130_fd_sc_hd__fill_1
XFILLER_0_29_391 VGND VGND VPWR VPWR sky130_fd_sc_hd__fill_1
XTAP_TAPCELL_ROW_47_529 VGND VPWR sky130_fd_sc_hd__tapvpwrvgnd_1
XTAP_TAPCELL_ROW_4_184 VGND VPWR sky130_fd_sc_hd__tapvpwrvgnd_1
XTAP_TAPCELL_ROW_55_595 VGND VPWR sky130_fd_sc_hd__tapvpwrvgnd_1
XFILLER_0_42_309 VPWR VGND VPWR VGND sky130_ef_sc_hd__decap_12
XFILLER_0_40_27 VGND VGND VPWR VPWR sky130_fd_sc_hd__fill_1
X_3110_ clknet_leaf_21_clk _0333_ _0169_ VGND VGND VPWR VPWR reg_file.registers\[5\]\[16\]
+ sky130_fd_sc_hd__dfrtp_1
XFILLER_0_4_27 VGND VGND VPWR VPWR sky130_fd_sc_hd__fill_1
X_3041_ clknet_leaf_9_clk _0264_ _0100_ VGND VGND VPWR VPWR reg_file.registers\[11\]\[11\]
+ sky130_fd_sc_hd__dfrtp_1
XFILLER_0_45_136 VPWR VGND VPWR VGND sky130_ef_sc_hd__decap_12
X_2825_ _1456_ VGND VGND VPWR VPWR _0082_ sky130_fd_sc_hd__inv_2
XFILLER_0_14_83 VGND VGND VPWR VPWR sky130_fd_sc_hd__fill_1
XTAP_TAPCELL_ROW_18_297 VGND VPWR sky130_fd_sc_hd__tapvpwrvgnd_1
XFILLER_0_69_3 VPWR VGND VPWR VGND sky130_ef_sc_hd__decap_12
X_1638_ reg_file.registers\[10\]\[4\] _0449_ VGND VGND VPWR VPWR _0459_ sky130_fd_sc_hd__and2_1
X_1707_ reg_file.registers\[10\]\[4\] _0381_ _0386_ _0491_ VGND VGND VPWR VPWR _0523_
+ sky130_fd_sc_hd__and4_1
XFILLER_0_53_180 VGND VGND VPWR VPWR sky130_fd_sc_hd__decap_4
X_2756_ _1444_ _1445_ VGND VGND VPWR VPWR _0016_ sky130_fd_sc_hd__nor2_1
X_2687_ net43 _1402_ _1404_ VGND VGND VPWR VPWR _1405_ sky130_fd_sc_hd__o21bai_1
X_1569_ _0422_ VGND VGND VPWR VPWR _0322_ sky130_fd_sc_hd__clkbuf_1
XFILLER_0_49_420 VPWR VGND VPWR VGND sky130_ef_sc_hd__decap_12
XTAP_TAPCELL_ROW_1_165 VGND VPWR sky130_fd_sc_hd__tapvpwrvgnd_1
XFILLER_0_64_445 VGND VGND VPWR VPWR sky130_fd_sc_hd__decap_6
XFILLER_0_36_158 VPWR VGND VPWR VGND sky130_ef_sc_hd__decap_12
XFILLER_0_19_39 VPWR VGND VPWR VGND sky130_ef_sc_hd__decap_12
XFILLER_0_35_27 VPWR VGND VPWR VGND sky130_ef_sc_hd__decap_12
XFILLER_0_67_261 VGND VGND VPWR VPWR sky130_fd_sc_hd__decap_6
XFILLER_0_51_15 VPWR VGND VPWR VGND sky130_ef_sc_hd__decap_12
XFILLER_0_27_169 VGND VGND VPWR VPWR sky130_fd_sc_hd__decap_3
XTAP_TAPCELL_ROW_15_278 VGND VPWR sky130_fd_sc_hd__tapvpwrvgnd_1
X_2472_ _1261_ VGND VGND VPWR VPWR _0258_ sky130_fd_sc_hd__clkbuf_1
X_2610_ _1330_ _1348_ VGND VGND VPWR VPWR _0207_ sky130_fd_sc_hd__nor2_1
Xclkload13 clknet_leaf_10_clk VGND VGND VPWR VPWR clkload13/Y sky130_fd_sc_hd__clkinvlp_2
X_2541_ reg_file.registers\[15\]\[13\] _1304_ VGND VGND VPWR VPWR _1307_ sky130_fd_sc_hd__and2_1
XFILLER_0_35_180 VPWR VGND VPWR VGND sky130_ef_sc_hd__decap_12
X_3024_ clknet_leaf_20_clk _0247_ _0083_ VGND VGND VPWR VPWR reg_file.registers\[15\]\[26\]
+ sky130_fd_sc_hd__dfrtp_1
Xclkload7 clknet_leaf_6_clk VGND VGND VPWR VPWR clkload7/Y sky130_fd_sc_hd__bufinv_16
X_2808_ _1450_ VGND VGND VPWR VPWR _1455_ sky130_fd_sc_hd__buf_4
XFILLER_0_18_125 VPWR VGND VPWR VGND sky130_ef_sc_hd__decap_12
XTAP_TAPCELL_ROW_6_202 VGND VPWR sky130_fd_sc_hd__tapvpwrvgnd_1
X_2739_ _1434_ _1435_ VGND VGND VPWR VPWR _0009_ sky130_fd_sc_hd__nor2_1
XTAP_TAPCELL_ROW_57_613 VGND VPWR sky130_fd_sc_hd__tapvpwrvgnd_1
XFILLER_0_5_81 VPWR VGND VPWR VGND sky130_ef_sc_hd__decap_12
XFILLER_0_52_437 VPWR VGND VPWR VGND sky130_ef_sc_hd__decap_12
XFILLER_0_32_161 VPWR VGND VPWR VGND sky130_ef_sc_hd__decap_12
XFILLER_0_24_128 VPWR VGND VPWR VGND sky130_ef_sc_hd__decap_12
XFILLER_0_9_380 VGND VGND VPWR VPWR sky130_fd_sc_hd__decap_6
XFILLER_0_9_391 VGND VGND VPWR VPWR sky130_fd_sc_hd__fill_1
XTAP_TAPCELL_ROW_12_248 VGND VPWR sky130_fd_sc_hd__tapvpwrvgnd_1
XFILLER_0_46_15 VPWR VGND VPWR VGND sky130_ef_sc_hd__decap_12
XTAP_TAPCELL_ROW_28_381 VGND VPWR sky130_fd_sc_hd__tapvpwrvgnd_1
XFILLER_0_1_39 VPWR VGND VPWR VGND sky130_ef_sc_hd__decap_12
XFILLER_0_70_245 VGND VGND VPWR VPWR sky130_fd_sc_hd__decap_6
X_1972_ _0565_ _0783_ VGND VGND VPWR VPWR _0788_ sky130_fd_sc_hd__nor2_1
XFILLER_0_7_317 VPWR VGND VPWR VGND sky130_ef_sc_hd__decap_12
XFILLER_0_11_51 VGND VGND VPWR VPWR sky130_fd_sc_hd__decap_4
XFILLER_0_70_289 VPWR VGND VPWR VGND sky130_ef_sc_hd__decap_12
X_2455_ _1247_ VGND VGND VPWR VPWR _0261_ sky130_fd_sc_hd__clkbuf_1
XPHY_EDGE_ROW_49_Right_49 VGND VGND VPWR VPWR sky130_fd_sc_hd__decap_3
X_2524_ reg_file.registers\[15\]\[21\] _1293_ VGND VGND VPWR VPWR _1298_ sky130_fd_sc_hd__and2_1
XPHY_EDGE_ROW_58_Right_58 VGND VGND VPWR VPWR sky130_fd_sc_hd__decap_3
X_2386_ _0470_ _0752_ _1183_ _1186_ VGND VGND VPWR VPWR _1187_ sky130_fd_sc_hd__a31o_1
XFILLER_0_36_70 VGND VGND VPWR VPWR sky130_fd_sc_hd__fill_2
XFILLER_0_52_80 VGND VGND VPWR VPWR sky130_fd_sc_hd__decap_4
X_3007_ clknet_leaf_3_clk _0230_ _0066_ VGND VGND VPWR VPWR reg_file.registers\[15\]\[9\]
+ sky130_fd_sc_hd__dfrtp_1
XFILLER_0_38_209 VPWR VGND VPWR VGND sky130_ef_sc_hd__decap_12
XFILLER_0_19_445 VGND VGND VPWR VPWR sky130_fd_sc_hd__decap_3
XPHY_EDGE_ROW_67_Right_67 VGND VGND VPWR VPWR sky130_fd_sc_hd__decap_3
XFILLER_0_46_253 VPWR VGND VPWR VGND sky130_ef_sc_hd__decap_12
XFILLER_0_34_448 VGND VGND VPWR VPWR sky130_fd_sc_hd__decap_3
XFILLER_0_16_29 VPWR VGND VPWR VGND sky130_ef_sc_hd__decap_12
XFILLER_0_4_309 VPWR VGND VPWR VGND sky130_ef_sc_hd__decap_12
XFILLER_0_12_109 VPWR VGND VPWR VGND sky130_ef_sc_hd__decap_12
XFILLER_0_20_153 VGND VGND VPWR VPWR sky130_fd_sc_hd__decap_3
X_2171_ _0850_ _0619_ _0849_ VGND VGND VPWR VPWR _0985_ sky130_fd_sc_hd__or3_1
X_2240_ _0834_ _1049_ _1051_ VGND VGND VPWR VPWR _1052_ sky130_fd_sc_hd__nand3_1
XFILLER_0_20_197 VGND VGND VPWR VPWR sky130_fd_sc_hd__fill_1
XFILLER_0_28_242 VGND VGND VPWR VPWR sky130_fd_sc_hd__fill_1
X_1886_ reg_file.registers\[10\]\[7\] _0604_ _0609_ reg_file.registers\[11\]\[7\]
+ VGND VGND VPWR VPWR _0702_ sky130_fd_sc_hd__a22o_1
XFILLER_0_43_234 VGND VGND VPWR VPWR sky130_fd_sc_hd__decap_6
XFILLER_0_43_223 VGND VGND VPWR VPWR sky130_fd_sc_hd__fill_1
XFILLER_0_28_297 VGND VGND VPWR VPWR sky130_fd_sc_hd__decap_4
XFILLER_0_28_253 VGND VGND VPWR VPWR sky130_fd_sc_hd__decap_3
X_1955_ _0770_ VGND VGND VPWR VPWR _0771_ sky130_fd_sc_hd__inv_2
XFILLER_0_7_125 VPWR VGND VPWR VGND sky130_ef_sc_hd__decap_12
XFILLER_0_7_169 VPWR VGND VPWR VGND sky130_ef_sc_hd__decap_12
XFILLER_0_22_83 VGND VGND VPWR VPWR sky130_fd_sc_hd__fill_1
X_2438_ _0932_ VGND VGND VPWR VPWR _1234_ sky130_fd_sc_hd__clkbuf_4
XFILLER_0_51_3 VPWR VGND VPWR VGND sky130_ef_sc_hd__decap_12
X_2507_ reg_file.registers\[15\]\[29\] _1286_ VGND VGND VPWR VPWR _1289_ sky130_fd_sc_hd__and2_1
XTAP_TAPCELL_ROW_39_465 VGND VPWR sky130_fd_sc_hd__tapvpwrvgnd_1
X_2369_ _1172_ VGND VGND VPWR VPWR _0272_ sky130_fd_sc_hd__clkbuf_1
XFILLER_0_34_223 VGND VGND VPWR VPWR sky130_fd_sc_hd__fill_2
XTAP_TAPCELL_ROW_22_332 VGND VPWR sky130_fd_sc_hd__tapvpwrvgnd_1
XFILLER_0_27_39 VPWR VGND VPWR VGND sky130_ef_sc_hd__decap_12
XFILLER_0_57_337 VGND VGND VPWR VPWR sky130_fd_sc_hd__decap_4
XFILLER_0_43_27 VGND VGND VPWR VPWR sky130_fd_sc_hd__decap_4
X_1740_ _0514_ VGND VGND VPWR VPWR _0556_ sky130_fd_sc_hd__buf_2
X_1671_ reg_file.registers\[15\]\[9\] _0485_ _0486_ reg_file.registers\[5\]\[9\] VGND
+ VGND VPWR VPWR _0487_ sky130_fd_sc_hd__a22o_1
XFILLER_0_25_223 VGND VGND VPWR VPWR sky130_fd_sc_hd__fill_1
XFILLER_0_7_27 VPWR VGND VPWR VGND sky130_ef_sc_hd__decap_12
XFILLER_0_4_139 VGND VGND VPWR VPWR sky130_fd_sc_hd__fill_1
XFILLER_0_0_389 VGND VGND VPWR VPWR sky130_fd_sc_hd__decap_3
X_2154_ _0966_ _0968_ _0901_ VGND VGND VPWR VPWR _0969_ sky130_fd_sc_hd__mux2_1
X_2223_ net35 _1034_ _1035_ VGND VGND VPWR VPWR _1036_ sky130_fd_sc_hd__o21ai_1
X_2085_ _0512_ VGND VGND VPWR VPWR _0901_ sky130_fd_sc_hd__clkbuf_4
XFILLER_0_63_307 VGND VGND VPWR VPWR sky130_fd_sc_hd__fill_1
X_2987_ clknet_leaf_4_clk _0217_ _0053_ VGND VGND VPWR VPWR imem.address\[28\] sky130_fd_sc_hd__dfrtp_1
XFILLER_0_48_348 VGND VGND VPWR VPWR sky130_fd_sc_hd__fill_1
XTAP_TAPCELL_ROW_36_446 VGND VPWR sky130_fd_sc_hd__tapvpwrvgnd_1
X_1869_ _0684_ _0489_ VGND VGND VPWR VPWR _0685_ sky130_fd_sc_hd__nor2_2
X_1938_ net27 _0753_ VGND VGND VPWR VPWR _0754_ sky130_fd_sc_hd__nand2_2
XFILLER_0_3_161 VGND VGND VPWR VPWR sky130_fd_sc_hd__decap_6
XTAP_TAPCELL_ROW_70_714 VGND VPWR sky130_fd_sc_hd__tapvpwrvgnd_1
XFILLER_0_39_359 VPWR VGND VPWR VGND sky130_ef_sc_hd__decap_12
XPHY_EDGE_ROW_57_Left_129 VGND VGND VPWR VPWR sky130_fd_sc_hd__decap_3
XFILLER_0_47_370 VGND VGND VPWR VPWR sky130_fd_sc_hd__decap_6
XFILLER_0_38_49 VGND VGND VPWR VPWR sky130_fd_sc_hd__fill_1
XFILLER_0_38_27 VGND VGND VPWR VPWR sky130_fd_sc_hd__fill_1
XFILLER_0_22_237 VPWR VGND VPWR VGND sky130_ef_sc_hd__decap_12
XPHY_EDGE_ROW_66_Left_138 VGND VGND VPWR VPWR sky130_fd_sc_hd__decap_3
XFILLER_0_54_15 VPWR VGND VPWR VGND sky130_ef_sc_hd__decap_12
X_2841_ _1460_ VGND VGND VPWR VPWR _0094_ sky130_fd_sc_hd__inv_2
XFILLER_0_45_329 VGND VGND VPWR VPWR sky130_fd_sc_hd__decap_6
X_2910_ _1469_ VGND VGND VPWR VPWR _0154_ sky130_fd_sc_hd__inv_2
XFILLER_0_38_381 VPWR VGND VPWR VGND sky130_ef_sc_hd__decap_12
XTAP_TAPCELL_ROW_33_416 VGND VPWR sky130_fd_sc_hd__tapvpwrvgnd_1
X_2772_ _1451_ VGND VGND VPWR VPWR _0034_ sky130_fd_sc_hd__inv_2
X_1654_ _0469_ VGND VGND VPWR VPWR _0470_ sky130_fd_sc_hd__buf_2
X_1723_ _0478_ _0538_ VGND VGND VPWR VPWR _0539_ sky130_fd_sc_hd__and2_1
XTAP_TAPCELL_ROW_41_482 VGND VPWR sky130_fd_sc_hd__tapvpwrvgnd_1
XFILLER_0_0_153 VPWR VGND VPWR VGND sky130_ef_sc_hd__decap_12
XFILLER_0_0_197 VPWR VGND VPWR VGND sky130_ef_sc_hd__decap_12
X_2206_ _0815_ _0822_ _0816_ VGND VGND VPWR VPWR _1019_ sky130_fd_sc_hd__o21ai_1
X_1585_ _0431_ VGND VGND VPWR VPWR _0315_ sky130_fd_sc_hd__clkbuf_1
XFILLER_0_48_123 VGND VGND VPWR VPWR sky130_fd_sc_hd__decap_8
X_2137_ _0891_ _0951_ _0894_ VGND VGND VPWR VPWR _0952_ sky130_fd_sc_hd__o21a_1
X_2068_ reg_file.registers\[11\]\[20\] _0867_ _0868_ reg_file.registers\[10\]\[20\]
+ VGND VGND VPWR VPWR _0884_ sky130_fd_sc_hd__a22o_1
XFILLER_0_14_3 VPWR VGND VPWR VGND sky130_ef_sc_hd__decap_12
XFILLER_0_60_80 VGND VGND VPWR VPWR sky130_fd_sc_hd__decap_4
XFILLER_0_48_178 VGND VGND VPWR VPWR sky130_fd_sc_hd__decap_4
XFILLER_0_36_307 VGND VGND VPWR VPWR sky130_fd_sc_hd__fill_1
XFILLER_0_8_253 VPWR VGND VPWR VGND sky130_ef_sc_hd__decap_12
XFILLER_0_71_181 VPWR VGND VPWR VGND sky130_ef_sc_hd__decap_12
XTAP_TAPCELL_ROW_4_185 VGND VPWR sky130_fd_sc_hd__tapvpwrvgnd_1
XTAP_TAPCELL_ROW_55_596 VGND VPWR sky130_fd_sc_hd__tapvpwrvgnd_1
XFILLER_0_39_156 VGND VGND VPWR VPWR sky130_fd_sc_hd__fill_1
XFILLER_0_24_29 VPWR VGND VPWR VGND sky130_ef_sc_hd__decap_12
XFILLER_0_54_148 VGND VGND VPWR VPWR sky130_fd_sc_hd__fill_1
XFILLER_0_50_365 VPWR VGND VPWR VGND sky130_ef_sc_hd__decap_12
XFILLER_0_50_321 VGND VGND VPWR VPWR sky130_fd_sc_hd__decap_4
XFILLER_0_49_15 VPWR VGND VPWR VGND sky130_ef_sc_hd__decap_12
X_3040_ clknet_leaf_10_clk _0263_ _0099_ VGND VGND VPWR VPWR reg_file.registers\[11\]\[10\]
+ sky130_fd_sc_hd__dfrtp_1
XFILLER_0_58_421 VPWR VGND VPWR VGND sky130_ef_sc_hd__decap_12
XFILLER_0_45_148 VGND VGND VPWR VPWR sky130_fd_sc_hd__decap_8
XFILLER_0_5_223 VGND VGND VPWR VPWR sky130_fd_sc_hd__fill_1
XTAP_TAPCELL_ROW_18_298 VGND VPWR sky130_fd_sc_hd__tapvpwrvgnd_1
X_2824_ _1456_ VGND VGND VPWR VPWR _0081_ sky130_fd_sc_hd__inv_2
X_1637_ _0458_ VGND VGND VPWR VPWR _0290_ sky130_fd_sc_hd__clkbuf_1
X_1706_ _0384_ _0464_ _0479_ _0465_ VGND VGND VPWR VPWR _0522_ sky130_fd_sc_hd__and4_1
X_2755_ display.counter\[18\] _1442_ VGND VGND VPWR VPWR _1445_ sky130_fd_sc_hd__nor2_1
X_2686_ _1382_ _1383_ _1393_ _1403_ VGND VGND VPWR VPWR _1404_ sky130_fd_sc_hd__and4_1
X_1499_ _0375_ _0373_ VGND VGND VPWR VPWR _0379_ sky130_fd_sc_hd__nor2_1
X_1568_ reg_file.registers\[5\]\[5\] _0414_ VGND VGND VPWR VPWR _0422_ sky130_fd_sc_hd__and2_1
XFILLER_0_49_443 VGND VGND VPWR VPWR sky130_fd_sc_hd__decap_4
XFILLER_0_36_115 VGND VGND VPWR VPWR sky130_fd_sc_hd__fill_1
XTAP_TAPCELL_ROW_1_166 VGND VPWR sky130_fd_sc_hd__tapvpwrvgnd_1
XFILLER_0_36_137 VGND VGND VPWR VPWR sky130_fd_sc_hd__decap_3
XFILLER_0_32_365 VPWR VGND VPWR VGND sky130_ef_sc_hd__decap_12
XFILLER_0_17_362 VPWR VGND VPWR VGND sky130_ef_sc_hd__decap_12
XFILLER_0_3_3 VPWR VGND VPWR VGND sky130_ef_sc_hd__decap_12
XTAP_TAPCELL_ROW_43_500 VGND VPWR sky130_fd_sc_hd__tapvpwrvgnd_1
XFILLER_0_35_39 VGND VGND VPWR VPWR sky130_fd_sc_hd__decap_4
XFILLER_0_55_435 VPWR VGND VPWR VGND sky130_ef_sc_hd__decap_12
XFILLER_0_51_27 VGND VGND VPWR VPWR sky130_fd_sc_hd__decap_6
XFILLER_0_42_118 VGND VGND VPWR VPWR sky130_fd_sc_hd__fill_2
XTAP_TAPCELL_ROW_15_279 VGND VPWR sky130_fd_sc_hd__tapvpwrvgnd_1
X_2471_ reg_file.registers\[11\]\[5\] _1260_ _1234_ VGND VGND VPWR VPWR _1261_ sky130_fd_sc_hd__mux2_1
XFILLER_0_50_195 VGND VGND VPWR VPWR sky130_fd_sc_hd__fill_1
XFILLER_0_50_184 VGND VGND VPWR VPWR sky130_fd_sc_hd__fill_1
Xclkload14 clknet_leaf_11_clk VGND VGND VPWR VPWR clkload14/Y sky130_fd_sc_hd__clkinv_4
X_2540_ _1306_ VGND VGND VPWR VPWR _0235_ sky130_fd_sc_hd__clkbuf_1
XFILLER_0_35_192 VPWR VGND VPWR VGND sky130_ef_sc_hd__decap_12
X_3023_ clknet_leaf_0_clk _0246_ _0082_ VGND VGND VPWR VPWR reg_file.registers\[15\]\[25\]
+ sky130_fd_sc_hd__dfrtp_1
XFILLER_0_58_251 VGND VGND VPWR VPWR sky130_fd_sc_hd__fill_1
XFILLER_0_46_424 VPWR VGND VPWR VGND sky130_ef_sc_hd__decap_12
XFILLER_0_61_449 VGND VGND VPWR VPWR sky130_fd_sc_hd__fill_2
XFILLER_0_61_405 VPWR VGND VPWR VGND sky130_ef_sc_hd__decap_12
Xclkload8 clknet_leaf_7_clk VGND VGND VPWR VPWR clkload8/Y sky130_fd_sc_hd__clkinv_8
X_2807_ _1454_ VGND VGND VPWR VPWR _0066_ sky130_fd_sc_hd__inv_2
XFILLER_0_41_140 VGND VGND VPWR VPWR sky130_fd_sc_hd__fill_1
XFILLER_0_41_60 VGND VGND VPWR VPWR sky130_fd_sc_hd__fill_1
XFILLER_0_33_107 VGND VGND VPWR VPWR sky130_fd_sc_hd__decap_4
XFILLER_0_26_181 VGND VGND VPWR VPWR sky130_fd_sc_hd__decap_4
X_2738_ display.counter\[10\] _1432_ display.counter\[11\] VGND VGND VPWR VPWR _1435_
+ sky130_fd_sc_hd__a21oi_1
XFILLER_0_18_137 VGND VGND VPWR VPWR sky130_fd_sc_hd__decap_3
X_2669_ _0470_ _1258_ _1259_ _1140_ _1214_ VGND VGND VPWR VPWR _1387_ sky130_fd_sc_hd__a32o_1
XFILLER_0_1_281 VPWR VGND VPWR VGND sky130_ef_sc_hd__decap_12
XTAP_TAPCELL_ROW_6_203 VGND VPWR sky130_fd_sc_hd__tapvpwrvgnd_1
XTAP_TAPCELL_ROW_57_614 VGND VPWR sky130_fd_sc_hd__tapvpwrvgnd_1
XFILLER_0_5_93 VPWR VGND VPWR VGND sky130_ef_sc_hd__decap_12
XFILLER_0_64_243 VGND VGND VPWR VPWR sky130_fd_sc_hd__decap_6
XFILLER_0_64_210 VGND VGND VPWR VPWR sky130_fd_sc_hd__decap_4
XFILLER_0_37_413 VGND VGND VPWR VPWR sky130_fd_sc_hd__decap_8
XTAP_TAPCELL_ROW_12_249 VGND VPWR sky130_fd_sc_hd__tapvpwrvgnd_1
XFILLER_0_52_449 VGND VGND VPWR VPWR sky130_fd_sc_hd__fill_2
XFILLER_0_32_173 VGND VGND VPWR VPWR sky130_fd_sc_hd__decap_3
XFILLER_0_46_27 VGND VGND VPWR VPWR sky130_fd_sc_hd__fill_1
XFILLER_0_62_48 VPWR VGND VPWR VGND sky130_ef_sc_hd__decap_12
XFILLER_0_62_15 VPWR VGND VPWR VGND sky130_ef_sc_hd__decap_12
XTAP_TAPCELL_ROW_28_382 VGND VPWR sky130_fd_sc_hd__tapvpwrvgnd_1
XFILLER_0_55_232 VGND VGND VPWR VPWR sky130_fd_sc_hd__decap_8
XFILLER_0_43_449 VGND VGND VPWR VPWR sky130_fd_sc_hd__fill_2
X_1971_ _0786_ VGND VGND VPWR VPWR _0787_ sky130_fd_sc_hd__inv_2
XFILLER_0_23_140 VPWR VGND VPWR VGND sky130_ef_sc_hd__decap_12
XFILLER_0_7_329 VGND VGND VPWR VPWR sky130_fd_sc_hd__decap_6
X_2454_ reg_file.registers\[11\]\[8\] _1246_ _1234_ VGND VGND VPWR VPWR _1247_ sky130_fd_sc_hd__mux2_1
X_2385_ _1028_ _1120_ _1121_ _1139_ _1185_ VGND VGND VPWR VPWR _1186_ sky130_fd_sc_hd__a221o_1
XFILLER_0_23_184 VGND VGND VPWR VPWR sky130_fd_sc_hd__fill_1
X_2523_ _1297_ VGND VGND VPWR VPWR _0243_ sky130_fd_sc_hd__clkbuf_1
Xinput1 control VGND VGND VPWR VPWR net1 sky130_fd_sc_hd__buf_1
X_3006_ clknet_leaf_3_clk _0229_ _0065_ VGND VGND VPWR VPWR reg_file.registers\[15\]\[8\]
+ sky130_fd_sc_hd__dfrtp_1
XTAP_TAPCELL_ROW_62_650 VGND VPWR sky130_fd_sc_hd__tapvpwrvgnd_1
XFILLER_0_46_265 VGND VGND VPWR VPWR sky130_fd_sc_hd__decap_8
XFILLER_0_19_413 VGND VGND VPWR VPWR sky130_fd_sc_hd__fill_1
XFILLER_0_69_335 VGND VGND VPWR VPWR sky130_fd_sc_hd__fill_1
XFILLER_0_32_29 VPWR VGND VPWR VGND sky130_ef_sc_hd__decap_12
XFILLER_0_52_235 VGND VGND VPWR VPWR sky130_fd_sc_hd__decap_8
XFILLER_0_25_449 VGND VGND VPWR VPWR sky130_fd_sc_hd__fill_2
XFILLER_0_25_405 VPWR VGND VPWR VGND sky130_ef_sc_hd__decap_12
XTAP_TAPCELL_ROW_25_352 VGND VPWR sky130_fd_sc_hd__tapvpwrvgnd_1
XFILLER_0_57_15 VGND VGND VPWR VPWR sky130_fd_sc_hd__decap_3
XFILLER_0_40_419 VGND VGND VPWR VPWR sky130_fd_sc_hd__fill_1
XPHY_EDGE_ROW_27_Left_99 VGND VGND VPWR VPWR sky130_fd_sc_hd__decap_3
X_2170_ _0984_ VGND VGND VPWR VPWR _0283_ sky130_fd_sc_hd__clkbuf_1
X_1954_ _0756_ _0762_ _0769_ VGND VGND VPWR VPWR _0770_ sky130_fd_sc_hd__nor3_1
XFILLER_0_7_137 VPWR VGND VPWR VGND sky130_ef_sc_hd__decap_12
X_1885_ _0699_ _0700_ _0652_ VGND VGND VPWR VPWR _0701_ sky130_fd_sc_hd__mux2_1
XFILLER_0_43_279 VGND VGND VPWR VPWR sky130_fd_sc_hd__fill_1
XFILLER_0_16_438 VGND VGND VPWR VPWR sky130_fd_sc_hd__decap_8
XFILLER_0_22_95 VGND VGND VPWR VPWR sky130_fd_sc_hd__decap_6
X_2437_ _0471_ _1228_ _1229_ _0940_ _1232_ VGND VGND VPWR VPWR _1233_ sky130_fd_sc_hd__a32o_1
XFILLER_0_44_3 VPWR VGND VPWR VGND sky130_ef_sc_hd__decap_12
X_2506_ _1288_ VGND VGND VPWR VPWR _0251_ sky130_fd_sc_hd__clkbuf_1
X_2368_ reg_file.registers\[11\]\[19\] _1171_ _1158_ VGND VGND VPWR VPWR _1172_ sky130_fd_sc_hd__mux2_1
XFILLER_0_63_91 VGND VGND VPWR VPWR sky130_fd_sc_hd__fill_1
XTAP_TAPCELL_ROW_39_466 VGND VPWR sky130_fd_sc_hd__tapvpwrvgnd_1
X_2299_ _1107_ _1108_ _0866_ VGND VGND VPWR VPWR _1109_ sky130_fd_sc_hd__mux2_1
XFILLER_0_2_83 VGND VGND VPWR VPWR sky130_fd_sc_hd__fill_1
XTAP_TAPCELL_ROW_22_333 VGND VPWR sky130_fd_sc_hd__tapvpwrvgnd_1
XFILLER_0_19_221 VGND VGND VPWR VPWR sky130_fd_sc_hd__decap_3
XFILLER_0_57_305 VGND VGND VPWR VPWR sky130_fd_sc_hd__decap_8
XFILLER_0_65_393 VPWR VGND VPWR VGND sky130_ef_sc_hd__decap_12
X_1670_ _0475_ VGND VGND VPWR VPWR _0486_ sky130_fd_sc_hd__buf_2
XFILLER_0_7_39 VPWR VGND VPWR VGND sky130_ef_sc_hd__decap_12
X_2222_ _0666_ _0967_ _0665_ VGND VGND VPWR VPWR _1035_ sky130_fd_sc_hd__a21o_1
X_2153_ _0871_ _0967_ VGND VGND VPWR VPWR _0968_ sky130_fd_sc_hd__nand2_1
XFILLER_0_48_327 VGND VGND VPWR VPWR sky130_fd_sc_hd__decap_6
XTAP_TAPCELL_ROW_36_447 VGND VPWR sky130_fd_sc_hd__tapvpwrvgnd_1
X_2084_ _0836_ _0838_ _0879_ VGND VGND VPWR VPWR _0900_ sky130_fd_sc_hd__mux2_1
XFILLER_0_17_51 VGND VGND VPWR VPWR sky130_fd_sc_hd__decap_4
XFILLER_0_56_393 VGND VGND VPWR VPWR sky130_fd_sc_hd__fill_1
X_2986_ clknet_leaf_4_clk _0216_ _0052_ VGND VGND VPWR VPWR imem.address\[27\] sky130_fd_sc_hd__dfrtp_1
X_1937_ _0559_ _0562_ _0564_ _0556_ VGND VGND VPWR VPWR _0753_ sky130_fd_sc_hd__o22ai_1
X_1868_ imem.address\[3\] _0473_ VGND VGND VPWR VPWR _0684_ sky130_fd_sc_hd__nand2_1
XFILLER_0_31_238 VPWR VGND VPWR VGND sky130_ef_sc_hd__decap_12
X_1799_ reg_file.registers\[10\]\[29\] _0605_ _0610_ reg_file.registers\[11\]\[29\]
+ VGND VGND VPWR VPWR _0615_ sky130_fd_sc_hd__a22o_1
XTAP_TAPCELL_ROW_70_715 VGND VPWR sky130_fd_sc_hd__tapvpwrvgnd_1
XFILLER_0_62_363 VGND VGND VPWR VPWR sky130_fd_sc_hd__fill_1
XFILLER_0_62_341 VGND VGND VPWR VPWR sky130_fd_sc_hd__fill_2
XFILLER_0_47_393 VGND VGND VPWR VPWR sky130_fd_sc_hd__decap_8
XFILLER_0_22_249 VGND VGND VPWR VPWR sky130_fd_sc_hd__decap_3
XFILLER_0_38_39 VGND VGND VPWR VPWR sky130_fd_sc_hd__fill_1
XFILLER_0_54_27 VGND VGND VPWR VPWR sky130_fd_sc_hd__fill_1
X_2771_ _1451_ VGND VGND VPWR VPWR _0033_ sky130_fd_sc_hd__inv_2
XFILLER_0_70_15 VPWR VGND VPWR VGND sky130_ef_sc_hd__decap_12
X_2840_ _1460_ VGND VGND VPWR VPWR _0093_ sky130_fd_sc_hd__inv_2
XFILLER_0_57_135 VPWR VGND VPWR VGND sky130_ef_sc_hd__decap_12
XFILLER_0_57_113 VGND VGND VPWR VPWR sky130_fd_sc_hd__decap_4
XTAP_TAPCELL_ROW_41_483 VGND VPWR sky130_fd_sc_hd__tapvpwrvgnd_1
XFILLER_0_38_393 VGND VGND VPWR VPWR sky130_fd_sc_hd__decap_6
XTAP_TAPCELL_ROW_33_417 VGND VPWR sky130_fd_sc_hd__tapvpwrvgnd_1
XFILLER_0_5_405 VPWR VGND VPWR VGND sky130_ef_sc_hd__decap_12
X_1653_ net41 _0468_ VGND VGND VPWR VPWR _0469_ sky130_fd_sc_hd__nor2_1
X_1722_ reg_file.registers\[15\]\[11\] _0485_ _0537_ reg_file.registers\[5\]\[11\]
+ VGND VGND VPWR VPWR _0538_ sky130_fd_sc_hd__a22o_1
XFILLER_0_5_449 VGND VGND VPWR VPWR sky130_fd_sc_hd__fill_2
XPHY_EDGE_ROW_9_Right_9 VGND VGND VPWR VPWR sky130_fd_sc_hd__decap_3
XFILLER_0_13_205 VPWR VGND VPWR VGND sky130_ef_sc_hd__decap_12
X_1584_ reg_file.registers\[10\]\[30\] _0429_ VGND VGND VPWR VPWR _0431_ sky130_fd_sc_hd__and2_1
XTAP_TAPCELL_ROW_49_550 VGND VPWR sky130_fd_sc_hd__tapvpwrvgnd_1
XFILLER_0_0_165 VGND VGND VPWR VPWR sky130_fd_sc_hd__decap_3
X_2205_ reg_file.registers\[10\]\[27\] _0775_ _0776_ reg_file.registers\[11\]\[27\]
+ VGND VGND VPWR VPWR _1018_ sky130_fd_sc_hd__a22o_1
XFILLER_0_48_135 VGND VGND VPWR VPWR sky130_fd_sc_hd__decap_4
XFILLER_0_44_71 VGND VGND VPWR VPWR sky130_fd_sc_hd__decap_4
X_2067_ _0873_ _0880_ _0882_ VGND VGND VPWR VPWR _0883_ sky130_fd_sc_hd__mux2_1
X_2136_ _0618_ _0827_ _0889_ VGND VGND VPWR VPWR _0951_ sky130_fd_sc_hd__mux2_1
XFILLER_0_8_221 VPWR VGND VPWR VGND sky130_ef_sc_hd__decap_12
XPHY_EDGE_ROW_14_Left_86 VGND VGND VPWR VPWR sky130_fd_sc_hd__decap_3
XFILLER_0_71_193 VGND VGND VPWR VPWR sky130_fd_sc_hd__decap_3
X_2969_ clknet_leaf_5_clk _0199_ _0035_ VGND VGND VPWR VPWR imem.address\[10\] sky130_fd_sc_hd__dfrtp_1
XFILLER_0_44_363 VGND VGND VPWR VPWR sky130_fd_sc_hd__fill_1
XFILLER_0_29_371 VPWR VGND VPWR VGND sky130_ef_sc_hd__decap_12
XFILLER_0_8_265 VPWR VGND VPWR VGND sky130_ef_sc_hd__decap_12
XFILLER_0_12_260 VGND VGND VPWR VPWR sky130_fd_sc_hd__decap_6
XTAP_TAPCELL_ROW_4_186 VGND VPWR sky130_fd_sc_hd__tapvpwrvgnd_1
XTAP_TAPCELL_ROW_55_597 VGND VPWR sky130_fd_sc_hd__tapvpwrvgnd_1
XFILLER_0_54_105 VGND VGND VPWR VPWR sky130_fd_sc_hd__fill_1
XFILLER_0_39_102 VGND VGND VPWR VPWR sky130_fd_sc_hd__fill_1
XFILLER_0_40_29 VGND VGND VPWR VPWR sky130_fd_sc_hd__decap_8
XFILLER_0_50_377 VGND VGND VPWR VPWR sky130_fd_sc_hd__fill_1
XFILLER_0_49_27 VPWR VGND VPWR VGND sky130_ef_sc_hd__decap_12
XFILLER_0_2_419 VGND VGND VPWR VPWR sky130_fd_sc_hd__fill_1
XFILLER_0_65_15 VPWR VGND VPWR VGND sky130_ef_sc_hd__decap_12
XFILLER_0_4_29 VPWR VGND VPWR VGND sky130_ef_sc_hd__decap_12
XFILLER_0_58_433 VPWR VGND VPWR VGND sky130_ef_sc_hd__decap_12
XFILLER_0_58_411 VGND VGND VPWR VPWR sky130_fd_sc_hd__decap_8
XTAP_TAPCELL_ROW_46_520 VGND VPWR sky130_fd_sc_hd__tapvpwrvgnd_1
XFILLER_0_14_41 VPWR VGND VPWR VGND sky130_ef_sc_hd__decap_12
XTAP_TAPCELL_ROW_18_299 VGND VPWR sky130_fd_sc_hd__tapvpwrvgnd_1
X_1705_ reg_file.registers\[15\]\[4\] _0484_ VGND VGND VPWR VPWR _0521_ sky130_fd_sc_hd__and2_1
XFILLER_0_41_322 VGND VGND VPWR VPWR sky130_fd_sc_hd__decap_4
XFILLER_0_41_311 VGND VGND VPWR VPWR sky130_fd_sc_hd__fill_2
XFILLER_0_38_190 VGND VGND VPWR VPWR sky130_fd_sc_hd__decap_6
X_2754_ display.counter\[18\] _1442_ VGND VGND VPWR VPWR _1444_ sky130_fd_sc_hd__and2_1
XFILLER_0_26_352 VPWR VGND VPWR VGND sky130_ef_sc_hd__decap_12
XFILLER_0_5_279 VGND VGND VPWR VPWR sky130_fd_sc_hd__fill_1
XFILLER_0_14_85 VGND VGND VPWR VPWR sky130_fd_sc_hd__decap_6
X_2823_ _1456_ VGND VGND VPWR VPWR _0080_ sky130_fd_sc_hd__inv_2
X_1636_ reg_file.registers\[10\]\[5\] _0449_ VGND VGND VPWR VPWR _0458_ sky130_fd_sc_hd__and2_1
X_1567_ _0421_ VGND VGND VPWR VPWR _0323_ sky130_fd_sc_hd__clkbuf_1
X_2685_ _1401_ VGND VGND VPWR VPWR _1403_ sky130_fd_sc_hd__inv_2
XFILLER_0_1_441 VGND VGND VPWR VPWR sky130_fd_sc_hd__decap_4
X_1498_ _0377_ VGND VGND VPWR VPWR _0378_ sky130_fd_sc_hd__buf_2
XTAP_TAPCELL_ROW_1_167 VGND VPWR sky130_fd_sc_hd__tapvpwrvgnd_1
X_2119_ _0934_ VGND VGND VPWR VPWR _0284_ sky130_fd_sc_hd__clkbuf_1
X_3099_ clknet_leaf_4_clk _0322_ _0158_ VGND VGND VPWR VPWR reg_file.registers\[5\]\[5\]
+ sky130_fd_sc_hd__dfrtp_1
XFILLER_0_51_119 VGND VGND VPWR VPWR sky130_fd_sc_hd__decap_3
XFILLER_0_32_377 VPWR VGND VPWR VGND sky130_ef_sc_hd__decap_12
XFILLER_0_17_341 VGND VGND VPWR VPWR sky130_fd_sc_hd__decap_8
XFILLER_0_17_374 VPWR VGND VPWR VGND sky130_ef_sc_hd__decap_12
XFILLER_0_17_396 VGND VGND VPWR VPWR sky130_fd_sc_hd__decap_4
XTAP_TAPCELL_ROW_43_501 VGND VPWR sky130_fd_sc_hd__tapvpwrvgnd_1
XFILLER_0_67_296 VPWR VGND VPWR VGND sky130_ef_sc_hd__decap_12
XFILLER_0_67_274 VGND VGND VPWR VPWR sky130_fd_sc_hd__decap_6
XFILLER_0_55_447 VGND VGND VPWR VPWR sky130_fd_sc_hd__fill_1
XFILLER_0_55_414 VPWR VGND VPWR VGND sky130_ef_sc_hd__decap_12
Xclkload15 clknet_leaf_12_clk VGND VGND VPWR VPWR clkload15/Y sky130_fd_sc_hd__clkinv_1
XFILLER_0_23_333 VGND VGND VPWR VPWR sky130_fd_sc_hd__decap_3
X_2470_ _0472_ _1258_ _1259_ _1012_ _1042_ VGND VGND VPWR VPWR _1260_ sky130_fd_sc_hd__a32o_1
X_3022_ clknet_leaf_18_clk _0245_ _0081_ VGND VGND VPWR VPWR reg_file.registers\[15\]\[24\]
+ sky130_fd_sc_hd__dfrtp_1
XFILLER_0_46_436 VPWR VGND VPWR VGND sky130_ef_sc_hd__decap_12
XFILLER_0_25_51 VGND VGND VPWR VPWR sky130_fd_sc_hd__decap_4
XFILLER_0_61_417 VPWR VGND VPWR VGND sky130_ef_sc_hd__decap_12
X_2806_ _1454_ VGND VGND VPWR VPWR _0065_ sky130_fd_sc_hd__inv_2
X_2668_ _0364_ VGND VGND VPWR VPWR _1386_ sky130_fd_sc_hd__inv_2
XFILLER_0_26_193 VGND VGND VPWR VPWR sky130_fd_sc_hd__decap_3
X_2737_ display.counter\[10\] display.counter\[11\] _1432_ VGND VGND VPWR VPWR _1434_
+ sky130_fd_sc_hd__and3_1
XFILLER_0_14_344 VGND VGND VPWR VPWR sky130_fd_sc_hd__decap_6
Xclkload9 clknet_leaf_18_clk VGND VGND VPWR VPWR clkload9/Y sky130_fd_sc_hd__clkinv_8
X_1619_ _0428_ VGND VGND VPWR VPWR _0449_ sky130_fd_sc_hd__clkbuf_2
X_2599_ imem.address\[24\] _1333_ VGND VGND VPWR VPWR _1344_ sky130_fd_sc_hd__nor2_1
XFILLER_0_1_293 VPWR VGND VPWR VGND sky130_ef_sc_hd__decap_12
XTAP_TAPCELL_ROW_6_204 VGND VPWR sky130_fd_sc_hd__tapvpwrvgnd_1
XTAP_TAPCELL_ROW_57_615 VGND VPWR sky130_fd_sc_hd__tapvpwrvgnd_1
XFILLER_0_64_299 VGND VGND VPWR VPWR sky130_fd_sc_hd__decap_4
XFILLER_0_52_406 VPWR VGND VPWR VGND sky130_ef_sc_hd__decap_12
XFILLER_0_9_393 VGND VGND VPWR VPWR sky130_fd_sc_hd__fill_2
XFILLER_0_32_130 VGND VGND VPWR VPWR sky130_fd_sc_hd__fill_1
XFILLER_0_20_303 VGND VGND VPWR VPWR sky130_fd_sc_hd__decap_4
XFILLER_0_62_27 VGND VGND VPWR VPWR sky130_fd_sc_hd__fill_1
XTAP_TAPCELL_ROW_28_383 VGND VPWR sky130_fd_sc_hd__tapvpwrvgnd_1
XFILLER_0_28_403 VGND VGND VPWR VPWR sky130_fd_sc_hd__fill_1
X_1970_ _0784_ _0785_ VGND VGND VPWR VPWR _0786_ sky130_fd_sc_hd__xnor2_2
XFILLER_0_55_266 VPWR VGND VPWR VGND sky130_ef_sc_hd__decap_12
XFILLER_0_23_152 VGND VGND VPWR VPWR sky130_fd_sc_hd__decap_4
X_2522_ reg_file.registers\[15\]\[22\] _1293_ VGND VGND VPWR VPWR _1297_ sky130_fd_sc_hd__and2_1
X_2453_ _0469_ _1225_ _1245_ _1122_ _0940_ VGND VGND VPWR VPWR _1246_ sky130_fd_sc_hd__a32o_1
X_2384_ _1184_ _1116_ VGND VGND VPWR VPWR _1185_ sky130_fd_sc_hd__nor2_1
X_3005_ clknet_leaf_3_clk _0228_ _0064_ VGND VGND VPWR VPWR reg_file.registers\[15\]\[7\]
+ sky130_fd_sc_hd__dfrtp_1
XFILLER_0_36_94 VGND VGND VPWR VPWR sky130_fd_sc_hd__fill_1
XTAP_TAPCELL_ROW_62_651 VGND VPWR sky130_fd_sc_hd__tapvpwrvgnd_1
XFILLER_0_61_269 VGND VGND VPWR VPWR sky130_fd_sc_hd__decap_8
XFILLER_0_6_363 VGND VGND VPWR VPWR sky130_fd_sc_hd__fill_1
XFILLER_0_14_141 VGND VGND VPWR VPWR sky130_fd_sc_hd__fill_2
XFILLER_0_37_222 VGND VGND VPWR VPWR sky130_fd_sc_hd__fill_2
XTAP_TAPCELL_ROW_25_353 VGND VPWR sky130_fd_sc_hd__tapvpwrvgnd_1
XFILLER_0_37_288 VGND VGND VPWR VPWR sky130_fd_sc_hd__decap_8
XFILLER_0_25_417 VGND VGND VPWR VPWR sky130_fd_sc_hd__decap_6
XPHY_EDGE_ROW_2_Left_74 VGND VGND VPWR VPWR sky130_fd_sc_hd__decap_3
XFILLER_0_57_38 VGND VGND VPWR VPWR sky130_fd_sc_hd__decap_6
XFILLER_0_20_100 VGND VGND VPWR VPWR sky130_fd_sc_hd__fill_1
X_1884_ _0533_ VGND VGND VPWR VPWR _0700_ sky130_fd_sc_hd__inv_2
X_1953_ _0766_ _0768_ VGND VGND VPWR VPWR _0769_ sky130_fd_sc_hd__or2b_1
XFILLER_0_7_105 VGND VGND VPWR VPWR sky130_fd_sc_hd__decap_6
XFILLER_0_7_149 VPWR VGND VPWR VGND sky130_ef_sc_hd__decap_12
XFILLER_0_22_41 VPWR VGND VPWR VGND sky130_ef_sc_hd__decap_12
X_2505_ reg_file.registers\[15\]\[30\] _1286_ VGND VGND VPWR VPWR _1288_ sky130_fd_sc_hd__and2_1
XFILLER_0_11_111 VGND VGND VPWR VPWR sky130_fd_sc_hd__fill_1
X_2436_ _1230_ _1231_ _0910_ VGND VGND VPWR VPWR _1232_ sky130_fd_sc_hd__mux2_1
X_2298_ _1004_ _1011_ _0897_ VGND VGND VPWR VPWR _1108_ sky130_fd_sc_hd__mux2_1
XFILLER_0_37_3 VPWR VGND VPWR VGND sky130_ef_sc_hd__decap_12
X_2367_ _1141_ _1087_ _1168_ _1169_ _1170_ VGND VGND VPWR VPWR _1171_ sky130_fd_sc_hd__a221o_1
XTAP_TAPCELL_ROW_39_467 VGND VPWR sky130_fd_sc_hd__tapvpwrvgnd_1
XFILLER_0_19_233 VGND VGND VPWR VPWR sky130_fd_sc_hd__fill_1
XFILLER_0_34_258 VPWR VGND VPWR VGND sky130_ef_sc_hd__decap_12
XTAP_TAPCELL_ROW_22_334 VGND VPWR sky130_fd_sc_hd__tapvpwrvgnd_1
XFILLER_0_19_266 VGND VGND VPWR VPWR sky130_fd_sc_hd__fill_1
XFILLER_0_69_133 VGND VGND VPWR VPWR sky130_fd_sc_hd__decap_3
XFILLER_0_69_155 VGND VGND VPWR VPWR sky130_fd_sc_hd__fill_1
XFILLER_0_65_361 VPWR VGND VPWR VGND sky130_ef_sc_hd__decap_12
XFILLER_0_25_225 VGND VGND VPWR VPWR sky130_fd_sc_hd__decap_3
XFILLER_0_68_15 VPWR VGND VPWR VGND sky130_ef_sc_hd__decap_12
X_2152_ reg_file.registers\[10\]\[0\] _0604_ _0609_ reg_file.registers\[11\]\[0\]
+ VGND VGND VPWR VPWR _0967_ sky130_fd_sc_hd__a22o_1
X_2221_ _0961_ _0965_ _0901_ VGND VGND VPWR VPWR _1034_ sky130_fd_sc_hd__mux2_1
X_2083_ _0827_ _0833_ _0889_ VGND VGND VPWR VPWR _0899_ sky130_fd_sc_hd__mux2_1
X_2985_ clknet_leaf_4_clk _0215_ _0051_ VGND VGND VPWR VPWR imem.address\[26\] sky130_fd_sc_hd__dfrtp_1
X_1867_ _0537_ _0556_ VGND VGND VPWR VPWR _0683_ sky130_fd_sc_hd__or2_2
X_1936_ _0745_ _0730_ _0751_ VGND VGND VPWR VPWR _0752_ sky130_fd_sc_hd__o21ai_4
XFILLER_0_33_95 VPWR VGND VPWR VGND sky130_ef_sc_hd__decap_12
XFILLER_0_33_62 VPWR VGND VPWR VGND sky130_ef_sc_hd__decap_12
X_1798_ _0595_ _0613_ VGND VGND VPWR VPWR _0614_ sky130_fd_sc_hd__nand2_1
X_2419_ _1215_ _1216_ _0893_ VGND VGND VPWR VPWR _1217_ sky130_fd_sc_hd__mux2_1
XTAP_TAPCELL_ROW_70_716 VGND VPWR sky130_fd_sc_hd__tapvpwrvgnd_1
XFILLER_0_66_169 VGND VGND VPWR VPWR sky130_fd_sc_hd__decap_3
XFILLER_0_66_158 VGND VGND VPWR VPWR sky130_fd_sc_hd__fill_1
XFILLER_0_38_29 VGND VGND VPWR VPWR sky130_fd_sc_hd__decap_6
XFILLER_0_30_261 VGND VGND VPWR VPWR sky130_fd_sc_hd__fill_2
XFILLER_0_30_250 VGND VGND VPWR VPWR sky130_fd_sc_hd__fill_2
XTAP_TAPCELL_ROW_33_418 VGND VPWR sky130_fd_sc_hd__tapvpwrvgnd_1
X_2770_ _1451_ VGND VGND VPWR VPWR _0032_ sky130_fd_sc_hd__inv_2
XFILLER_0_70_27 VGND VGND VPWR VPWR sky130_fd_sc_hd__fill_1
XFILLER_0_57_169 VPWR VGND VPWR VGND sky130_ef_sc_hd__decap_12
X_1721_ _0486_ VGND VGND VPWR VPWR _0537_ sky130_fd_sc_hd__clkbuf_4
XTAP_TAPCELL_ROW_41_484 VGND VPWR sky130_fd_sc_hd__tapvpwrvgnd_1
XFILLER_0_5_417 VPWR VGND VPWR VGND sky130_ef_sc_hd__decap_12
X_1652_ _0467_ VGND VGND VPWR VPWR _0468_ sky130_fd_sc_hd__buf_4
XFILLER_0_13_217 VGND VGND VPWR VPWR sky130_fd_sc_hd__fill_2
X_1583_ _0430_ VGND VGND VPWR VPWR _0316_ sky130_fd_sc_hd__clkbuf_1
XFILLER_0_21_250 VGND VGND VPWR VPWR sky130_fd_sc_hd__fill_2
XFILLER_0_21_272 VGND VGND VPWR VPWR sky130_fd_sc_hd__decap_3
XTAP_TAPCELL_ROW_49_551 VGND VPWR sky130_fd_sc_hd__tapvpwrvgnd_1
X_2135_ _0889_ _0615_ _0949_ VGND VGND VPWR VPWR _0950_ sky130_fd_sc_hd__a21o_1
X_2204_ _0824_ _0841_ _0846_ _0848_ VGND VGND VPWR VPWR _1017_ sky130_fd_sc_hd__o211ai_1
XFILLER_0_44_94 VGND VGND VPWR VPWR sky130_fd_sc_hd__fill_2
X_2066_ _0881_ VGND VGND VPWR VPWR _0882_ sky130_fd_sc_hd__clkbuf_4
XFILLER_0_29_383 VGND VGND VPWR VPWR sky130_fd_sc_hd__decap_8
XFILLER_0_8_233 VPWR VGND VPWR VGND sky130_ef_sc_hd__decap_12
X_2968_ clknet_leaf_6_clk _0198_ _0034_ VGND VGND VPWR VPWR imem.address\[9\] sky130_fd_sc_hd__dfrtp_1
XFILLER_0_63_139 VGND VGND VPWR VPWR sky130_fd_sc_hd__fill_2
X_1919_ _0716_ _0734_ VGND VGND VPWR VPWR _0735_ sky130_fd_sc_hd__or2b_1
XFILLER_0_8_83 VGND VGND VPWR VPWR sky130_fd_sc_hd__fill_1
XFILLER_0_8_277 VPWR VGND VPWR VGND sky130_ef_sc_hd__decap_12
X_2899_ _1466_ VGND VGND VPWR VPWR _0146_ sky130_fd_sc_hd__inv_2
XTAP_TAPCELL_ROW_4_187 VGND VPWR sky130_fd_sc_hd__tapvpwrvgnd_1
XTAP_TAPCELL_ROW_55_598 VGND VPWR sky130_fd_sc_hd__tapvpwrvgnd_1
XFILLER_0_54_139 VGND VGND VPWR VPWR sky130_fd_sc_hd__fill_1
XFILLER_0_39_169 VGND VGND VPWR VPWR sky130_fd_sc_hd__decap_4
XFILLER_0_50_389 VGND VGND VPWR VPWR sky130_fd_sc_hd__fill_2
XFILLER_0_10_209 VPWR VGND VPWR VGND sky130_ef_sc_hd__decap_12
XFILLER_0_65_27 VPWR VGND VPWR VGND sky130_ef_sc_hd__decap_12
XFILLER_0_58_445 VGND VGND VPWR VPWR sky130_fd_sc_hd__decap_6
XTAP_TAPCELL_ROW_46_521 VGND VPWR sky130_fd_sc_hd__tapvpwrvgnd_1
XFILLER_0_14_53 VPWR VGND VPWR VGND sky130_ef_sc_hd__decap_12
X_1704_ reg_file.registers\[15\]\[5\] _0484_ _0467_ reg_file.registers\[5\]\[5\] _0519_
+ VGND VGND VPWR VPWR _0520_ sky130_fd_sc_hd__a221o_1
XFILLER_0_30_85 VGND VGND VPWR VPWR sky130_fd_sc_hd__decap_4
XFILLER_0_30_41 VGND VGND VPWR VPWR sky130_fd_sc_hd__decap_4
X_2753_ _1442_ _1443_ VGND VGND VPWR VPWR _0015_ sky130_fd_sc_hd__nor2_1
XFILLER_0_26_331 VGND VGND VPWR VPWR sky130_fd_sc_hd__decap_4
X_2684_ _1393_ _1401_ VGND VGND VPWR VPWR _1402_ sky130_fd_sc_hd__nand2_1
XFILLER_0_5_225 VPWR VGND VPWR VGND sky130_ef_sc_hd__decap_12
X_2822_ _1456_ VGND VGND VPWR VPWR _0079_ sky130_fd_sc_hd__inv_2
X_1635_ _0457_ VGND VGND VPWR VPWR _0291_ sky130_fd_sc_hd__clkbuf_1
X_1497_ _0375_ _0376_ VGND VGND VPWR VPWR _0377_ sky130_fd_sc_hd__nor2_1
X_1566_ reg_file.registers\[5\]\[6\] _0414_ VGND VGND VPWR VPWR _0421_ sky130_fd_sc_hd__and2_1
XFILLER_0_68_209 VPWR VGND VPWR VGND sky130_ef_sc_hd__decap_12
XFILLER_0_55_60 VGND VGND VPWR VPWR sky130_fd_sc_hd__decap_8
X_3098_ clknet_leaf_2_clk _0321_ _0157_ VGND VGND VPWR VPWR reg_file.registers\[5\]\[4\]
+ sky130_fd_sc_hd__dfrtp_1
X_2049_ _0612_ _0855_ _0863_ VGND VGND VPWR VPWR _0865_ sky130_fd_sc_hd__nand3_1
X_2118_ reg_file.registers\[11\]\[31\] _0931_ _0933_ VGND VGND VPWR VPWR _0934_ sky130_fd_sc_hd__mux2_1
XFILLER_0_71_81 VGND VGND VPWR VPWR sky130_fd_sc_hd__decap_3
XTAP_TAPCELL_ROW_52_568 VGND VPWR sky130_fd_sc_hd__tapvpwrvgnd_1
XFILLER_0_44_150 VGND VGND VPWR VPWR sky130_fd_sc_hd__decap_8
XFILLER_0_32_389 VPWR VGND VPWR VGND sky130_ef_sc_hd__decap_12
XTAP_TAPCELL_ROW_9_224 VGND VPWR sky130_fd_sc_hd__tapvpwrvgnd_1
XFILLER_0_17_386 VGND VGND VPWR VPWR sky130_fd_sc_hd__fill_2
XFILLER_0_55_426 VGND VGND VPWR VPWR sky130_fd_sc_hd__decap_6
XTAP_TAPCELL_ROW_43_502 VGND VPWR sky130_fd_sc_hd__tapvpwrvgnd_1
XFILLER_0_50_131 VGND VGND VPWR VPWR sky130_fd_sc_hd__fill_1
Xclkload16 clknet_leaf_13_clk VGND VGND VPWR VPWR clkload16/X sky130_fd_sc_hd__clkbuf_4
XFILLER_0_50_153 VGND VGND VPWR VPWR sky130_fd_sc_hd__decap_3
XFILLER_0_23_367 VGND VGND VPWR VPWR sky130_fd_sc_hd__fill_2
X_3021_ clknet_leaf_20_clk _0244_ _0080_ VGND VGND VPWR VPWR reg_file.registers\[15\]\[23\]
+ sky130_fd_sc_hd__dfrtp_1
XFILLER_0_58_253 VPWR VGND VPWR VGND sky130_ef_sc_hd__decap_12
X_2805_ _1454_ VGND VGND VPWR VPWR _0064_ sky130_fd_sc_hd__inv_2
XTAP_TAPCELL_ROW_14_270 VGND VPWR sky130_fd_sc_hd__tapvpwrvgnd_1
XFILLER_0_67_3 VPWR VGND VPWR VGND sky130_ef_sc_hd__decap_12
XFILLER_0_61_429 VPWR VGND VPWR VGND sky130_ef_sc_hd__decap_12
XFILLER_0_41_131 VGND VGND VPWR VPWR sky130_fd_sc_hd__fill_2
X_1618_ _0448_ VGND VGND VPWR VPWR _0299_ sky130_fd_sc_hd__clkbuf_1
X_2667_ _1384_ VGND VGND VPWR VPWR _1385_ sky130_fd_sc_hd__buf_6
XFILLER_0_1_261 VPWR VGND VPWR VGND sky130_ef_sc_hd__decap_12
X_2736_ display.counter\[10\] _1432_ VGND VGND VPWR VPWR _0008_ sky130_fd_sc_hd__xor2_1
XFILLER_0_14_312 VPWR VGND VPWR VGND sky130_ef_sc_hd__decap_12
X_2598_ imem.address\[25\] _1334_ VGND VGND VPWR VPWR _0214_ sky130_fd_sc_hd__xor2_1
X_1549_ reg_file.registers\[5\]\[14\] _0403_ VGND VGND VPWR VPWR _0412_ sky130_fd_sc_hd__and2_1
XFILLER_0_5_51 VGND VGND VPWR VPWR sky130_fd_sc_hd__decap_4
XTAP_TAPCELL_ROW_6_205 VGND VPWR sky130_fd_sc_hd__tapvpwrvgnd_1
XFILLER_0_52_418 VGND VGND VPWR VPWR sky130_fd_sc_hd__fill_2
XFILLER_0_32_197 VGND VGND VPWR VPWR sky130_fd_sc_hd__fill_2
XFILLER_0_20_359 VGND VGND VPWR VPWR sky130_fd_sc_hd__decap_4
XFILLER_0_46_29 VGND VGND VPWR VPWR sky130_fd_sc_hd__fill_1
XFILLER_0_28_448 VGND VGND VPWR VPWR sky130_fd_sc_hd__decap_3
XFILLER_0_55_278 VGND VGND VPWR VPWR sky130_fd_sc_hd__fill_2
XTAP_TAPCELL_ROW_11_240 VGND VPWR sky130_fd_sc_hd__tapvpwrvgnd_1
X_2521_ _1296_ VGND VGND VPWR VPWR _0244_ sky130_fd_sc_hd__clkbuf_1
X_2452_ _0728_ _0706_ VGND VGND VPWR VPWR _1245_ sky130_fd_sc_hd__nand2_1
X_2383_ _1041_ VGND VGND VPWR VPWR _1184_ sky130_fd_sc_hd__inv_2
XPHY_EDGE_ROW_18_Right_18 VGND VGND VPWR VPWR sky130_fd_sc_hd__decap_3
X_3004_ clknet_leaf_3_clk _0227_ _0063_ VGND VGND VPWR VPWR reg_file.registers\[15\]\[6\]
+ sky130_fd_sc_hd__dfrtp_1
XPHY_EDGE_ROW_27_Right_27 VGND VGND VPWR VPWR sky130_fd_sc_hd__decap_3
XTAP_TAPCELL_ROW_62_652 VGND VPWR sky130_fd_sc_hd__tapvpwrvgnd_1
XFILLER_0_61_237 VGND VGND VPWR VPWR sky130_fd_sc_hd__decap_4
XFILLER_0_61_215 VGND VGND VPWR VPWR sky130_fd_sc_hd__fill_1
XFILLER_0_52_94 VGND VGND VPWR VPWR sky130_fd_sc_hd__decap_4
XFILLER_0_34_407 VPWR VGND VPWR VGND sky130_ef_sc_hd__decap_12
XPHY_EDGE_ROW_36_Right_36 VGND VGND VPWR VPWR sky130_fd_sc_hd__decap_3
X_2719_ display.counter\[3\] _1422_ VGND VGND VPWR VPWR _1424_ sky130_fd_sc_hd__and2_1
XFILLER_0_69_337 VPWR VGND VPWR VGND sky130_ef_sc_hd__decap_12
XPHY_EDGE_ROW_45_Right_45 VGND VGND VPWR VPWR sky130_fd_sc_hd__decap_3
XTAP_TAPCELL_ROW_25_354 VGND VPWR sky130_fd_sc_hd__tapvpwrvgnd_1
XPHY_EDGE_ROW_54_Right_54 VGND VGND VPWR VPWR sky130_fd_sc_hd__decap_3
XFILLER_0_25_429 VGND VGND VPWR VPWR sky130_fd_sc_hd__decap_3
XPHY_EDGE_ROW_63_Right_63 VGND VGND VPWR VPWR sky130_fd_sc_hd__decap_3
X_1883_ _0556_ _0533_ VGND VGND VPWR VPWR _0699_ sky130_fd_sc_hd__or2_1
X_1952_ _0764_ _0767_ VGND VGND VPWR VPWR _0768_ sky130_fd_sc_hd__nand2_1
XFILLER_0_22_53 VPWR VGND VPWR VGND sky130_ef_sc_hd__decap_12
XFILLER_0_51_281 VGND VGND VPWR VPWR sky130_fd_sc_hd__decap_3
X_2435_ _0893_ _1201_ VGND VGND VPWR VPWR _1231_ sky130_fd_sc_hd__and2_1
X_2504_ _1287_ VGND VGND VPWR VPWR _0252_ sky130_fd_sc_hd__clkbuf_1
XFILLER_0_11_167 VGND VGND VPWR VPWR sky130_fd_sc_hd__fill_1
X_2297_ _0665_ _0882_ _1007_ VGND VGND VPWR VPWR _1107_ sky130_fd_sc_hd__and3_1
XFILLER_0_47_94 VGND VGND VPWR VPWR sky130_fd_sc_hd__decap_3
XTAP_TAPCELL_ROW_39_468 VGND VPWR sky130_fd_sc_hd__tapvpwrvgnd_1
X_2366_ _1140_ _1064_ _1139_ _1072_ VGND VGND VPWR VPWR _1170_ sky130_fd_sc_hd__a22o_1
XFILLER_0_2_41 VPWR VGND VPWR VGND sky130_ef_sc_hd__decap_12
XFILLER_0_66_329 VPWR VGND VPWR VGND sky130_ef_sc_hd__decap_12
XFILLER_0_63_60 VGND VGND VPWR VPWR sky130_fd_sc_hd__decap_6
XFILLER_0_2_85 VPWR VGND VPWR VGND sky130_ef_sc_hd__decap_12
XFILLER_0_19_201 VGND VGND VPWR VPWR sky130_fd_sc_hd__decap_4
XFILLER_0_30_421 VPWR VGND VPWR VGND sky130_ef_sc_hd__decap_12
XTAP_TAPCELL_ROW_22_335 VGND VPWR sky130_fd_sc_hd__tapvpwrvgnd_1
XFILLER_0_19_278 VGND VGND VPWR VPWR sky130_fd_sc_hd__fill_2
XFILLER_0_69_167 VGND VGND VPWR VPWR sky130_fd_sc_hd__fill_1
XFILLER_0_65_373 VPWR VGND VPWR VGND sky130_ef_sc_hd__decap_12
XFILLER_0_25_237 VGND VGND VPWR VPWR sky130_fd_sc_hd__decap_4
XFILLER_0_25_204 VGND VGND VPWR VPWR sky130_fd_sc_hd__decap_6
XFILLER_0_4_109 VPWR VGND VPWR VGND sky130_ef_sc_hd__decap_12
XFILLER_0_68_27 VGND VGND VPWR VPWR sky130_fd_sc_hd__fill_1
XFILLER_0_33_281 VPWR VGND VPWR VGND sky130_ef_sc_hd__decap_12
XFILLER_0_0_337 VPWR VGND VPWR VGND sky130_ef_sc_hd__decap_12
X_2151_ _0965_ VGND VGND VPWR VPWR _0966_ sky130_fd_sc_hd__inv_2
X_2220_ _1031_ _1032_ net36 VGND VGND VPWR VPWR _1033_ sky130_fd_sc_hd__mux2_1
X_2082_ _0897_ VGND VGND VPWR VPWR _0898_ sky130_fd_sc_hd__clkbuf_4
X_2984_ clknet_leaf_4_clk _0214_ _0050_ VGND VGND VPWR VPWR imem.address\[25\] sky130_fd_sc_hd__dfrtp_1
XFILLER_0_48_307 VGND VGND VPWR VPWR sky130_fd_sc_hd__fill_1
XFILLER_0_33_85 VGND VGND VPWR VPWR sky130_fd_sc_hd__decap_6
XFILLER_0_33_74 VGND VGND VPWR VPWR sky130_fd_sc_hd__decap_4
XFILLER_0_8_415 VGND VGND VPWR VPWR sky130_fd_sc_hd__fill_1
XFILLER_0_71_365 VPWR VGND VPWR VGND sky130_ef_sc_hd__decap_12
XFILLER_0_71_321 VPWR VGND VPWR VGND sky130_ef_sc_hd__decap_12
X_1866_ _0680_ _0681_ VGND VGND VPWR VPWR _0682_ sky130_fd_sc_hd__xnor2_1
X_1935_ _0749_ _0750_ VGND VGND VPWR VPWR _0751_ sky130_fd_sc_hd__and2_1
XFILLER_0_8_448 VGND VGND VPWR VPWR sky130_fd_sc_hd__decap_3
X_1797_ _0556_ _0594_ _0592_ VGND VGND VPWR VPWR _0613_ sky130_fd_sc_hd__o21ai_1
X_2418_ _1085_ _1059_ _0882_ VGND VGND VPWR VPWR _1216_ sky130_fd_sc_hd__mux2_1
X_2349_ _1005_ _1028_ VGND VGND VPWR VPWR _1155_ sky130_fd_sc_hd__and2_1
XTAP_TAPCELL_ROW_70_717 VGND VPWR sky130_fd_sc_hd__tapvpwrvgnd_1
XFILLER_0_66_115 VPWR VGND VPWR VGND sky130_ef_sc_hd__decap_12
XPHY_EDGE_ROW_0_Right_0 VGND VGND VPWR VPWR sky130_fd_sc_hd__decap_3
XFILLER_0_62_376 VPWR VGND VPWR VGND sky130_ef_sc_hd__decap_12
XFILLER_0_62_365 VGND VGND VPWR VPWR sky130_fd_sc_hd__fill_2
XFILLER_0_22_207 VGND VGND VPWR VPWR sky130_fd_sc_hd__decap_3
XFILLER_0_54_29 VPWR VGND VPWR VGND sky130_ef_sc_hd__decap_12
XPHY_EDGE_ROW_35_Left_107 VGND VGND VPWR VPWR sky130_fd_sc_hd__decap_3
XTAP_TAPCELL_ROW_33_419 VGND VPWR sky130_fd_sc_hd__tapvpwrvgnd_1
X_1651_ _0466_ VGND VGND VPWR VPWR _0467_ sky130_fd_sc_hd__clkbuf_4
X_1720_ _0535_ _0531_ _0533_ _0527_ VGND VGND VPWR VPWR _0536_ sky130_fd_sc_hd__or4_4
XPHY_EDGE_ROW_44_Left_116 VGND VGND VPWR VPWR sky130_fd_sc_hd__decap_3
XTAP_TAPCELL_ROW_41_485 VGND VPWR sky130_fd_sc_hd__tapvpwrvgnd_1
XFILLER_0_38_373 VGND VGND VPWR VPWR sky130_fd_sc_hd__fill_1
XFILLER_0_38_362 VGND VGND VPWR VPWR sky130_fd_sc_hd__fill_2
XFILLER_0_5_429 VPWR VGND VPWR VGND sky130_ef_sc_hd__decap_12
XFILLER_0_28_41 VGND VGND VPWR VPWR sky130_fd_sc_hd__decap_4
X_1582_ reg_file.registers\[10\]\[31\] _0429_ VGND VGND VPWR VPWR _0430_ sky130_fd_sc_hd__and2_1
XPHY_EDGE_ROW_53_Left_125 VGND VGND VPWR VPWR sky130_fd_sc_hd__decap_3
X_2065_ _0501_ _0511_ VGND VGND VPWR VPWR _0881_ sky130_fd_sc_hd__nor2_2
XFILLER_0_44_40 VGND VGND VPWR VPWR sky130_fd_sc_hd__fill_1
XFILLER_0_28_85 VPWR VGND VPWR VGND sky130_ef_sc_hd__decap_12
XFILLER_0_28_74 VGND VGND VPWR VPWR sky130_fd_sc_hd__fill_1
X_2134_ _0872_ _0611_ _0903_ VGND VGND VPWR VPWR _0949_ sky130_fd_sc_hd__a21o_1
X_2203_ _1016_ VGND VGND VPWR VPWR _0282_ sky130_fd_sc_hd__clkbuf_1
X_2967_ clknet_leaf_6_clk _0197_ _0033_ VGND VGND VPWR VPWR imem.address\[8\] sky130_fd_sc_hd__dfrtp_1
XFILLER_0_48_148 VGND VGND VPWR VPWR sky130_fd_sc_hd__decap_4
XFILLER_0_8_245 VGND VGND VPWR VPWR sky130_fd_sc_hd__decap_6
XFILLER_0_69_81 VPWR VGND VPWR VGND sky130_ef_sc_hd__decap_12
X_1918_ reg_file.registers\[10\]\[10\] _0603_ _0608_ reg_file.registers\[11\]\[10\]
+ VGND VGND VPWR VPWR _0734_ sky130_fd_sc_hd__a22o_1
XPHY_EDGE_ROW_62_Left_134 VGND VGND VPWR VPWR sky130_fd_sc_hd__decap_3
XFILLER_0_44_387 VPWR VGND VPWR VGND sky130_ef_sc_hd__decap_12
X_1849_ _0543_ _0498_ _0500_ _0501_ VGND VGND VPWR VPWR _0665_ sky130_fd_sc_hd__o22ai_4
XFILLER_0_8_289 VPWR VGND VPWR VGND sky130_ef_sc_hd__decap_12
XFILLER_0_12_273 VPWR VGND VPWR VGND sky130_ef_sc_hd__decap_12
X_2898_ _1466_ VGND VGND VPWR VPWR _0145_ sky130_fd_sc_hd__inv_2
XPHY_EDGE_ROW_71_Left_143 VGND VGND VPWR VPWR sky130_fd_sc_hd__decap_3
XTAP_TAPCELL_ROW_55_599 VGND VPWR sky130_fd_sc_hd__tapvpwrvgnd_1
XTAP_TAPCELL_ROW_4_188 VGND VPWR sky130_fd_sc_hd__tapvpwrvgnd_1
Xclkbuf_leaf_20_clk clknet_1_0__leaf_clk VGND VGND VPWR VPWR clknet_leaf_20_clk sky130_fd_sc_hd__clkbuf_8
XFILLER_0_62_195 VGND VGND VPWR VPWR sky130_fd_sc_hd__fill_1
XFILLER_0_65_39 VPWR VGND VPWR VGND sky130_ef_sc_hd__decap_12
XTAP_TAPCELL_ROW_46_522 VGND VPWR sky130_fd_sc_hd__tapvpwrvgnd_1
XFILLER_0_26_321 VGND VGND VPWR VPWR sky130_fd_sc_hd__decap_4
X_2821_ _1456_ VGND VGND VPWR VPWR _0078_ sky130_fd_sc_hd__inv_2
XFILLER_0_14_65 VPWR VGND VPWR VGND sky130_ef_sc_hd__decap_12
X_1634_ reg_file.registers\[10\]\[6\] _0449_ VGND VGND VPWR VPWR _0457_ sky130_fd_sc_hd__and2_1
X_1703_ _0517_ _0518_ _0378_ _0481_ VGND VGND VPWR VPWR _0519_ sky130_fd_sc_hd__and4_4
Xclkbuf_leaf_11_clk clknet_1_1__leaf_clk VGND VGND VPWR VPWR clknet_leaf_11_clk sky130_fd_sc_hd__clkbuf_8
XFILLER_0_41_335 VGND VGND VPWR VPWR sky130_fd_sc_hd__fill_1
X_2752_ display.counter\[16\] _1440_ display.counter\[17\] VGND VGND VPWR VPWR _1443_
+ sky130_fd_sc_hd__a21oi_1
XFILLER_0_26_365 VGND VGND VPWR VPWR sky130_fd_sc_hd__decap_6
X_2683_ _1280_ _0358_ _1400_ VGND VGND VPWR VPWR _1401_ sky130_fd_sc_hd__o21a_1
XFILLER_0_5_237 VPWR VGND VPWR VGND sky130_ef_sc_hd__decap_12
X_1496_ imem.address\[5\] imem.address\[4\] VGND VGND VPWR VPWR _0376_ sky130_fd_sc_hd__or2_1
X_1565_ _0420_ VGND VGND VPWR VPWR _0324_ sky130_fd_sc_hd__clkbuf_1
X_3097_ clknet_leaf_2_clk _0320_ _0156_ VGND VGND VPWR VPWR reg_file.registers\[5\]\[3\]
+ sky130_fd_sc_hd__dfrtp_1
X_2117_ _0932_ VGND VGND VPWR VPWR _0933_ sky130_fd_sc_hd__clkbuf_4
X_2048_ _0612_ _0855_ _0863_ VGND VGND VPWR VPWR _0864_ sky130_fd_sc_hd__a21o_1
XFILLER_0_12_3 VPWR VGND VPWR VGND sky130_ef_sc_hd__decap_12
XFILLER_0_64_405 VPWR VGND VPWR VGND sky130_ef_sc_hd__decap_12
XTAP_TAPCELL_ROW_52_569 VGND VPWR sky130_fd_sc_hd__tapvpwrvgnd_1
XFILLER_0_44_173 VGND VGND VPWR VPWR sky130_fd_sc_hd__fill_1
XFILLER_0_36_129 VGND VGND VPWR VPWR sky130_fd_sc_hd__decap_8
XTAP_TAPCELL_ROW_17_290 VGND VPWR sky130_fd_sc_hd__tapvpwrvgnd_1
XFILLER_0_17_354 VGND VGND VPWR VPWR sky130_fd_sc_hd__decap_4
XFILLER_0_44_195 VGND VGND VPWR VPWR sky130_fd_sc_hd__fill_1
XFILLER_0_32_357 VGND VGND VPWR VPWR sky130_fd_sc_hd__decap_6
XTAP_TAPCELL_ROW_9_225 VGND VPWR sky130_fd_sc_hd__tapvpwrvgnd_1
XFILLER_0_55_449 VGND VGND VPWR VPWR sky130_fd_sc_hd__fill_2
XTAP_TAPCELL_ROW_43_503 VGND VPWR sky130_fd_sc_hd__tapvpwrvgnd_1
XFILLER_0_70_419 VGND VGND VPWR VPWR sky130_fd_sc_hd__fill_1
Xclkload17 clknet_leaf_15_clk VGND VGND VPWR VPWR clkload17/Y sky130_fd_sc_hd__clkinv_1
Xclkbuf_leaf_0_clk clknet_1_0__leaf_clk VGND VGND VPWR VPWR clknet_leaf_0_clk sky130_fd_sc_hd__clkbuf_8
X_3020_ clknet_leaf_20_clk _0243_ _0079_ VGND VGND VPWR VPWR reg_file.registers\[15\]\[22\]
+ sky130_fd_sc_hd__dfrtp_1
XFILLER_0_58_265 VPWR VGND VPWR VGND sky130_ef_sc_hd__decap_12
X_2804_ _1454_ VGND VGND VPWR VPWR _0063_ sky130_fd_sc_hd__inv_2
XFILLER_0_41_96 VGND VGND VPWR VPWR sky130_fd_sc_hd__decap_8
XTAP_TAPCELL_ROW_14_271 VGND VPWR sky130_fd_sc_hd__tapvpwrvgnd_1
X_2597_ _1335_ _1343_ VGND VGND VPWR VPWR _0215_ sky130_fd_sc_hd__nor2_1
X_1617_ reg_file.registers\[10\]\[14\] _0438_ VGND VGND VPWR VPWR _0448_ sky130_fd_sc_hd__and2_1
XFILLER_0_1_273 VGND VGND VPWR VPWR sky130_fd_sc_hd__decap_6
XTAP_TAPCELL_ROW_6_206 VGND VPWR sky130_fd_sc_hd__tapvpwrvgnd_1
X_2735_ _1432_ _1433_ VGND VGND VPWR VPWR _0026_ sky130_fd_sc_hd__nor2_1
XFILLER_0_14_324 VPWR VGND VPWR VGND sky130_ef_sc_hd__decap_12
X_2666_ _1382_ _1383_ VGND VGND VPWR VPWR _1384_ sky130_fd_sc_hd__and2_4
X_1548_ _0411_ VGND VGND VPWR VPWR _0332_ sky130_fd_sc_hd__clkbuf_1
X_3149_ clknet_leaf_14_clk _0012_ VGND VGND VPWR VPWR display.counter\[14\] sky130_fd_sc_hd__dfxtp_1
XTAP_TAPCELL_ROW_65_672 VGND VPWR sky130_fd_sc_hd__tapvpwrvgnd_1
XFILLER_0_37_449 VGND VGND VPWR VPWR sky130_fd_sc_hd__fill_2
XFILLER_0_37_405 VGND VGND VPWR VPWR sky130_fd_sc_hd__decap_4
XFILLER_0_9_340 VGND VGND VPWR VPWR sky130_fd_sc_hd__decap_8
XFILLER_0_17_140 VGND VGND VPWR VPWR sky130_fd_sc_hd__decap_8
XFILLER_0_1_3 VPWR VGND VPWR VGND sky130_ef_sc_hd__decap_12
XFILLER_0_20_316 VPWR VGND VPWR VGND sky130_ef_sc_hd__decap_12
XFILLER_0_20_349 VGND VGND VPWR VPWR sky130_fd_sc_hd__decap_3
XFILLER_0_62_29 VPWR VGND VPWR VGND sky130_ef_sc_hd__decap_12
XFILLER_0_55_213 VGND VGND VPWR VPWR sky130_fd_sc_hd__fill_2
X_2451_ _1244_ VGND VGND VPWR VPWR _0262_ sky130_fd_sc_hd__clkbuf_1
XFILLER_0_23_110 VGND VGND VPWR VPWR sky130_fd_sc_hd__fill_2
XFILLER_0_11_55 VGND VGND VPWR VPWR sky130_fd_sc_hd__fill_1
XTAP_TAPCELL_ROW_11_241 VGND VPWR sky130_fd_sc_hd__tapvpwrvgnd_1
X_2520_ reg_file.registers\[15\]\[23\] _1293_ VGND VGND VPWR VPWR _1296_ sky130_fd_sc_hd__and2_1
X_3003_ clknet_leaf_4_clk _0226_ _0062_ VGND VGND VPWR VPWR reg_file.registers\[15\]\[5\]
+ sky130_fd_sc_hd__dfrtp_1
X_2382_ _0751_ _0730_ _0745_ VGND VGND VPWR VPWR _1183_ sky130_fd_sc_hd__or3_1
XTAP_TAPCELL_ROW_62_653 VGND VPWR sky130_fd_sc_hd__tapvpwrvgnd_1
XFILLER_0_19_405 VGND VGND VPWR VPWR sky130_fd_sc_hd__decap_8
XFILLER_0_19_449 VGND VGND VPWR VPWR sky130_fd_sc_hd__fill_2
XFILLER_0_46_235 VGND VGND VPWR VPWR sky130_fd_sc_hd__fill_1
XFILLER_0_34_419 VGND VGND VPWR VPWR sky130_fd_sc_hd__fill_1
XFILLER_0_6_321 VPWR VGND VPWR VGND sky130_ef_sc_hd__decap_12
XFILLER_0_6_365 VPWR VGND VPWR VGND sky130_ef_sc_hd__decap_12
X_2718_ _1422_ _1423_ VGND VGND VPWR VPWR _0019_ sky130_fd_sc_hd__nor2_1
X_2649_ net38 _0360_ VGND VGND VPWR VPWR _1368_ sky130_fd_sc_hd__nor2_1
XFILLER_0_69_349 VPWR VGND VPWR VGND sky130_ef_sc_hd__decap_12
XFILLER_0_69_305 VPWR VGND VPWR VGND sky130_ef_sc_hd__decap_12
XFILLER_0_37_246 VGND VGND VPWR VPWR sky130_fd_sc_hd__decap_4
XTAP_TAPCELL_ROW_25_355 VGND VPWR sky130_fd_sc_hd__tapvpwrvgnd_1
XFILLER_0_9_181 VPWR VGND VPWR VGND sky130_ef_sc_hd__decap_12
XFILLER_0_52_227 VGND VGND VPWR VPWR sky130_fd_sc_hd__fill_1
XFILLER_0_20_124 VGND VGND VPWR VPWR sky130_fd_sc_hd__decap_4
XFILLER_0_28_224 VGND VGND VPWR VPWR sky130_fd_sc_hd__decap_4
X_1882_ _0664_ _0695_ _0697_ VGND VGND VPWR VPWR _0698_ sky130_fd_sc_hd__or3b_2
X_1951_ reg_file.registers\[10\]\[17\] _0604_ _0609_ reg_file.registers\[11\]\[17\]
+ VGND VGND VPWR VPWR _0767_ sky130_fd_sc_hd__a22o_1
XFILLER_0_3_335 VGND VGND VPWR VPWR sky130_fd_sc_hd__fill_1
XFILLER_0_16_419 VGND VGND VPWR VPWR sky130_fd_sc_hd__fill_1
XFILLER_0_22_65 VPWR VGND VPWR VGND sky130_ef_sc_hd__decap_12
XFILLER_0_51_260 VPWR VGND VPWR VGND sky130_ef_sc_hd__decap_12
X_2434_ _1198_ _1200_ _0897_ VGND VGND VPWR VPWR _1230_ sky130_fd_sc_hd__mux2_1
X_2503_ reg_file.registers\[15\]\[31\] _1286_ VGND VGND VPWR VPWR _1287_ sky130_fd_sc_hd__and2_1
X_2365_ _0756_ _0761_ _1167_ _0498_ VGND VGND VPWR VPWR _1169_ sky130_fd_sc_hd__a31oi_1
XFILLER_0_11_113 VPWR VGND VPWR VGND sky130_ef_sc_hd__decap_12
XTAP_TAPCELL_ROW_39_469 VGND VPWR sky130_fd_sc_hd__tapvpwrvgnd_1
X_2296_ _1001_ _0991_ _0893_ VGND VGND VPWR VPWR _1106_ sky130_fd_sc_hd__mux2_1
XFILLER_0_2_53 VPWR VGND VPWR VGND sky130_ef_sc_hd__decap_12
XFILLER_0_2_97 VPWR VGND VPWR VGND sky130_ef_sc_hd__decap_12
XFILLER_0_19_213 VGND VGND VPWR VPWR sky130_fd_sc_hd__decap_8
XFILLER_0_6_195 VGND VGND VPWR VPWR sky130_fd_sc_hd__fill_1
XFILLER_0_69_179 VPWR VGND VPWR VGND sky130_ef_sc_hd__decap_12
XFILLER_0_65_385 VGND VGND VPWR VPWR sky130_fd_sc_hd__decap_6
XFILLER_0_0_305 VGND VGND VPWR VPWR sky130_fd_sc_hd__decap_3
XFILLER_0_0_349 VPWR VGND VPWR VGND sky130_ef_sc_hd__decap_12
X_2150_ _0963_ _0964_ _0877_ VGND VGND VPWR VPWR _0965_ sky130_fd_sc_hd__mux2_1
X_2081_ net34 VGND VGND VPWR VPWR _0897_ sky130_fd_sc_hd__clkbuf_4
X_2983_ clknet_leaf_4_clk _0213_ _0049_ VGND VGND VPWR VPWR imem.address\[24\] sky130_fd_sc_hd__dfrtp_1
X_1934_ _0747_ _0748_ VGND VGND VPWR VPWR _0750_ sky130_fd_sc_hd__nand2_1
XFILLER_0_71_377 VPWR VGND VPWR VGND sky130_ef_sc_hd__decap_12
XFILLER_0_71_333 VGND VGND VPWR VPWR sky130_fd_sc_hd__decap_3
X_1865_ reg_file.registers\[10\]\[3\] _0507_ _0607_ reg_file.registers\[11\]\[3\]
+ VGND VGND VPWR VPWR _0681_ sky130_fd_sc_hd__a22o_1
XFILLER_0_31_208 VGND VGND VPWR VPWR sky130_fd_sc_hd__fill_1
X_1796_ _0602_ _0611_ VGND VGND VPWR VPWR _0612_ sky130_fd_sc_hd__nand2_1
X_2417_ _1078_ _1082_ _0881_ VGND VGND VPWR VPWR _1215_ sky130_fd_sc_hd__mux2_1
XFILLER_0_42_3 VPWR VGND VPWR VGND sky130_ef_sc_hd__decap_12
X_2348_ _0807_ _0791_ _1152_ VGND VGND VPWR VPWR _1154_ sky130_fd_sc_hd__nand3_1
XTAP_TAPCELL_ROW_70_718 VGND VPWR sky130_fd_sc_hd__tapvpwrvgnd_1
XFILLER_0_66_127 VPWR VGND VPWR VGND sky130_ef_sc_hd__decap_12
X_2279_ reg_file.registers\[11\]\[27\] _1090_ _0933_ VGND VGND VPWR VPWR _1091_ sky130_fd_sc_hd__mux2_1
XFILLER_0_62_388 VPWR VGND VPWR VGND sky130_ef_sc_hd__decap_12
XFILLER_0_70_29 VPWR VGND VPWR VGND sky130_ef_sc_hd__decap_12
X_1581_ _0428_ VGND VGND VPWR VPWR _0429_ sky130_fd_sc_hd__buf_2
X_1650_ _0372_ _0384_ _0464_ _0465_ VGND VGND VPWR VPWR _0466_ sky130_fd_sc_hd__and4_1
XFILLER_0_53_388 VGND VGND VPWR VPWR sky130_fd_sc_hd__decap_4
XFILLER_0_53_366 VGND VGND VPWR VPWR sky130_fd_sc_hd__decap_8
XTAP_TAPCELL_ROW_41_486 VGND VPWR sky130_fd_sc_hd__tapvpwrvgnd_1
XFILLER_0_0_113 VPWR VGND VPWR VGND sky130_ef_sc_hd__decap_12
X_2202_ reg_file.registers\[11\]\[29\] _1015_ _0933_ VGND VGND VPWR VPWR _1016_ sky130_fd_sc_hd__mux2_1
XFILLER_0_44_85 VGND VGND VPWR VPWR sky130_fd_sc_hd__fill_1
X_2133_ _0866_ _0947_ VGND VGND VPWR VPWR _0948_ sky130_fd_sc_hd__or2_1
X_2064_ _0874_ _0875_ _0879_ VGND VGND VPWR VPWR _0880_ sky130_fd_sc_hd__mux2_1
XFILLER_0_28_97 VGND VGND VPWR VPWR sky130_fd_sc_hd__decap_3
XFILLER_0_71_141 VPWR VGND VPWR VGND sky130_ef_sc_hd__decap_12
X_2966_ clknet_leaf_6_clk _0196_ _0032_ VGND VGND VPWR VPWR imem.address\[7\] sky130_fd_sc_hd__dfrtp_1
X_1917_ _0708_ _0709_ VGND VGND VPWR VPWR _0733_ sky130_fd_sc_hd__nor2_1
XFILLER_0_56_193 VGND VGND VPWR VPWR sky130_fd_sc_hd__decap_3
X_2897_ _1466_ VGND VGND VPWR VPWR _0144_ sky130_fd_sc_hd__inv_2
XFILLER_0_69_93 VGND VGND VPWR VPWR sky130_fd_sc_hd__fill_1
X_1848_ _0662_ _0663_ VGND VGND VPWR VPWR _0664_ sky130_fd_sc_hd__nor2_1
XFILLER_0_44_399 VGND VGND VPWR VPWR sky130_fd_sc_hd__decap_8
XFILLER_0_8_41 VPWR VGND VPWR VGND sky130_ef_sc_hd__decap_12
XFILLER_0_8_85 VPWR VGND VPWR VGND sky130_ef_sc_hd__decap_12
XFILLER_0_12_285 VGND VGND VPWR VPWR sky130_fd_sc_hd__fill_1
X_1779_ _0592_ _0594_ VGND VGND VPWR VPWR _0595_ sky130_fd_sc_hd__or2_1
XTAP_TAPCELL_ROW_4_189 VGND VPWR sky130_fd_sc_hd__tapvpwrvgnd_1
XFILLER_0_67_447 VGND VGND VPWR VPWR sky130_fd_sc_hd__fill_1
XFILLER_0_62_141 VGND VGND VPWR VPWR sky130_fd_sc_hd__decap_4
Xclone10 net28 VGND VGND VPWR VPWR net26 sky130_fd_sc_hd__buf_2
XFILLER_0_35_355 VGND VGND VPWR VPWR sky130_fd_sc_hd__fill_1
XFILLER_0_35_311 VGND VGND VPWR VPWR sky130_fd_sc_hd__decap_8
XTAP_TAPCELL_ROW_46_523 VGND VPWR sky130_fd_sc_hd__tapvpwrvgnd_1
XFILLER_0_53_130 VGND VGND VPWR VPWR sky130_fd_sc_hd__decap_8
X_2751_ display.counter\[16\] display.counter\[17\] _1440_ VGND VGND VPWR VPWR _1442_
+ sky130_fd_sc_hd__and3_1
X_2820_ _1456_ VGND VGND VPWR VPWR _0077_ sky130_fd_sc_hd__inv_2
XFILLER_0_5_205 VPWR VGND VPWR VGND sky130_ef_sc_hd__decap_12
XFILLER_0_14_77 VGND VGND VPWR VPWR sky130_fd_sc_hd__decap_6
X_1633_ _0456_ VGND VGND VPWR VPWR _0292_ sky130_fd_sc_hd__clkbuf_1
X_1702_ _0384_ _0464_ VGND VGND VPWR VPWR _0518_ sky130_fd_sc_hd__and2_1
X_1564_ reg_file.registers\[5\]\[7\] _0414_ VGND VGND VPWR VPWR _0420_ sky130_fd_sc_hd__and2_1
XFILLER_0_41_303 VGND VGND VPWR VPWR sky130_fd_sc_hd__decap_8
XFILLER_0_30_98 VGND VGND VPWR VPWR sky130_fd_sc_hd__decap_6
XFILLER_0_26_377 VPWR VGND VPWR VGND sky130_ef_sc_hd__decap_12
X_2682_ _1047_ _1360_ _1399_ VGND VGND VPWR VPWR _1400_ sky130_fd_sc_hd__a21o_1
XFILLER_0_5_249 VPWR VGND VPWR VGND sky130_ef_sc_hd__decap_12
X_1495_ _0374_ VGND VGND VPWR VPWR _0375_ sky130_fd_sc_hd__dlymetal6s2s_1
XFILLER_0_55_51 VGND VGND VPWR VPWR sky130_fd_sc_hd__decap_4
XFILLER_0_64_417 VGND VGND VPWR VPWR sky130_fd_sc_hd__decap_3
X_2116_ _0684_ _0391_ VGND VGND VPWR VPWR _0932_ sky130_fd_sc_hd__nor2_2
X_3096_ clknet_leaf_4_clk _0319_ _0155_ VGND VGND VPWR VPWR reg_file.registers\[5\]\[2\]
+ sky130_fd_sc_hd__dfrtp_1
XFILLER_0_49_447 VGND VGND VPWR VPWR sky130_fd_sc_hd__fill_1
X_2047_ _0856_ _0862_ VGND VGND VPWR VPWR _0863_ sky130_fd_sc_hd__xnor2_1
X_2949_ _1472_ VGND VGND VPWR VPWR _1475_ sky130_fd_sc_hd__clkbuf_1
XTAP_TAPCELL_ROW_17_291 VGND VPWR sky130_fd_sc_hd__tapvpwrvgnd_1
XFILLER_0_17_333 VGND VGND VPWR VPWR sky130_fd_sc_hd__decap_3
XTAP_TAPCELL_ROW_9_226 VGND VPWR sky130_fd_sc_hd__tapvpwrvgnd_1
XFILLER_0_35_152 VPWR VGND VPWR VGND sky130_ef_sc_hd__decap_12
XFILLER_0_23_325 VGND VGND VPWR VPWR sky130_fd_sc_hd__decap_8
Xclkload18 clknet_leaf_16_clk VGND VGND VPWR VPWR clkload18/Y sky130_fd_sc_hd__inv_6
XFILLER_0_58_277 VGND VGND VPWR VPWR sky130_fd_sc_hd__decap_3
X_2803_ _1454_ VGND VGND VPWR VPWR _0062_ sky130_fd_sc_hd__inv_2
XFILLER_0_41_53 VGND VGND VPWR VPWR sky130_fd_sc_hd__decap_3
X_2734_ display.counter\[9\] _1430_ VGND VGND VPWR VPWR _1433_ sky130_fd_sc_hd__nor2_1
XFILLER_0_14_336 VGND VGND VPWR VPWR sky130_fd_sc_hd__decap_4
X_2596_ imem.address\[25\] _1334_ imem.address\[26\] VGND VGND VPWR VPWR _1343_ sky130_fd_sc_hd__a21oi_1
X_1616_ _0447_ VGND VGND VPWR VPWR _0300_ sky130_fd_sc_hd__clkbuf_1
XFILLER_0_41_155 VGND VGND VPWR VPWR sky130_fd_sc_hd__fill_2
XFILLER_0_41_144 VGND VGND VPWR VPWR sky130_fd_sc_hd__decap_4
X_1547_ reg_file.registers\[5\]\[15\] _0403_ VGND VGND VPWR VPWR _0411_ sky130_fd_sc_hd__and2_1
X_2665_ _1271_ _0358_ VGND VGND VPWR VPWR _1383_ sky130_fd_sc_hd__or2_1
XTAP_TAPCELL_ROW_6_207 VGND VPWR sky130_fd_sc_hd__tapvpwrvgnd_1
X_3148_ clknet_leaf_14_clk _0011_ VGND VGND VPWR VPWR display.counter\[13\] sky130_fd_sc_hd__dfxtp_1
XTAP_TAPCELL_ROW_65_673 VGND VPWR sky130_fd_sc_hd__tapvpwrvgnd_1
XFILLER_0_49_255 VGND VGND VPWR VPWR sky130_fd_sc_hd__fill_1
X_3079_ clknet_leaf_0_clk _0302_ _0138_ VGND VGND VPWR VPWR reg_file.registers\[10\]\[17\]
+ sky130_fd_sc_hd__dfrtp_1
XFILLER_0_20_328 VGND VGND VPWR VPWR sky130_fd_sc_hd__fill_2
XTAP_TAPCELL_ROW_11_242 VGND VPWR sky130_fd_sc_hd__tapvpwrvgnd_1
X_2450_ reg_file.registers\[11\]\[9\] _1243_ _1234_ VGND VGND VPWR VPWR _1244_ sky130_fd_sc_hd__mux2_1
X_2381_ _1182_ VGND VGND VPWR VPWR _0270_ sky130_fd_sc_hd__clkbuf_1
X_3002_ clknet_leaf_2_clk _0225_ _0061_ VGND VGND VPWR VPWR reg_file.registers\[15\]\[4\]
+ sky130_fd_sc_hd__dfrtp_1
XTAP_TAPCELL_ROW_62_654 VGND VPWR sky130_fd_sc_hd__tapvpwrvgnd_1
XFILLER_0_19_428 VGND VGND VPWR VPWR sky130_fd_sc_hd__fill_2
XFILLER_0_6_333 VPWR VGND VPWR VGND sky130_ef_sc_hd__decap_12
XFILLER_0_6_377 VPWR VGND VPWR VGND sky130_ef_sc_hd__decap_12
X_2717_ display.counter\[1\] display.counter\[0\] display.counter\[2\] VGND VGND VPWR
+ VPWR _1423_ sky130_fd_sc_hd__a21oi_1
X_2579_ imem.address\[20\] imem.address\[19\] _1330_ VGND VGND VPWR VPWR _1331_ sky130_fd_sc_hd__and3_1
X_2648_ _1367_ VGND VGND VPWR VPWR _0360_ sky130_fd_sc_hd__buf_1
XFILLER_0_69_317 VPWR VGND VPWR VGND sky130_ef_sc_hd__decap_12
XFILLER_0_37_225 VGND VGND VPWR VPWR sky130_fd_sc_hd__decap_4
XFILLER_0_37_203 VGND VGND VPWR VPWR sky130_fd_sc_hd__decap_3
XTAP_TAPCELL_ROW_25_356 VGND VPWR sky130_fd_sc_hd__tapvpwrvgnd_1
XFILLER_0_9_193 VPWR VGND VPWR VGND sky130_ef_sc_hd__decap_12
XFILLER_0_33_442 VGND VGND VPWR VPWR sky130_fd_sc_hd__decap_6
XFILLER_0_20_136 VGND VGND VPWR VPWR sky130_fd_sc_hd__decap_4
X_1950_ _0764_ _0765_ VGND VGND VPWR VPWR _0766_ sky130_fd_sc_hd__nor2_1
X_1881_ _0696_ _0656_ VGND VGND VPWR VPWR _0697_ sky130_fd_sc_hd__and2_1
XFILLER_0_51_272 VGND VGND VPWR VPWR sky130_fd_sc_hd__decap_8
XFILLER_0_36_280 VPWR VGND VPWR VGND sky130_ef_sc_hd__decap_12
X_2502_ _1285_ VGND VGND VPWR VPWR _1286_ sky130_fd_sc_hd__buf_2
XFILLER_0_22_77 VGND VGND VPWR VPWR sky130_fd_sc_hd__decap_3
X_2433_ _0710_ _0735_ _1227_ VGND VGND VPWR VPWR _1229_ sky130_fd_sc_hd__nand3_1
XFILLER_0_47_52 VGND VGND VPWR VPWR sky130_fd_sc_hd__decap_4
X_2364_ _0761_ _1167_ _0756_ VGND VGND VPWR VPWR _1168_ sky130_fd_sc_hd__a21o_1
XFILLER_0_11_125 VPWR VGND VPWR VGND sky130_ef_sc_hd__decap_12
XFILLER_0_11_169 VPWR VGND VPWR VGND sky130_ef_sc_hd__decap_12
XFILLER_0_2_65 VPWR VGND VPWR VGND sky130_ef_sc_hd__decap_12
X_2295_ _0817_ _0839_ _1103_ VGND VGND VPWR VPWR _1105_ sky130_fd_sc_hd__nand3_1
XFILLER_0_6_141 VPWR VGND VPWR VGND sky130_ef_sc_hd__decap_12
XFILLER_0_19_225 VGND VGND VPWR VPWR sky130_fd_sc_hd__decap_8
XFILLER_0_19_258 VGND VGND VPWR VPWR sky130_fd_sc_hd__decap_8
XFILLER_0_42_261 VGND VGND VPWR VPWR sky130_fd_sc_hd__fill_1
XTAP_TAPCELL_ROW_30_392 VGND VPWR sky130_fd_sc_hd__tapvpwrvgnd_1
XFILLER_0_15_431 VGND VGND VPWR VPWR sky130_fd_sc_hd__fill_1
XPHY_EDGE_ROW_6_Left_78 VGND VGND VPWR VPWR sky130_fd_sc_hd__decap_3
XFILLER_0_18_280 VGND VGND VPWR VPWR sky130_fd_sc_hd__decap_8
XFILLER_0_21_401 VGND VGND VPWR VPWR sky130_fd_sc_hd__fill_1
XFILLER_0_68_29 VPWR VGND VPWR VGND sky130_ef_sc_hd__decap_12
X_2080_ _0866_ _0895_ VGND VGND VPWR VPWR _0896_ sky130_fd_sc_hd__or2_1
XFILLER_0_17_55 VGND VGND VPWR VPWR sky130_fd_sc_hd__fill_1
X_2982_ clknet_leaf_4_clk _0212_ _0048_ VGND VGND VPWR VPWR imem.address\[23\] sky130_fd_sc_hd__dfrtp_1
XFILLER_0_56_397 VGND VGND VPWR VPWR sky130_fd_sc_hd__decap_4
XFILLER_0_56_375 VPWR VGND VPWR VGND sky130_ef_sc_hd__decap_12
XFILLER_0_56_342 VGND VGND VPWR VPWR sky130_fd_sc_hd__fill_1
X_1933_ _0747_ _0748_ VGND VGND VPWR VPWR _0749_ sky130_fd_sc_hd__or2_1
XFILLER_0_16_206 VGND VGND VPWR VPWR sky130_fd_sc_hd__decap_4
XFILLER_0_16_217 VGND VGND VPWR VPWR sky130_fd_sc_hd__decap_6
XFILLER_0_71_389 VGND VGND VPWR VPWR sky130_fd_sc_hd__decap_3
X_1864_ _0497_ _0658_ VGND VGND VPWR VPWR _0680_ sky130_fd_sc_hd__xnor2_1
X_1795_ reg_file.registers\[10\]\[30\] _0605_ _0610_ reg_file.registers\[11\]\[30\]
+ VGND VGND VPWR VPWR _0611_ sky130_fd_sc_hd__a22o_1
XFILLER_0_3_111 VGND VGND VPWR VPWR sky130_fd_sc_hd__fill_1
XFILLER_0_12_412 VGND VGND VPWR VPWR sky130_fd_sc_hd__fill_2
X_2416_ _1008_ _1213_ _0893_ VGND VGND VPWR VPWR _1214_ sky130_fd_sc_hd__mux2_1
XFILLER_0_35_3 VPWR VGND VPWR VGND sky130_ef_sc_hd__decap_12
X_2347_ _0807_ _1152_ _0791_ VGND VGND VPWR VPWR _1153_ sky130_fd_sc_hd__a21o_1
X_2278_ _0472_ _1052_ _1053_ _1089_ VGND VGND VPWR VPWR _1090_ sky130_fd_sc_hd__a31o_1
XTAP_TAPCELL_ROW_70_719 VGND VPWR sky130_fd_sc_hd__tapvpwrvgnd_1
XFILLER_0_66_139 VGND VGND VPWR VPWR sky130_fd_sc_hd__fill_1
X_1580_ imem.address\[3\] _0372_ _0376_ _0391_ VGND VGND VPWR VPWR _0428_ sky130_fd_sc_hd__or4_2
XFILLER_0_53_356 VGND VGND VPWR VPWR sky130_fd_sc_hd__decap_6
XTAP_TAPCELL_ROW_41_487 VGND VPWR sky130_fd_sc_hd__tapvpwrvgnd_1
XFILLER_0_0_125 VPWR VGND VPWR VGND sky130_ef_sc_hd__decap_12
XFILLER_0_21_242 VGND VGND VPWR VPWR sky130_fd_sc_hd__decap_8
X_2132_ _0943_ _0946_ _0898_ VGND VGND VPWR VPWR _0947_ sky130_fd_sc_hd__mux2_1
X_2201_ _0472_ _0851_ _0985_ _1014_ VGND VGND VPWR VPWR _1015_ sky130_fd_sc_hd__a31o_1
XFILLER_0_0_169 VPWR VGND VPWR VGND sky130_ef_sc_hd__decap_12
XFILLER_0_48_139 VGND VGND VPWR VPWR sky130_fd_sc_hd__fill_1
XFILLER_0_44_75 VGND VGND VPWR VPWR sky130_fd_sc_hd__fill_1
X_2063_ _0878_ VGND VGND VPWR VPWR _0879_ sky130_fd_sc_hd__clkbuf_4
XFILLER_0_71_153 VGND VGND VPWR VPWR sky130_fd_sc_hd__decap_3
X_2965_ clknet_leaf_6_clk _0195_ _0031_ VGND VGND VPWR VPWR imem.address\[6\] sky130_fd_sc_hd__dfrtp_1
X_1847_ reg_file.registers\[10\]\[5\] _0620_ _0622_ reg_file.registers\[11\]\[5\]
+ VGND VGND VPWR VPWR _0663_ sky130_fd_sc_hd__a22o_1
XFILLER_0_60_85 VPWR VGND VPWR VGND sky130_ef_sc_hd__decap_12
X_1916_ _0637_ _0731_ _0650_ VGND VGND VPWR VPWR _0732_ sky130_fd_sc_hd__and3b_1
XTAP_TAPCELL_ROW_32_410 VGND VPWR sky130_fd_sc_hd__tapvpwrvgnd_1
X_2896_ _1466_ VGND VGND VPWR VPWR _0143_ sky130_fd_sc_hd__inv_2
XFILLER_0_71_197 VPWR VGND VPWR VGND sky130_ef_sc_hd__decap_12
XFILLER_0_8_53 VPWR VGND VPWR VGND sky130_ef_sc_hd__decap_12
XFILLER_0_8_97 VPWR VGND VPWR VGND sky130_ef_sc_hd__decap_12
XFILLER_0_12_297 VGND VGND VPWR VPWR sky130_fd_sc_hd__decap_8
X_1778_ _0566_ _0593_ VGND VGND VPWR VPWR _0594_ sky130_fd_sc_hd__and2_1
XFILLER_0_62_197 VGND VGND VPWR VPWR sky130_fd_sc_hd__decap_4
XFILLER_0_62_175 VPWR VGND VPWR VGND sky130_ef_sc_hd__decap_12
Xclone22 _0389_ VGND VGND VPWR VPWR net38 sky130_fd_sc_hd__buf_2
XTAP_TAPCELL_ROW_46_524 VGND VPWR sky130_fd_sc_hd__tapvpwrvgnd_1
XPHY_EDGE_ROW_9_Left_81 VGND VGND VPWR VPWR sky130_fd_sc_hd__decap_3
X_1701_ _0382_ _0383_ VGND VGND VPWR VPWR _0517_ sky130_fd_sc_hd__nor2_1
XTAP_TAPCELL_ROW_54_590 VGND VPWR sky130_fd_sc_hd__tapvpwrvgnd_1
X_2750_ display.counter\[16\] _1440_ VGND VGND VPWR VPWR _0014_ sky130_fd_sc_hd__xor2_1
XFILLER_0_26_389 VGND VGND VPWR VPWR sky130_fd_sc_hd__decap_3
XFILLER_0_26_345 VGND VGND VPWR VPWR sky130_fd_sc_hd__fill_1
X_2681_ _1124_ _1364_ _1398_ VGND VGND VPWR VPWR _1399_ sky130_fd_sc_hd__a21o_1
XFILLER_0_5_217 VGND VGND VPWR VPWR sky130_fd_sc_hd__decap_6
X_1494_ imem.address\[9\] imem.address\[8\] imem.address\[7\] imem.address\[6\] VGND
+ VGND VPWR VPWR _0374_ sky130_fd_sc_hd__or4_1
X_1632_ reg_file.registers\[10\]\[7\] _0449_ VGND VGND VPWR VPWR _0456_ sky130_fd_sc_hd__and2_1
X_1563_ _0419_ VGND VGND VPWR VPWR _0325_ sky130_fd_sc_hd__clkbuf_1
XFILLER_0_39_53 VGND VGND VPWR VPWR sky130_fd_sc_hd__decap_3
XFILLER_0_30_77 VGND VGND VPWR VPWR sky130_fd_sc_hd__fill_1
XFILLER_0_30_66 VGND VGND VPWR VPWR sky130_fd_sc_hd__decap_4
X_3095_ clknet_leaf_2_clk _0318_ _0154_ VGND VGND VPWR VPWR reg_file.registers\[5\]\[1\]
+ sky130_fd_sc_hd__dfrtp_1
X_2115_ _0472_ _0864_ _0865_ _0930_ VGND VGND VPWR VPWR _0931_ sky130_fd_sc_hd__a31o_1
XFILLER_0_29_150 VGND VGND VPWR VPWR sky130_fd_sc_hd__fill_1
X_2046_ _0857_ _0861_ VGND VGND VPWR VPWR _0862_ sky130_fd_sc_hd__xnor2_1
XTAP_TAPCELL_ROW_17_292 VGND VPWR sky130_fd_sc_hd__tapvpwrvgnd_1
XFILLER_0_17_301 VGND VGND VPWR VPWR sky130_fd_sc_hd__decap_6
X_2879_ _1464_ VGND VGND VPWR VPWR _0128_ sky130_fd_sc_hd__inv_2
X_2948_ _1474_ VGND VGND VPWR VPWR _0187_ sky130_fd_sc_hd__inv_2
XFILLER_0_44_197 VGND VGND VPWR VPWR sky130_fd_sc_hd__decap_6
XTAP_TAPCELL_ROW_9_227 VGND VPWR sky130_fd_sc_hd__tapvpwrvgnd_1
XFILLER_0_67_223 VGND VGND VPWR VPWR sky130_fd_sc_hd__fill_1
XFILLER_0_67_289 VGND VGND VPWR VPWR sky130_fd_sc_hd__fill_1
XTAP_TAPCELL_ROW_51_560 VGND VPWR sky130_fd_sc_hd__tapvpwrvgnd_1
XFILLER_0_35_164 VGND VGND VPWR VPWR sky130_fd_sc_hd__decap_4
Xclkload19 clknet_leaf_17_clk VGND VGND VPWR VPWR clkload19/Y sky130_fd_sc_hd__clkinvlp_4
XFILLER_0_23_359 VGND VGND VPWR VPWR sky130_fd_sc_hd__decap_8
XFILLER_0_23_337 VGND VGND VPWR VPWR sky130_fd_sc_hd__decap_4
XFILLER_0_2_209 VPWR VGND VPWR VGND sky130_ef_sc_hd__decap_12
XFILLER_0_46_418 VGND VGND VPWR VPWR sky130_fd_sc_hd__fill_2
XFILLER_0_25_55 VGND VGND VPWR VPWR sky130_fd_sc_hd__fill_1
X_2802_ _1454_ VGND VGND VPWR VPWR _0061_ sky130_fd_sc_hd__inv_2
XFILLER_0_26_197 VGND VGND VPWR VPWR sky130_fd_sc_hd__decap_8
X_2664_ _0509_ _0983_ _1360_ _1381_ VGND VGND VPWR VPWR _1382_ sky130_fd_sc_hd__a31o_1
X_2733_ display.counter\[9\] _1430_ VGND VGND VPWR VPWR _1432_ sky130_fd_sc_hd__and2_1
XFILLER_0_66_62 VGND VGND VPWR VPWR sky130_fd_sc_hd__decap_3
X_2595_ _1336_ _1342_ VGND VGND VPWR VPWR _0216_ sky130_fd_sc_hd__nor2_1
X_1615_ reg_file.registers\[10\]\[15\] _0438_ VGND VGND VPWR VPWR _0447_ sky130_fd_sc_hd__and2_1
X_1546_ _0410_ VGND VGND VPWR VPWR _0333_ sky130_fd_sc_hd__clkbuf_1
XTAP_TAPCELL_ROW_65_674 VGND VPWR sky130_fd_sc_hd__tapvpwrvgnd_1
XTAP_TAPCELL_ROW_57_608 VGND VPWR sky130_fd_sc_hd__tapvpwrvgnd_1
X_3078_ clknet_leaf_0_clk _0301_ _0137_ VGND VGND VPWR VPWR reg_file.registers\[10\]\[16\]
+ sky130_fd_sc_hd__dfrtp_1
X_3147_ clknet_leaf_13_clk _0010_ VGND VGND VPWR VPWR display.counter\[12\] sky130_fd_sc_hd__dfxtp_1
XPHY_EDGE_ROW_59_Left_131 VGND VGND VPWR VPWR sky130_fd_sc_hd__decap_3
XFILLER_0_37_429 VGND VGND VPWR VPWR sky130_fd_sc_hd__fill_2
X_2029_ _0831_ _0842_ _0834_ _0844_ VGND VGND VPWR VPWR _0845_ sky130_fd_sc_hd__and4b_1
XPHY_EDGE_ROW_68_Left_140 VGND VGND VPWR VPWR sky130_fd_sc_hd__decap_3
XFILLER_0_60_421 VPWR VGND VPWR VGND sky130_ef_sc_hd__decap_12
XFILLER_0_32_134 VGND VGND VPWR VPWR sky130_fd_sc_hd__fill_1
XFILLER_0_20_307 VGND VGND VPWR VPWR sky130_fd_sc_hd__fill_1
XTAP_TAPCELL_ROW_28_376 VGND VPWR sky130_fd_sc_hd__tapvpwrvgnd_1
XFILLER_0_63_281 VGND VGND VPWR VPWR sky130_fd_sc_hd__fill_2
XFILLER_0_23_156 VGND VGND VPWR VPWR sky130_fd_sc_hd__fill_1
XFILLER_0_11_57 VPWR VGND VPWR VGND sky130_ef_sc_hd__decap_12
XTAP_TAPCELL_ROW_11_243 VGND VPWR sky130_fd_sc_hd__tapvpwrvgnd_1
X_2380_ reg_file.registers\[11\]\[17\] _1181_ _1158_ VGND VGND VPWR VPWR _1182_ sky130_fd_sc_hd__mux2_1
X_3001_ clknet_leaf_2_clk _0224_ _0060_ VGND VGND VPWR VPWR reg_file.registers\[15\]\[3\]
+ sky130_fd_sc_hd__dfrtp_1
XTAP_TAPCELL_ROW_19_310 VGND VPWR sky130_fd_sc_hd__tapvpwrvgnd_1
XTAP_TAPCELL_ROW_62_655 VGND VPWR sky130_fd_sc_hd__tapvpwrvgnd_1
XFILLER_0_52_64 VGND VGND VPWR VPWR sky130_fd_sc_hd__fill_2
XFILLER_0_6_301 VGND VGND VPWR VPWR sky130_fd_sc_hd__decap_6
XFILLER_0_65_3 VPWR VGND VPWR VGND sky130_ef_sc_hd__decap_12
XFILLER_0_42_421 VPWR VGND VPWR VGND sky130_ef_sc_hd__decap_12
X_2647_ display.digit_sel\[2\] display.digit_sel\[0\] display.digit_sel\[1\] VGND
+ VGND VPWR VPWR _1367_ sky130_fd_sc_hd__or3b_1
XFILLER_0_6_345 VPWR VGND VPWR VGND sky130_ef_sc_hd__decap_12
XFILLER_0_6_389 VPWR VGND VPWR VGND sky130_ef_sc_hd__decap_12
X_2716_ display.counter\[1\] display.counter\[0\] display.counter\[2\] VGND VGND VPWR
+ VPWR _1422_ sky130_fd_sc_hd__and3_1
X_2578_ imem.address\[18\] _1329_ VGND VGND VPWR VPWR _1330_ sky130_fd_sc_hd__and2_1
X_1529_ _0401_ VGND VGND VPWR VPWR _0341_ sky130_fd_sc_hd__clkbuf_1
XFILLER_0_69_329 VGND VGND VPWR VPWR sky130_fd_sc_hd__decap_6
XTAP_TAPCELL_ROW_25_357 VGND VPWR sky130_fd_sc_hd__tapvpwrvgnd_1
XFILLER_0_45_281 VPWR VGND VPWR VGND sky130_ef_sc_hd__decap_12
XFILLER_0_37_259 VGND VGND VPWR VPWR sky130_fd_sc_hd__decap_8
XFILLER_0_9_161 VGND VGND VPWR VPWR sky130_fd_sc_hd__decap_6
XPHY_EDGE_ROW_14_Right_14 VGND VGND VPWR VPWR sky130_fd_sc_hd__decap_3
XPHY_EDGE_ROW_23_Right_23 VGND VGND VPWR VPWR sky130_fd_sc_hd__decap_3
X_1880_ _0654_ _0655_ VGND VGND VPWR VPWR _0696_ sky130_fd_sc_hd__or2_1
XPHY_EDGE_ROW_32_Right_32 VGND VGND VPWR VPWR sky130_fd_sc_hd__decap_3
X_2501_ imem.address\[3\] _0473_ _0376_ _0391_ VGND VGND VPWR VPWR _1285_ sky130_fd_sc_hd__or4_4
XFILLER_0_36_292 VGND VGND VPWR VPWR sky130_fd_sc_hd__fill_1
XFILLER_0_24_421 VGND VGND VPWR VPWR sky130_fd_sc_hd__fill_1
XFILLER_0_3_337 VPWR VGND VPWR VGND sky130_ef_sc_hd__decap_12
XFILLER_0_11_137 VPWR VGND VPWR VGND sky130_ef_sc_hd__decap_12
X_2432_ _0735_ _1227_ _0710_ VGND VGND VPWR VPWR _1228_ sky130_fd_sc_hd__a21o_1
XFILLER_0_47_86 VGND VGND VPWR VPWR sky130_fd_sc_hd__decap_8
XPHY_EDGE_ROW_41_Right_41 VGND VGND VPWR VPWR sky130_fd_sc_hd__decap_3
X_2363_ _0768_ _1166_ _0762_ VGND VGND VPWR VPWR _1167_ sky130_fd_sc_hd__a21o_1
X_2294_ _0839_ _1103_ _0817_ VGND VGND VPWR VPWR _1104_ sky130_fd_sc_hd__a21o_1
XPHY_EDGE_ROW_22_Left_94 VGND VGND VPWR VPWR sky130_fd_sc_hd__decap_3
XFILLER_0_63_30 VPWR VGND VPWR VGND sky130_ef_sc_hd__decap_12
XPHY_EDGE_ROW_50_Right_50 VGND VGND VPWR VPWR sky130_fd_sc_hd__decap_3
XFILLER_0_2_77 VGND VGND VPWR VPWR sky130_fd_sc_hd__decap_6
XFILLER_0_27_281 VGND VGND VPWR VPWR sky130_fd_sc_hd__decap_6
XFILLER_0_6_153 VPWR VGND VPWR VGND sky130_ef_sc_hd__decap_12
XFILLER_0_30_446 VGND VGND VPWR VPWR sky130_fd_sc_hd__fill_2
XTAP_TAPCELL_ROW_30_393 VGND VPWR sky130_fd_sc_hd__tapvpwrvgnd_1
XFILLER_0_6_197 VPWR VGND VPWR VGND sky130_ef_sc_hd__decap_12
XFILLER_0_69_159 VGND VGND VPWR VPWR sky130_fd_sc_hd__decap_3
XTAP_TAPCELL_ROW_38_460 VGND VPWR sky130_fd_sc_hd__tapvpwrvgnd_1
X_2981_ clknet_leaf_4_clk _0211_ _0047_ VGND VGND VPWR VPWR imem.address\[22\] sky130_fd_sc_hd__dfrtp_1
XFILLER_0_56_387 VGND VGND VPWR VPWR sky130_fd_sc_hd__decap_6
XFILLER_0_56_321 VGND VGND VPWR VPWR sky130_fd_sc_hd__fill_2
X_1863_ _0669_ _0677_ _0678_ VGND VGND VPWR VPWR _0679_ sky130_fd_sc_hd__a21o_1
X_1932_ reg_file.registers\[10\]\[16\] _0641_ _0642_ reg_file.registers\[11\]\[16\]
+ VGND VGND VPWR VPWR _0748_ sky130_fd_sc_hd__a22o_1
X_2415_ _1070_ _1075_ _0882_ VGND VGND VPWR VPWR _1213_ sky130_fd_sc_hd__mux2_1
X_1794_ _0609_ VGND VGND VPWR VPWR _0610_ sky130_fd_sc_hd__buf_2
XFILLER_0_24_251 VGND VGND VPWR VPWR sky130_fd_sc_hd__fill_1
XFILLER_0_3_167 VGND VGND VPWR VPWR sky130_fd_sc_hd__fill_1
X_2277_ _1056_ _1065_ _1068_ _1088_ _0937_ VGND VGND VPWR VPWR _1089_ sky130_fd_sc_hd__a32o_1
XFILLER_0_28_3 VPWR VGND VPWR VGND sky130_ef_sc_hd__decap_12
X_2346_ _1129_ _1130_ _0786_ VGND VGND VPWR VPWR _1152_ sky130_fd_sc_hd__o21ai_1
XFILLER_0_66_107 VGND VGND VPWR VPWR sky130_fd_sc_hd__fill_1
XFILLER_0_47_332 VGND VGND VPWR VPWR sky130_fd_sc_hd__decap_4
XFILLER_0_47_321 VGND VGND VPWR VPWR sky130_fd_sc_hd__fill_1
XFILLER_0_62_324 VGND VGND VPWR VPWR sky130_fd_sc_hd__fill_1
XFILLER_0_47_376 VGND VGND VPWR VPWR sky130_fd_sc_hd__fill_1
XFILLER_0_15_273 VGND VGND VPWR VPWR sky130_fd_sc_hd__decap_6
XFILLER_0_65_151 VPWR VGND VPWR VGND sky130_ef_sc_hd__decap_12
XFILLER_0_53_335 VGND VGND VPWR VPWR sky130_fd_sc_hd__fill_1
XFILLER_0_38_365 VGND VGND VPWR VPWR sky130_fd_sc_hd__decap_8
XFILLER_0_0_137 VGND VGND VPWR VPWR sky130_fd_sc_hd__decap_3
X_2062_ _0877_ VGND VGND VPWR VPWR _0878_ sky130_fd_sc_hd__clkbuf_4
XTAP_TAPCELL_ROW_49_544 VGND VPWR sky130_fd_sc_hd__tapvpwrvgnd_1
X_2131_ _0944_ _0945_ _0901_ VGND VGND VPWR VPWR _0946_ sky130_fd_sc_hd__mux2_1
X_2200_ _0940_ _0993_ _0998_ _1013_ _0937_ VGND VGND VPWR VPWR _1014_ sky130_fd_sc_hd__a32o_1
X_2964_ clknet_leaf_6_clk _0194_ _0030_ VGND VGND VPWR VPWR imem.address\[5\] sky130_fd_sc_hd__dfrtp_1
XTAP_TAPCELL_ROW_32_411 VGND VPWR sky130_fd_sc_hd__tapvpwrvgnd_1
XFILLER_0_52_390 VGND VGND VPWR VPWR sky130_fd_sc_hd__decap_6
X_1846_ _0600_ _0661_ _0527_ VGND VGND VPWR VPWR _0662_ sky130_fd_sc_hd__o21ai_2
XFILLER_0_44_368 VGND VGND VPWR VPWR sky130_fd_sc_hd__decap_8
XFILLER_0_44_346 VGND VGND VPWR VPWR sky130_fd_sc_hd__decap_4
X_1915_ _0644_ _0646_ VGND VGND VPWR VPWR _0731_ sky130_fd_sc_hd__nor2_1
XFILLER_0_4_421 VPWR VGND VPWR VGND sky130_ef_sc_hd__decap_12
XFILLER_0_8_65 VPWR VGND VPWR VGND sky130_ef_sc_hd__decap_12
Xclkbuf_leaf_14_clk clknet_1_1__leaf_clk VGND VGND VPWR VPWR clknet_leaf_14_clk sky130_fd_sc_hd__clkbuf_8
XFILLER_0_12_221 VGND VGND VPWR VPWR sky130_fd_sc_hd__decap_4
X_2895_ _1466_ VGND VGND VPWR VPWR _0142_ sky130_fd_sc_hd__inv_2
X_1777_ reg_file.registers\[15\]\[29\] _0569_ _0570_ reg_file.registers\[5\]\[29\]
+ VGND VGND VPWR VPWR _0593_ sky130_fd_sc_hd__a22o_1
XFILLER_0_69_51 VGND VGND VPWR VPWR sky130_fd_sc_hd__decap_4
XPHY_EDGE_ROW_31_Left_103 VGND VGND VPWR VPWR sky130_fd_sc_hd__decap_3
XPHY_EDGE_ROW_4_Right_4 VGND VGND VPWR VPWR sky130_fd_sc_hd__decap_3
XFILLER_0_67_405 VPWR VGND VPWR VGND sky130_ef_sc_hd__decap_12
XPHY_EDGE_ROW_40_Left_112 VGND VGND VPWR VPWR sky130_fd_sc_hd__decap_3
X_2329_ _1071_ _1079_ _0894_ VGND VGND VPWR VPWR _1137_ sky130_fd_sc_hd__mux2_1
XFILLER_0_67_449 VGND VGND VPWR VPWR sky130_fd_sc_hd__fill_2
XFILLER_0_47_195 VGND VGND VPWR VPWR sky130_fd_sc_hd__decap_8
XFILLER_0_62_187 VGND VGND VPWR VPWR sky130_fd_sc_hd__decap_8
XFILLER_0_35_379 VPWR VGND VPWR VGND sky130_ef_sc_hd__decap_12
XFILLER_0_7_281 VPWR VGND VPWR VGND sky130_ef_sc_hd__decap_12
XTAP_TAPCELL_ROW_54_591 VGND VPWR sky130_fd_sc_hd__tapvpwrvgnd_1
XTAP_TAPCELL_ROW_46_525 VGND VPWR sky130_fd_sc_hd__tapvpwrvgnd_1
XTAP_TAPCELL_ROW_3_180 VGND VPWR sky130_fd_sc_hd__tapvpwrvgnd_1
X_1631_ _0455_ VGND VGND VPWR VPWR _0293_ sky130_fd_sc_hd__clkbuf_1
X_1700_ _0515_ _0514_ _0390_ VGND VGND VPWR VPWR _0516_ sky130_fd_sc_hd__or3_4
XFILLER_0_30_89 VGND VGND VPWR VPWR sky130_fd_sc_hd__fill_1
XFILLER_0_30_45 VGND VGND VPWR VPWR sky130_fd_sc_hd__fill_1
X_2680_ _1164_ _1361_ _1396_ _1397_ VGND VGND VPWR VPWR _1398_ sky130_fd_sc_hd__a211o_1
XFILLER_0_26_335 VGND VGND VPWR VPWR sky130_fd_sc_hd__fill_1
X_1493_ imem.address\[5\] imem.address\[3\] imem.address\[4\] VGND VGND VPWR VPWR
+ _0373_ sky130_fd_sc_hd__or3b_1
X_1562_ reg_file.registers\[5\]\[8\] _0414_ VGND VGND VPWR VPWR _0419_ sky130_fd_sc_hd__and2_1
Xclkbuf_leaf_3_clk clknet_1_0__leaf_clk VGND VGND VPWR VPWR clknet_leaf_3_clk sky130_fd_sc_hd__clkbuf_8
X_3094_ clknet_leaf_4_clk _0317_ _0153_ VGND VGND VPWR VPWR reg_file.registers\[5\]\[0\]
+ sky130_fd_sc_hd__dfrtp_1
X_2045_ _0510_ _0860_ _0638_ VGND VGND VPWR VPWR _0861_ sky130_fd_sc_hd__o21ai_1
X_2114_ _0896_ _0911_ _0912_ _0928_ _0929_ VGND VGND VPWR VPWR _0930_ sky130_fd_sc_hd__a32o_1
XFILLER_0_71_85 VPWR VGND VPWR VGND sky130_ef_sc_hd__decap_12
XFILLER_0_71_41 VPWR VGND VPWR VGND sky130_ef_sc_hd__decap_12
XFILLER_0_49_449 VGND VGND VPWR VPWR sky130_fd_sc_hd__fill_2
X_2947_ _1474_ VGND VGND VPWR VPWR _0186_ sky130_fd_sc_hd__inv_2
XTAP_TAPCELL_ROW_17_293 VGND VPWR sky130_fd_sc_hd__tapvpwrvgnd_1
X_2878_ _1464_ VGND VGND VPWR VPWR _0127_ sky130_fd_sc_hd__inv_2
X_1829_ reg_file.registers\[10\]\[12\] _0603_ _0608_ reg_file.registers\[11\]\[12\]
+ VGND VGND VPWR VPWR _0645_ sky130_fd_sc_hd__a22o_1
XFILLER_0_40_371 VGND VGND VPWR VPWR sky130_fd_sc_hd__fill_1
XFILLER_0_25_390 VGND VGND VPWR VPWR sky130_fd_sc_hd__fill_2
XFILLER_0_4_251 VGND VGND VPWR VPWR sky130_fd_sc_hd__fill_1
XTAP_TAPCELL_ROW_9_228 VGND VPWR sky130_fd_sc_hd__tapvpwrvgnd_1
XFILLER_0_40_393 VPWR VGND VPWR VGND sky130_ef_sc_hd__decap_12
XTAP_TAPCELL_ROW_0_150 VGND VPWR sky130_fd_sc_hd__tapvpwrvgnd_1
XFILLER_0_63_441 VGND VGND VPWR VPWR sky130_fd_sc_hd__decap_6
XTAP_TAPCELL_ROW_51_561 VGND VPWR sky130_fd_sc_hd__tapvpwrvgnd_1
XFILLER_0_50_135 VGND VGND VPWR VPWR sky130_fd_sc_hd__decap_4
X_2801_ _1454_ VGND VGND VPWR VPWR _0060_ sky130_fd_sc_hd__inv_2
X_2594_ imem.address\[27\] _1335_ VGND VGND VPWR VPWR _1342_ sky130_fd_sc_hd__nor2_1
XFILLER_0_41_179 VGND VGND VPWR VPWR sky130_fd_sc_hd__fill_1
X_1614_ _0446_ VGND VGND VPWR VPWR _0301_ sky130_fd_sc_hd__clkbuf_1
X_2663_ _0509_ _1150_ _1361_ _1380_ VGND VGND VPWR VPWR _1381_ sky130_fd_sc_hd__a31o_1
X_2732_ _1430_ _1431_ VGND VGND VPWR VPWR _0025_ sky130_fd_sc_hd__nor2_1
XFILLER_0_66_85 VGND VGND VPWR VPWR sky130_fd_sc_hd__decap_4
XFILLER_0_66_41 VPWR VGND VPWR VGND sky130_ef_sc_hd__decap_12
XTAP_TAPCELL_ROW_57_609 VGND VPWR sky130_fd_sc_hd__tapvpwrvgnd_1
X_1545_ reg_file.registers\[5\]\[16\] _0403_ VGND VGND VPWR VPWR _0410_ sky130_fd_sc_hd__and2_1
XFILLER_0_5_55 VGND VGND VPWR VPWR sky130_fd_sc_hd__fill_1
XTAP_TAPCELL_ROW_65_675 VGND VPWR sky130_fd_sc_hd__tapvpwrvgnd_1
X_3077_ clknet_leaf_1_clk _0300_ _0136_ VGND VGND VPWR VPWR reg_file.registers\[10\]\[15\]
+ sky130_fd_sc_hd__dfrtp_1
XFILLER_0_10_3 VPWR VGND VPWR VGND sky130_ef_sc_hd__decap_12
X_3146_ clknet_leaf_13_clk _0009_ VGND VGND VPWR VPWR display.counter\[11\] sky130_fd_sc_hd__dfxtp_1
X_2028_ _0832_ _0843_ VGND VGND VPWR VPWR _0844_ sky130_fd_sc_hd__or2_1
XFILLER_0_17_110 VGND VGND VPWR VPWR sky130_fd_sc_hd__fill_2
XFILLER_0_17_165 VGND VGND VPWR VPWR sky130_fd_sc_hd__decap_3
XFILLER_0_17_198 VGND VGND VPWR VPWR sky130_fd_sc_hd__decap_3
XFILLER_0_60_433 VPWR VGND VPWR VGND sky130_ef_sc_hd__decap_12
XFILLER_0_13_393 VGND VGND VPWR VPWR sky130_fd_sc_hd__fill_1
XFILLER_0_55_249 VGND VGND VPWR VPWR sky130_fd_sc_hd__fill_1
XFILLER_0_55_205 VGND VGND VPWR VPWR sky130_fd_sc_hd__fill_1
XTAP_TAPCELL_ROW_28_377 VGND VPWR sky130_fd_sc_hd__tapvpwrvgnd_1
XFILLER_0_63_271 VGND VGND VPWR VPWR sky130_fd_sc_hd__fill_2
XFILLER_0_51_444 VGND VGND VPWR VPWR sky130_fd_sc_hd__fill_1
XFILLER_0_23_102 VGND VGND VPWR VPWR sky130_fd_sc_hd__decap_8
XFILLER_0_11_69 VPWR VGND VPWR VGND sky130_ef_sc_hd__decap_12
XTAP_TAPCELL_ROW_11_244 VGND VPWR sky130_fd_sc_hd__tapvpwrvgnd_1
X_3000_ clknet_leaf_2_clk _0223_ _0059_ VGND VGND VPWR VPWR reg_file.registers\[15\]\[2\]
+ sky130_fd_sc_hd__dfrtp_1
XTAP_TAPCELL_ROW_19_311 VGND VPWR sky130_fd_sc_hd__tapvpwrvgnd_1
XFILLER_0_61_219 VGND VGND VPWR VPWR sky130_fd_sc_hd__fill_2
XFILLER_0_54_260 VPWR VGND VPWR VGND sky130_ef_sc_hd__decap_12
XFILLER_0_52_98 VGND VGND VPWR VPWR sky130_fd_sc_hd__fill_1
XFILLER_0_46_249 VGND VGND VPWR VPWR sky130_fd_sc_hd__decap_3
XFILLER_0_42_411 VGND VGND VPWR VPWR sky130_fd_sc_hd__decap_8
XFILLER_0_6_357 VGND VGND VPWR VPWR sky130_fd_sc_hd__decap_6
X_2577_ imem.address\[17\] imem.address\[16\] _1328_ VGND VGND VPWR VPWR _1329_ sky130_fd_sc_hd__and3_1
XFILLER_0_58_3 VPWR VGND VPWR VGND sky130_ef_sc_hd__decap_12
XFILLER_0_54_293 VGND VGND VPWR VPWR sky130_fd_sc_hd__fill_1
XFILLER_0_42_433 VPWR VGND VPWR VGND sky130_ef_sc_hd__decap_12
X_2646_ display.digit_sel\[2\] _1365_ VGND VGND VPWR VPWR _1366_ sky130_fd_sc_hd__nor2_2
XFILLER_0_22_190 VGND VGND VPWR VPWR sky130_fd_sc_hd__decap_6
X_2715_ display.counter\[1\] display.counter\[0\] VGND VGND VPWR VPWR _0018_ sky130_fd_sc_hd__xor2_1
X_1528_ reg_file.registers\[5\]\[24\] _0393_ VGND VGND VPWR VPWR _0401_ sky130_fd_sc_hd__and2_1
X_3129_ clknet_leaf_0_clk _0352_ _0188_ VGND VGND VPWR VPWR reg_file.registers\[2\]\[4\]
+ sky130_fd_sc_hd__dfrtp_1
XTAP_TAPCELL_ROW_25_358 VGND VPWR sky130_fd_sc_hd__tapvpwrvgnd_1
XFILLER_0_45_293 VGND VGND VPWR VPWR sky130_fd_sc_hd__decap_3
XFILLER_0_68_363 VGND VGND VPWR VPWR sky130_fd_sc_hd__fill_1
XFILLER_0_43_219 VGND VGND VPWR VPWR sky130_fd_sc_hd__decap_4
X_2500_ _0372_ net1 _1282_ VGND VGND VPWR VPWR _1284_ sky130_fd_sc_hd__and3_1
X_2431_ _0718_ _1226_ VGND VGND VPWR VPWR _1227_ sky130_fd_sc_hd__nand2_1
XFILLER_0_51_241 VGND VGND VPWR VPWR sky130_fd_sc_hd__fill_1
XFILLER_0_3_349 VPWR VGND VPWR VGND sky130_ef_sc_hd__decap_12
XFILLER_0_3_305 VPWR VGND VPWR VGND sky130_ef_sc_hd__decap_12
XFILLER_0_11_105 VGND VGND VPWR VPWR sky130_fd_sc_hd__decap_6
XFILLER_0_11_149 VPWR VGND VPWR VGND sky130_ef_sc_hd__decap_12
X_2362_ _0750_ _0752_ _0766_ VGND VGND VPWR VPWR _1166_ sky130_fd_sc_hd__a21o_1
X_2293_ _0793_ _0810_ _0823_ VGND VGND VPWR VPWR _1103_ sky130_fd_sc_hd__a21o_1
XFILLER_0_63_42 VGND VGND VPWR VPWR sky130_fd_sc_hd__decap_4
XFILLER_0_59_341 VGND VGND VPWR VPWR sky130_fd_sc_hd__fill_1
XFILLER_0_19_205 VGND VGND VPWR VPWR sky130_fd_sc_hd__fill_1
XFILLER_0_30_403 VPWR VGND VPWR VGND sky130_ef_sc_hd__decap_12
XTAP_TAPCELL_ROW_30_394 VGND VPWR sky130_fd_sc_hd__tapvpwrvgnd_1
XFILLER_0_27_260 VPWR VGND VPWR VGND sky130_ef_sc_hd__decap_12
XFILLER_0_6_121 VPWR VGND VPWR VGND sky130_ef_sc_hd__decap_12
XFILLER_0_6_165 VPWR VGND VPWR VGND sky130_ef_sc_hd__decap_12
XFILLER_0_15_411 VPWR VGND VPWR VGND sky130_ef_sc_hd__decap_12
XTAP_TAPCELL_ROW_22_328 VGND VPWR sky130_fd_sc_hd__tapvpwrvgnd_1
X_2629_ imem.address\[6\] _1321_ VGND VGND VPWR VPWR _1356_ sky130_fd_sc_hd__nor2_1
XFILLER_0_69_116 VGND VGND VPWR VPWR sky130_fd_sc_hd__fill_2
XTAP_TAPCELL_ROW_38_461 VGND VPWR sky130_fd_sc_hd__tapvpwrvgnd_1
XFILLER_0_25_219 VGND VGND VPWR VPWR sky130_fd_sc_hd__decap_4
X_2980_ clknet_leaf_5_clk _0210_ _0046_ VGND VGND VPWR VPWR imem.address\[21\] sky130_fd_sc_hd__dfrtp_1
XFILLER_0_17_57 VPWR VGND VPWR VGND sky130_ef_sc_hd__decap_12
X_1793_ _0608_ VGND VGND VPWR VPWR _0609_ sky130_fd_sc_hd__clkbuf_4
X_1862_ _0667_ _0668_ VGND VGND VPWR VPWR _0678_ sky130_fd_sc_hd__and2_1
X_1931_ _0627_ _0746_ VGND VGND VPWR VPWR _0747_ sky130_fd_sc_hd__xor2_1
XFILLER_0_3_113 VPWR VGND VPWR VGND sky130_ef_sc_hd__decap_12
X_2414_ _0650_ _1210_ VGND VGND VPWR VPWR _1212_ sky130_fd_sc_hd__nand2_1
X_2276_ _1072_ _1087_ _0866_ VGND VGND VPWR VPWR _1088_ sky130_fd_sc_hd__mux2_1
X_2345_ _1151_ VGND VGND VPWR VPWR _0275_ sky130_fd_sc_hd__clkbuf_1
XFILLER_0_7_441 VGND VGND VPWR VPWR sky130_fd_sc_hd__decap_6
XFILLER_0_15_296 VPWR VGND VPWR VGND sky130_ef_sc_hd__decap_12
XFILLER_0_30_266 VPWR VGND VPWR VGND sky130_ef_sc_hd__decap_12
XFILLER_0_65_163 VGND VGND VPWR VPWR sky130_fd_sc_hd__decap_4
X_2061_ _0876_ VGND VGND VPWR VPWR _0877_ sky130_fd_sc_hd__buf_2
XTAP_TAPCELL_ROW_49_545 VGND VPWR sky130_fd_sc_hd__tapvpwrvgnd_1
X_2130_ _0796_ _0629_ _0877_ VGND VGND VPWR VPWR _0945_ sky130_fd_sc_hd__mux2_1
XFILLER_0_28_78 VGND VGND VPWR VPWR sky130_fd_sc_hd__fill_1
X_2963_ clknet_leaf_6_clk _0193_ _0029_ VGND VGND VPWR VPWR imem.address\[4\] sky130_fd_sc_hd__dfrtp_1
XFILLER_0_56_152 VGND VGND VPWR VPWR sky130_fd_sc_hd__fill_1
XFILLER_0_56_130 VGND VGND VPWR VPWR sky130_fd_sc_hd__decap_3
X_1914_ _0729_ _0706_ _0651_ VGND VGND VPWR VPWR _0730_ sky130_fd_sc_hd__nor3_4
XFILLER_0_44_66 VGND VGND VPWR VPWR sky130_fd_sc_hd__fill_2
XTAP_TAPCELL_ROW_32_412 VGND VPWR sky130_fd_sc_hd__tapvpwrvgnd_1
X_1845_ _0657_ _0658_ _0659_ _0660_ VGND VGND VPWR VPWR _0661_ sky130_fd_sc_hd__a31o_1
XFILLER_0_4_433 VPWR VGND VPWR VGND sky130_ef_sc_hd__decap_12
XFILLER_0_8_77 VGND VGND VPWR VPWR sky130_fd_sc_hd__decap_6
X_2894_ _1466_ VGND VGND VPWR VPWR _0141_ sky130_fd_sc_hd__inv_2
X_1776_ _0589_ _0591_ VGND VGND VPWR VPWR _0592_ sky130_fd_sc_hd__or2_1
XFILLER_0_40_3 VPWR VGND VPWR VGND sky130_ef_sc_hd__decap_12
X_2328_ _0778_ _1134_ VGND VGND VPWR VPWR _1136_ sky130_fd_sc_hd__or2_1
XFILLER_0_67_417 VPWR VGND VPWR VGND sky130_ef_sc_hd__decap_12
X_2259_ _1007_ _1070_ _0891_ VGND VGND VPWR VPWR _1071_ sky130_fd_sc_hd__mux2_1
XFILLER_0_62_111 VGND VGND VPWR VPWR sky130_fd_sc_hd__fill_2
XFILLER_0_7_293 VPWR VGND VPWR VGND sky130_ef_sc_hd__decap_12
XFILLER_0_43_391 VGND VGND VPWR VPWR sky130_fd_sc_hd__fill_1
XTAP_TAPCELL_ROW_46_526 VGND VPWR sky130_fd_sc_hd__tapvpwrvgnd_1
XFILLER_0_38_141 VGND VGND VPWR VPWR sky130_fd_sc_hd__fill_2
XFILLER_0_26_303 VGND VGND VPWR VPWR sky130_fd_sc_hd__decap_4
XTAP_TAPCELL_ROW_3_181 VGND VPWR sky130_fd_sc_hd__tapvpwrvgnd_1
X_1630_ reg_file.registers\[10\]\[8\] _0449_ VGND VGND VPWR VPWR _0455_ sky130_fd_sc_hd__and2_1
XFILLER_0_26_325 VGND VGND VPWR VPWR sky130_fd_sc_hd__fill_1
X_1492_ imem.address\[2\] VGND VGND VPWR VPWR _0372_ sky130_fd_sc_hd__buf_2
X_1561_ _0418_ VGND VGND VPWR VPWR _0326_ sky130_fd_sc_hd__clkbuf_1
X_3162_ clknet_leaf_12_clk _0365_ VGND VGND VPWR VPWR net9 sky130_fd_sc_hd__dfxtp_1
XFILLER_0_55_76 VPWR VGND VPWR VGND sky130_ef_sc_hd__decap_12
X_2113_ reg_file.registers\[5\]\[4\] _0468_ VGND VGND VPWR VPWR _0929_ sky130_fd_sc_hd__and2_1
X_2044_ _0858_ _0859_ VGND VGND VPWR VPWR _0860_ sky130_fd_sc_hd__nor2_1
X_3093_ clknet_leaf_19_clk _0316_ _0152_ VGND VGND VPWR VPWR reg_file.registers\[10\]\[31\]
+ sky130_fd_sc_hd__dfrtp_1
XFILLER_0_71_97 VPWR VGND VPWR VGND sky130_ef_sc_hd__decap_12
XFILLER_0_71_53 VGND VGND VPWR VPWR sky130_fd_sc_hd__decap_3
X_2877_ _1464_ VGND VGND VPWR VPWR _0126_ sky130_fd_sc_hd__inv_2
X_2946_ _1474_ VGND VGND VPWR VPWR _0185_ sky130_fd_sc_hd__inv_2
XTAP_TAPCELL_ROW_17_294 VGND VPWR sky130_fd_sc_hd__tapvpwrvgnd_1
X_1828_ _0640_ _0643_ VGND VGND VPWR VPWR _0644_ sky130_fd_sc_hd__nor2_1
X_1759_ _0568_ _0565_ _0572_ _0574_ VGND VGND VPWR VPWR _0575_ sky130_fd_sc_hd__or4bb_4
XTAP_TAPCELL_ROW_9_229 VGND VPWR sky130_fd_sc_hd__tapvpwrvgnd_1
XFILLER_0_67_225 VPWR VGND VPWR VGND sky130_ef_sc_hd__decap_12
XFILLER_0_67_203 VPWR VGND VPWR VGND sky130_ef_sc_hd__decap_12
XTAP_TAPCELL_ROW_0_151 VGND VPWR sky130_fd_sc_hd__tapvpwrvgnd_1
XTAP_TAPCELL_ROW_51_562 VGND VPWR sky130_fd_sc_hd__tapvpwrvgnd_1
XFILLER_0_35_144 VGND VGND VPWR VPWR sky130_fd_sc_hd__decap_4
XFILLER_0_35_122 VGND VGND VPWR VPWR sky130_fd_sc_hd__fill_1
XFILLER_0_58_225 VPWR VGND VPWR VGND sky130_ef_sc_hd__decap_12
XFILLER_0_25_57 VPWR VGND VPWR VGND sky130_ef_sc_hd__decap_12
XFILLER_0_66_280 VGND VGND VPWR VPWR sky130_fd_sc_hd__fill_2
X_2800_ _1454_ VGND VGND VPWR VPWR _0059_ sky130_fd_sc_hd__inv_2
XFILLER_0_26_144 VGND VGND VPWR VPWR sky130_fd_sc_hd__fill_1
X_2731_ display.counter\[7\] _1428_ display.counter\[8\] VGND VGND VPWR VPWR _1431_
+ sky130_fd_sc_hd__a21oi_1
XTAP_TAPCELL_ROW_14_264 VGND VPWR sky130_fd_sc_hd__tapvpwrvgnd_1
X_2593_ imem.address\[28\] _1336_ VGND VGND VPWR VPWR _0217_ sky130_fd_sc_hd__xor2_1
XFILLER_0_41_169 VGND VGND VPWR VPWR sky130_fd_sc_hd__fill_2
XFILLER_0_41_136 VGND VGND VPWR VPWR sky130_fd_sc_hd__decap_4
X_1613_ reg_file.registers\[10\]\[16\] _0438_ VGND VGND VPWR VPWR _0446_ sky130_fd_sc_hd__and2_1
X_1544_ _0409_ VGND VGND VPWR VPWR _0334_ sky130_fd_sc_hd__clkbuf_1
X_2662_ _1176_ _1363_ _1101_ _1364_ _1379_ VGND VGND VPWR VPWR _1380_ sky130_fd_sc_hd__a221o_1
XFILLER_0_66_53 VGND VGND VPWR VPWR sky130_fd_sc_hd__decap_6
X_3145_ clknet_leaf_14_clk _0008_ VGND VGND VPWR VPWR display.counter\[10\] sky130_fd_sc_hd__dfxtp_1
XTAP_TAPCELL_ROW_65_676 VGND VPWR sky130_fd_sc_hd__tapvpwrvgnd_1
XFILLER_0_64_217 VGND VGND VPWR VPWR sky130_fd_sc_hd__decap_6
XFILLER_0_49_247 VGND VGND VPWR VPWR sky130_fd_sc_hd__decap_8
XFILLER_0_49_236 VGND VGND VPWR VPWR sky130_fd_sc_hd__decap_8
XFILLER_0_49_225 VGND VGND VPWR VPWR sky130_fd_sc_hd__fill_1
XFILLER_0_37_409 VGND VGND VPWR VPWR sky130_fd_sc_hd__fill_1
X_3076_ clknet_leaf_1_clk _0299_ _0135_ VGND VGND VPWR VPWR reg_file.registers\[10\]\[14\]
+ sky130_fd_sc_hd__dfrtp_1
X_2027_ reg_file.registers\[10\]\[26\] _0775_ _0776_ reg_file.registers\[11\]\[26\]
+ VGND VGND VPWR VPWR _0843_ sky130_fd_sc_hd__a22o_1
XFILLER_0_60_445 VGND VGND VPWR VPWR sky130_fd_sc_hd__decap_6
X_2929_ _1470_ VGND VGND VPWR VPWR _0172_ sky130_fd_sc_hd__inv_2
XFILLER_0_9_355 VGND VGND VPWR VPWR sky130_fd_sc_hd__fill_1
XFILLER_0_17_177 VGND VGND VPWR VPWR sky130_fd_sc_hd__fill_2
XFILLER_0_70_209 VPWR VGND VPWR VGND sky130_ef_sc_hd__decap_12
XTAP_TAPCELL_ROW_28_378 VGND VPWR sky130_fd_sc_hd__tapvpwrvgnd_1
XFILLER_0_11_15 VPWR VGND VPWR VGND sky130_ef_sc_hd__decap_12
XFILLER_0_23_169 VGND VGND VPWR VPWR sky130_fd_sc_hd__fill_2
XTAP_TAPCELL_ROW_11_245 VGND VPWR sky130_fd_sc_hd__tapvpwrvgnd_1
XFILLER_0_46_206 VPWR VGND VPWR VGND sky130_ef_sc_hd__decap_12
XFILLER_0_54_272 VPWR VGND VPWR VGND sky130_ef_sc_hd__decap_12
XFILLER_0_42_445 VGND VGND VPWR VPWR sky130_fd_sc_hd__decap_6
XFILLER_0_42_401 VGND VGND VPWR VPWR sky130_fd_sc_hd__fill_1
X_2714_ _1360_ VGND VGND VPWR VPWR _0365_ sky130_fd_sc_hd__inv_2
XFILLER_0_14_114 VGND VGND VPWR VPWR sky130_fd_sc_hd__decap_3
X_2576_ imem.address\[15\] _1327_ VGND VGND VPWR VPWR _1328_ sky130_fd_sc_hd__and2_1
X_2645_ display.digit_sel\[1\] display.digit_sel\[0\] VGND VGND VPWR VPWR _1365_ sky130_fd_sc_hd__nand2_1
X_1527_ _0400_ VGND VGND VPWR VPWR _0342_ sky130_fd_sc_hd__clkbuf_1
XFILLER_0_14_169 VPWR VGND VPWR VGND sky130_ef_sc_hd__decap_12
X_3128_ clknet_leaf_2_clk _0351_ _0187_ VGND VGND VPWR VPWR reg_file.registers\[2\]\[3\]
+ sky130_fd_sc_hd__dfrtp_1
XTAP_TAPCELL_ROW_25_359 VGND VPWR sky130_fd_sc_hd__tapvpwrvgnd_1
X_3059_ clknet_leaf_15_clk _0282_ _0118_ VGND VGND VPWR VPWR reg_file.registers\[11\]\[29\]
+ sky130_fd_sc_hd__dfrtp_1
XFILLER_0_60_297 VGND VGND VPWR VPWR sky130_fd_sc_hd__decap_8
XFILLER_0_60_253 VGND VGND VPWR VPWR sky130_fd_sc_hd__fill_1
XFILLER_0_60_242 VGND VGND VPWR VPWR sky130_fd_sc_hd__fill_1
XFILLER_0_52_209 VPWR VGND VPWR VGND sky130_ef_sc_hd__decap_12
XFILLER_0_5_391 VGND VGND VPWR VPWR sky130_fd_sc_hd__fill_1
XFILLER_0_24_412 VGND VGND VPWR VPWR sky130_fd_sc_hd__decap_8
XFILLER_0_3_317 VPWR VGND VPWR VGND sky130_ef_sc_hd__decap_12
X_2430_ _1225_ _0736_ _0715_ VGND VGND VPWR VPWR _1226_ sky130_fd_sc_hd__a21oi_1
X_2361_ _1165_ VGND VGND VPWR VPWR _0273_ sky130_fd_sc_hd__clkbuf_1
X_2292_ _1102_ VGND VGND VPWR VPWR _0279_ sky130_fd_sc_hd__clkbuf_1
XTAP_TAPCELL_ROW_22_329 VGND VPWR sky130_fd_sc_hd__tapvpwrvgnd_1
XFILLER_0_70_3 VPWR VGND VPWR VGND sky130_ef_sc_hd__decap_12
XFILLER_0_42_253 VGND VGND VPWR VPWR sky130_fd_sc_hd__decap_8
XFILLER_0_30_415 VGND VGND VPWR VPWR sky130_fd_sc_hd__decap_4
XTAP_TAPCELL_ROW_30_395 VGND VPWR sky130_fd_sc_hd__tapvpwrvgnd_1
XFILLER_0_27_272 VGND VGND VPWR VPWR sky130_fd_sc_hd__decap_8
XFILLER_0_6_133 VGND VGND VPWR VPWR sky130_fd_sc_hd__decap_6
XFILLER_0_6_177 VPWR VGND VPWR VGND sky130_ef_sc_hd__decap_12
XFILLER_0_15_401 VGND VGND VPWR VPWR sky130_fd_sc_hd__decap_3
XFILLER_0_15_423 VGND VGND VPWR VPWR sky130_fd_sc_hd__decap_8
X_2628_ imem.address\[7\] _1322_ VGND VGND VPWR VPWR _0196_ sky130_fd_sc_hd__xor2_1
X_2559_ reg_file.registers\[15\]\[4\] _1285_ VGND VGND VPWR VPWR _1316_ sky130_fd_sc_hd__and2_1
XFILLER_0_69_139 VPWR VGND VPWR VGND sky130_ef_sc_hd__decap_12
XTAP_TAPCELL_ROW_38_462 VGND VPWR sky130_fd_sc_hd__tapvpwrvgnd_1
XFILLER_0_0_309 VPWR VGND VPWR VGND sky130_ef_sc_hd__decap_12
XFILLER_0_17_69 VPWR VGND VPWR VGND sky130_ef_sc_hd__decap_12
X_1930_ _0596_ _0554_ VGND VGND VPWR VPWR _0746_ sky130_fd_sc_hd__and2_1
XFILLER_0_33_35 VGND VGND VPWR VPWR sky130_fd_sc_hd__fill_1
XFILLER_0_71_337 VPWR VGND VPWR VGND sky130_ef_sc_hd__decap_12
X_1861_ _0672_ _0675_ _0676_ VGND VGND VPWR VPWR _0677_ sky130_fd_sc_hd__o21ai_1
X_1792_ _0607_ VGND VGND VPWR VPWR _0608_ sky130_fd_sc_hd__clkbuf_4
XFILLER_0_24_275 VGND VGND VPWR VPWR sky130_fd_sc_hd__fill_1
XFILLER_0_24_253 VGND VGND VPWR VPWR sky130_fd_sc_hd__fill_2
XFILLER_0_3_169 VPWR VGND VPWR VGND sky130_ef_sc_hd__decap_12
XFILLER_0_3_125 VPWR VGND VPWR VGND sky130_ef_sc_hd__decap_12
XFILLER_0_12_404 VGND VGND VPWR VPWR sky130_fd_sc_hd__decap_8
XFILLER_0_12_426 VGND VGND VPWR VPWR sky130_fd_sc_hd__fill_2
X_2413_ _0650_ _1210_ VGND VGND VPWR VPWR _1211_ sky130_fd_sc_hd__or2_1
Xclkbuf_1_0__f_clk clknet_0_clk VGND VGND VPWR VPWR clknet_1_0__leaf_clk sky130_fd_sc_hd__clkbuf_16
X_2344_ reg_file.registers\[11\]\[22\] _1150_ _0933_ VGND VGND VPWR VPWR _1151_ sky130_fd_sc_hd__mux2_1
X_2275_ _1079_ _1086_ _0893_ VGND VGND VPWR VPWR _1087_ sky130_fd_sc_hd__mux2_1
XTAP_TAPCELL_ROW_35_432 VGND VPWR sky130_fd_sc_hd__tapvpwrvgnd_1
XFILLER_0_23_90 VPWR VGND VPWR VGND sky130_ef_sc_hd__decap_12
XFILLER_0_30_278 VPWR VGND VPWR VGND sky130_ef_sc_hd__decap_12
XFILLER_0_21_223 VGND VGND VPWR VPWR sky130_fd_sc_hd__fill_1
X_2060_ _0506_ _0508_ VGND VGND VPWR VPWR _0876_ sky130_fd_sc_hd__and2_1
XTAP_TAPCELL_ROW_49_546 VGND VPWR sky130_fd_sc_hd__tapvpwrvgnd_1
X_2962_ clknet_leaf_6_clk _0192_ _0028_ VGND VGND VPWR VPWR imem.address\[3\] sky130_fd_sc_hd__dfrtp_2
X_1913_ _0719_ _0721_ _0728_ VGND VGND VPWR VPWR _0729_ sky130_fd_sc_hd__or3_4
XTAP_TAPCELL_ROW_32_413 VGND VPWR sky130_fd_sc_hd__tapvpwrvgnd_1
X_2893_ _1462_ VGND VGND VPWR VPWR _1466_ sky130_fd_sc_hd__buf_4
XFILLER_0_71_167 VGND VGND VPWR VPWR sky130_fd_sc_hd__fill_1
XFILLER_0_69_97 VPWR VGND VPWR VGND sky130_ef_sc_hd__decap_12
X_1844_ _0520_ VGND VGND VPWR VPWR _0660_ sky130_fd_sc_hd__inv_2
XFILLER_0_4_445 VGND VGND VPWR VPWR sky130_fd_sc_hd__decap_6
XFILLER_0_4_401 VPWR VGND VPWR VGND sky130_ef_sc_hd__decap_12
X_1775_ _0566_ _0590_ _0529_ VGND VGND VPWR VPWR _0591_ sky130_fd_sc_hd__a21o_1
X_2258_ _0686_ _1069_ _0878_ VGND VGND VPWR VPWR _1070_ sky130_fd_sc_hd__mux2_1
XFILLER_0_33_3 VPWR VGND VPWR VGND sky130_ef_sc_hd__decap_12
X_2327_ _0778_ _1134_ VGND VGND VPWR VPWR _1135_ sky130_fd_sc_hd__nand2_1
XFILLER_0_67_429 VPWR VGND VPWR VGND sky130_ef_sc_hd__decap_12
X_2189_ _0702_ _0958_ _0878_ VGND VGND VPWR VPWR _1003_ sky130_fd_sc_hd__mux2_1
XFILLER_0_62_145 VGND VGND VPWR VPWR sky130_fd_sc_hd__fill_1
XFILLER_0_50_307 VGND VGND VPWR VPWR sky130_fd_sc_hd__fill_1
XFILLER_0_35_337 VPWR VGND VPWR VGND sky130_ef_sc_hd__decap_12
XFILLER_0_7_261 VPWR VGND VPWR VGND sky130_ef_sc_hd__decap_12
XTAP_TAPCELL_ROW_46_527 VGND VPWR sky130_fd_sc_hd__tapvpwrvgnd_1
XTAP_TAPCELL_ROW_3_182 VGND VPWR sky130_fd_sc_hd__tapvpwrvgnd_1
XFILLER_0_38_197 VGND VGND VPWR VPWR sky130_fd_sc_hd__decap_6
XFILLER_0_14_15 VPWR VGND VPWR VGND sky130_ef_sc_hd__decap_12
X_1560_ reg_file.registers\[5\]\[9\] _0414_ VGND VGND VPWR VPWR _0418_ sky130_fd_sc_hd__and2_1
XFILLER_0_55_44 VGND VGND VPWR VPWR sky130_fd_sc_hd__fill_2
X_1491_ _0371_ VGND VGND VPWR VPWR _0349_ sky130_fd_sc_hd__clkbuf_1
X_2112_ _0919_ _0927_ _0910_ VGND VGND VPWR VPWR _0928_ sky130_fd_sc_hd__mux2_1
X_3161_ clknet_leaf_11_clk _0364_ VGND VGND VPWR VPWR net8 sky130_fd_sc_hd__dfxtp_1
XFILLER_0_39_78 VPWR VGND VPWR VGND sky130_ef_sc_hd__decap_12
XFILLER_0_55_88 VPWR VGND VPWR VGND sky130_ef_sc_hd__decap_12
XFILLER_0_55_55 VGND VGND VPWR VPWR sky130_fd_sc_hd__fill_1
X_2043_ reg_file.registers\[15\]\[31\] _0569_ _0522_ reg_file.registers\[2\]\[31\]
+ VGND VGND VPWR VPWR _0859_ sky130_fd_sc_hd__a22o_1
XFILLER_0_29_120 VGND VGND VPWR VPWR sky130_fd_sc_hd__decap_8
X_3092_ clknet_leaf_19_clk _0315_ _0151_ VGND VGND VPWR VPWR reg_file.registers\[10\]\[30\]
+ sky130_fd_sc_hd__dfrtp_2
X_2876_ _1464_ VGND VGND VPWR VPWR _0125_ sky130_fd_sc_hd__inv_2
X_1827_ reg_file.registers\[10\]\[12\] _0641_ _0642_ reg_file.registers\[11\]\[12\]
+ VGND VGND VPWR VPWR _0643_ sky130_fd_sc_hd__a22o_1
XFILLER_0_44_189 VGND VGND VPWR VPWR sky130_fd_sc_hd__decap_6
XFILLER_0_44_134 VGND VGND VPWR VPWR sky130_fd_sc_hd__decap_6
X_2945_ _1472_ VGND VGND VPWR VPWR _1474_ sky130_fd_sc_hd__dlymetal6s2s_1
XFILLER_0_32_318 VGND VGND VPWR VPWR sky130_fd_sc_hd__decap_6
XFILLER_0_32_307 VGND VGND VPWR VPWR sky130_fd_sc_hd__fill_1
XFILLER_0_17_337 VGND VGND VPWR VPWR sky130_fd_sc_hd__fill_1
XTAP_TAPCELL_ROW_17_295 VGND VPWR sky130_fd_sc_hd__tapvpwrvgnd_1
X_1689_ reg_file.registers\[15\]\[0\] _0484_ _0494_ reg_file.registers\[2\]\[0\] _0504_
+ VGND VGND VPWR VPWR _0505_ sky130_fd_sc_hd__a221oi_2
XFILLER_0_40_384 VGND VGND VPWR VPWR sky130_fd_sc_hd__decap_4
X_1758_ _0566_ _0573_ _0556_ VGND VGND VPWR VPWR _0574_ sky130_fd_sc_hd__a21oi_2
XFILLER_0_4_253 VPWR VGND VPWR VGND sky130_ef_sc_hd__decap_12
XFILLER_0_20_91 VGND VGND VPWR VPWR sky130_fd_sc_hd__fill_1
XTAP_TAPCELL_ROW_68_696 VGND VPWR sky130_fd_sc_hd__tapvpwrvgnd_1
XFILLER_0_67_237 VPWR VGND VPWR VGND sky130_ef_sc_hd__decap_12
XFILLER_0_67_215 VGND VGND VPWR VPWR sky130_fd_sc_hd__decap_8
XTAP_TAPCELL_ROW_51_563 VGND VPWR sky130_fd_sc_hd__tapvpwrvgnd_1
XTAP_TAPCELL_ROW_0_152 VGND VPWR sky130_fd_sc_hd__tapvpwrvgnd_1
XFILLER_0_50_126 VGND VGND VPWR VPWR sky130_fd_sc_hd__fill_2
XTAP_TAPCELL_ROW_59_630 VGND VPWR sky130_fd_sc_hd__tapvpwrvgnd_1
XFILLER_0_58_237 VGND VGND VPWR VPWR sky130_fd_sc_hd__decap_4
XFILLER_0_25_69 VPWR VGND VPWR VGND sky130_ef_sc_hd__decap_12
XFILLER_0_54_421 VPWR VGND VPWR VGND sky130_ef_sc_hd__decap_12
XFILLER_0_41_104 VGND VGND VPWR VPWR sky130_fd_sc_hd__fill_2
X_2661_ _1208_ _1366_ _1378_ _1371_ VGND VGND VPWR VPWR _1379_ sky130_fd_sc_hd__a211o_1
X_2730_ display.counter\[7\] display.counter\[8\] _1428_ VGND VGND VPWR VPWR _1430_
+ sky130_fd_sc_hd__and3_1
XTAP_TAPCELL_ROW_14_265 VGND VPWR sky130_fd_sc_hd__tapvpwrvgnd_1
XFILLER_0_14_307 VGND VGND VPWR VPWR sky130_fd_sc_hd__fill_1
X_2592_ _1337_ _1341_ VGND VGND VPWR VPWR _0218_ sky130_fd_sc_hd__nor2_1
XFILLER_0_41_148 VGND VGND VPWR VPWR sky130_fd_sc_hd__fill_1
X_1543_ reg_file.registers\[5\]\[17\] _0403_ VGND VGND VPWR VPWR _0409_ sky130_fd_sc_hd__and2_1
X_1612_ _0445_ VGND VGND VPWR VPWR _0302_ sky130_fd_sc_hd__clkbuf_1
XFILLER_0_22_351 VPWR VGND VPWR VGND sky130_ef_sc_hd__decap_12
XFILLER_0_1_223 VGND VGND VPWR VPWR sky130_fd_sc_hd__fill_1
XFILLER_0_66_76 VGND VGND VPWR VPWR sky130_fd_sc_hd__decap_8
X_3075_ clknet_leaf_6_clk _0298_ _0134_ VGND VGND VPWR VPWR reg_file.registers\[10\]\[13\]
+ sky130_fd_sc_hd__dfrtp_1
XFILLER_0_5_57 VPWR VGND VPWR VGND sky130_ef_sc_hd__decap_12
X_3144_ clknet_leaf_14_clk _0026_ VGND VGND VPWR VPWR display.counter\[9\] sky130_fd_sc_hd__dfxtp_1
XTAP_TAPCELL_ROW_65_677 VGND VPWR sky130_fd_sc_hd__tapvpwrvgnd_1
XFILLER_0_57_281 VPWR VGND VPWR VGND sky130_ef_sc_hd__decap_12
XFILLER_0_9_301 VPWR VGND VPWR VGND sky130_ef_sc_hd__decap_12
X_2026_ _0589_ _0825_ _0830_ VGND VGND VPWR VPWR _0842_ sky130_fd_sc_hd__a21o_1
X_2859_ _1449_ VGND VGND VPWR VPWR _1462_ sky130_fd_sc_hd__clkbuf_2
XFILLER_0_32_126 VGND VGND VPWR VPWR sky130_fd_sc_hd__decap_4
X_2928_ _1470_ VGND VGND VPWR VPWR _0171_ sky130_fd_sc_hd__inv_2
XPHY_EDGE_ROW_28_Left_100 VGND VGND VPWR VPWR sky130_fd_sc_hd__decap_3
XFILLER_0_17_156 VGND VGND VPWR VPWR sky130_fd_sc_hd__decap_3
XTAP_TAPCELL_ROW_56_600 VGND VPWR sky130_fd_sc_hd__tapvpwrvgnd_1
XTAP_TAPCELL_ROW_28_379 VGND VPWR sky130_fd_sc_hd__tapvpwrvgnd_1
XFILLER_0_36_421 VGND VGND VPWR VPWR sky130_fd_sc_hd__fill_1
XFILLER_0_11_27 VPWR VGND VPWR VGND sky130_ef_sc_hd__decap_12
XTAP_TAPCELL_ROW_11_246 VGND VPWR sky130_fd_sc_hd__tapvpwrvgnd_1
XFILLER_0_31_181 VGND VGND VPWR VPWR sky130_fd_sc_hd__fill_2
XFILLER_0_36_79 VGND VGND VPWR VPWR sky130_fd_sc_hd__fill_2
XFILLER_0_52_56 VGND VGND VPWR VPWR sky130_fd_sc_hd__decap_8
XFILLER_0_46_218 VGND VGND VPWR VPWR sky130_fd_sc_hd__decap_4
XFILLER_0_54_284 VGND VGND VPWR VPWR sky130_fd_sc_hd__decap_4
XFILLER_0_54_251 VGND VGND VPWR VPWR sky130_fd_sc_hd__fill_1
X_2713_ _1361_ VGND VGND VPWR VPWR _0363_ sky130_fd_sc_hd__inv_2
X_2644_ net38 _0364_ VGND VGND VPWR VPWR _1364_ sky130_fd_sc_hd__nor2_1
X_2575_ imem.address\[14\] imem.address\[13\] _1326_ VGND VGND VPWR VPWR _1327_ sky130_fd_sc_hd__and3_1
X_1526_ reg_file.registers\[5\]\[25\] _0393_ VGND VGND VPWR VPWR _0400_ sky130_fd_sc_hd__and2_1
X_3127_ clknet_leaf_2_clk _0350_ _0186_ VGND VGND VPWR VPWR reg_file.registers\[2\]\[2\]
+ sky130_fd_sc_hd__dfrtp_1
X_3058_ clknet_leaf_15_clk _0281_ _0117_ VGND VGND VPWR VPWR reg_file.registers\[11\]\[28\]
+ sky130_fd_sc_hd__dfrtp_1
XFILLER_0_37_229 VGND VGND VPWR VPWR sky130_fd_sc_hd__fill_1
X_2009_ _0583_ _0586_ _0588_ _0529_ VGND VGND VPWR VPWR _0825_ sky130_fd_sc_hd__o22ai_2
XFILLER_0_18_432 VGND VGND VPWR VPWR sky130_fd_sc_hd__fill_1
XFILLER_0_13_181 VPWR VGND VPWR VGND sky130_ef_sc_hd__decap_12
XFILLER_0_68_365 VPWR VGND VPWR VGND sky130_ef_sc_hd__decap_12
XFILLER_0_68_321 VPWR VGND VPWR VGND sky130_ef_sc_hd__decap_12
XFILLER_0_22_15 VPWR VGND VPWR VGND sky130_ef_sc_hd__decap_12
XFILLER_0_3_329 VGND VGND VPWR VPWR sky130_fd_sc_hd__decap_6
X_2360_ reg_file.registers\[11\]\[20\] _1164_ _1158_ VGND VGND VPWR VPWR _1165_ sky130_fd_sc_hd__mux2_1
X_2291_ reg_file.registers\[11\]\[26\] _1101_ _0933_ VGND VGND VPWR VPWR _1102_ sky130_fd_sc_hd__mux2_1
XFILLER_0_63_55 VGND VGND VPWR VPWR sky130_fd_sc_hd__fill_1
XFILLER_0_59_310 VGND VGND VPWR VPWR sky130_fd_sc_hd__decap_8
XPHY_EDGE_ROW_10_Right_10 VGND VGND VPWR VPWR sky130_fd_sc_hd__decap_3
X_2627_ _1323_ _1355_ VGND VGND VPWR VPWR _0197_ sky130_fd_sc_hd__nor2_1
XFILLER_0_30_438 VGND VGND VPWR VPWR sky130_fd_sc_hd__fill_2
XTAP_TAPCELL_ROW_30_396 VGND VPWR sky130_fd_sc_hd__tapvpwrvgnd_1
XFILLER_0_6_189 VGND VGND VPWR VPWR sky130_fd_sc_hd__decap_6
X_1509_ _0378_ _0379_ _0388_ VGND VGND VPWR VPWR _0389_ sky130_fd_sc_hd__o21ai_4
X_2558_ _1315_ VGND VGND VPWR VPWR _0226_ sky130_fd_sc_hd__clkbuf_1
X_2489_ _1273_ _1006_ VGND VGND VPWR VPWR _1275_ sky130_fd_sc_hd__nor2_1
XFILLER_0_10_195 VGND VGND VPWR VPWR sky130_fd_sc_hd__fill_1
XTAP_TAPCELL_ROW_38_463 VGND VPWR sky130_fd_sc_hd__tapvpwrvgnd_1
XFILLER_0_33_210 VGND VGND VPWR VPWR sky130_fd_sc_hd__fill_2
XFILLER_0_21_449 VGND VGND VPWR VPWR sky130_fd_sc_hd__fill_2
XFILLER_0_17_15 VPWR VGND VPWR VGND sky130_ef_sc_hd__decap_12
XFILLER_0_71_305 VGND VGND VPWR VPWR sky130_fd_sc_hd__decap_3
X_1860_ _0513_ _0670_ _0671_ VGND VGND VPWR VPWR _0676_ sky130_fd_sc_hd__a21o_1
XFILLER_0_71_349 VPWR VGND VPWR VGND sky130_ef_sc_hd__decap_12
X_1791_ _0596_ _0606_ VGND VGND VPWR VPWR _0607_ sky130_fd_sc_hd__nand2_1
XPHY_EDGE_ROW_26_Left_98 VGND VGND VPWR VPWR sky130_fd_sc_hd__decap_3
XFILLER_0_24_287 VPWR VGND VPWR VGND sky130_ef_sc_hd__decap_12
XFILLER_0_3_137 VPWR VGND VPWR VGND sky130_ef_sc_hd__decap_12
XFILLER_0_58_44 VPWR VGND VPWR VGND sky130_ef_sc_hd__decap_12
X_2274_ _1082_ _1085_ _0891_ VGND VGND VPWR VPWR _1086_ sky130_fd_sc_hd__mux2_1
X_2412_ _0646_ _1190_ VGND VGND VPWR VPWR _1210_ sky130_fd_sc_hd__or2_1
X_2343_ _0978_ _1028_ _1148_ _1149_ VGND VGND VPWR VPWR _1150_ sky130_fd_sc_hd__a211o_1
XFILLER_0_59_140 VPWR VGND VPWR VGND sky130_ef_sc_hd__decap_12
XTAP_TAPCELL_ROW_35_433 VGND VPWR sky130_fd_sc_hd__tapvpwrvgnd_1
Xclkbuf_leaf_17_clk clknet_1_1__leaf_clk VGND VGND VPWR VPWR clknet_leaf_17_clk sky130_fd_sc_hd__clkbuf_8
X_1989_ _0789_ _0790_ VGND VGND VPWR VPWR _0805_ sky130_fd_sc_hd__or2_1
XFILLER_0_61_393 VPWR VGND VPWR VGND sky130_ef_sc_hd__decap_12
XFILLER_0_28_58 VPWR VGND VPWR VGND sky130_ef_sc_hd__decap_12
XTAP_TAPCELL_ROW_49_547 VGND VPWR sky130_fd_sc_hd__tapvpwrvgnd_1
XFILLER_0_44_46 VPWR VGND VPWR VGND sky130_ef_sc_hd__decap_12
XFILLER_0_71_113 VPWR VGND VPWR VGND sky130_ef_sc_hd__decap_12
X_2961_ clknet_leaf_6_clk _0191_ _0027_ VGND VGND VPWR VPWR imem.address\[2\] sky130_fd_sc_hd__dfrtp_1
XFILLER_0_56_176 VGND VGND VPWR VPWR sky130_fd_sc_hd__decap_3
X_1912_ _0725_ _0727_ VGND VGND VPWR VPWR _0728_ sky130_fd_sc_hd__nand2_1
X_1843_ _0519_ _0525_ VGND VGND VPWR VPWR _0659_ sky130_fd_sc_hd__nor2_1
XTAP_TAPCELL_ROW_32_414 VGND VPWR sky130_fd_sc_hd__tapvpwrvgnd_1
XFILLER_0_29_335 VGND VGND VPWR VPWR sky130_fd_sc_hd__fill_1
X_2892_ _1465_ VGND VGND VPWR VPWR _0140_ sky130_fd_sc_hd__inv_2
XFILLER_0_4_413 VGND VGND VPWR VPWR sky130_fd_sc_hd__decap_6
Xclkbuf_leaf_6_clk clknet_1_0__leaf_clk VGND VGND VPWR VPWR clknet_leaf_6_clk sky130_fd_sc_hd__clkbuf_8
X_1774_ reg_file.registers\[15\]\[28\] _0569_ _0570_ reg_file.registers\[5\]\[28\]
+ VGND VGND VPWR VPWR _0590_ sky130_fd_sc_hd__a22o_1
X_2257_ reg_file.registers\[11\]\[2\] _0828_ _0829_ reg_file.registers\[10\]\[2\]
+ VGND VGND VPWR VPWR _1069_ sky130_fd_sc_hd__a22o_1
XFILLER_0_26_3 VPWR VGND VPWR VGND sky130_ef_sc_hd__decap_12
X_2326_ _0780_ _0781_ _1133_ VGND VGND VPWR VPWR _1134_ sky130_fd_sc_hd__a21oi_1
X_2188_ _0720_ _0726_ _0878_ VGND VGND VPWR VPWR _1002_ sky130_fd_sc_hd__mux2_1
XFILLER_0_34_90 VPWR VGND VPWR VGND sky130_ef_sc_hd__decap_12
XFILLER_0_47_187 VGND VGND VPWR VPWR sky130_fd_sc_hd__fill_1
XFILLER_0_43_393 VGND VGND VPWR VPWR sky130_fd_sc_hd__decap_8
XFILLER_0_35_349 VGND VGND VPWR VPWR sky130_fd_sc_hd__decap_6
XFILLER_0_7_273 VGND VGND VPWR VPWR sky130_fd_sc_hd__decap_6
XFILLER_0_58_419 VGND VGND VPWR VPWR sky130_fd_sc_hd__fill_1
XTAP_TAPCELL_ROW_3_183 VGND VPWR sky130_fd_sc_hd__tapvpwrvgnd_1
XFILLER_0_14_27 VGND VGND VPWR VPWR sky130_fd_sc_hd__fill_1
XFILLER_0_38_121 VGND VGND VPWR VPWR sky130_fd_sc_hd__decap_8
XFILLER_0_30_15 VPWR VGND VPWR VGND sky130_ef_sc_hd__decap_12
XFILLER_0_19_390 VGND VGND VPWR VPWR sky130_fd_sc_hd__fill_2
X_1490_ reg_file.registers\[2\]\[0\] VGND VGND VPWR VPWR _0371_ sky130_fd_sc_hd__clkbuf_1
XFILLER_0_39_57 VPWR VGND VPWR VGND sky130_ef_sc_hd__decap_12
XFILLER_0_1_449 VGND VGND VPWR VPWR sky130_fd_sc_hd__fill_2
XFILLER_0_1_405 VPWR VGND VPWR VGND sky130_ef_sc_hd__decap_12
XFILLER_0_55_23 VGND VGND VPWR VPWR sky130_fd_sc_hd__fill_1
X_3160_ clknet_leaf_11_clk _0363_ VGND VGND VPWR VPWR net7 sky130_fd_sc_hd__dfxtp_1
X_2111_ _0922_ _0926_ _0898_ VGND VGND VPWR VPWR _0927_ sky130_fd_sc_hd__mux2_1
X_2042_ reg_file.registers\[10\]\[31\] _0492_ _0468_ reg_file.registers\[5\]\[31\]
+ VGND VGND VPWR VPWR _0858_ sky130_fd_sc_hd__a22o_1
X_3091_ clknet_leaf_15_clk _0314_ _0150_ VGND VGND VPWR VPWR reg_file.registers\[10\]\[29\]
+ sky130_fd_sc_hd__dfrtp_1
XFILLER_0_29_154 VGND VGND VPWR VPWR sky130_fd_sc_hd__decap_4
XPHY_EDGE_ROW_8_Right_8 VGND VGND VPWR VPWR sky130_fd_sc_hd__decap_3
X_2875_ _1464_ VGND VGND VPWR VPWR _0124_ sky130_fd_sc_hd__inv_2
X_1826_ _0622_ VGND VGND VPWR VPWR _0642_ sky130_fd_sc_hd__buf_2
X_2944_ _1473_ VGND VGND VPWR VPWR _0184_ sky130_fd_sc_hd__inv_2
XFILLER_0_29_176 VGND VGND VPWR VPWR sky130_fd_sc_hd__decap_3
XFILLER_0_4_265 VPWR VGND VPWR VGND sky130_ef_sc_hd__decap_12
XFILLER_0_4_221 VPWR VGND VPWR VGND sky130_ef_sc_hd__decap_12
XFILLER_0_17_349 VGND VGND VPWR VPWR sky130_fd_sc_hd__fill_2
X_1688_ reg_file.registers\[10\]\[0\] _0381_ _0386_ _0491_ VGND VGND VPWR VPWR _0504_
+ sky130_fd_sc_hd__and4_1
XPHY_EDGE_ROW_39_Right_39 VGND VGND VPWR VPWR sky130_fd_sc_hd__decap_3
XFILLER_0_40_363 VGND VGND VPWR VPWR sky130_fd_sc_hd__fill_1
X_1757_ reg_file.registers\[15\]\[21\] _0543_ _0537_ reg_file.registers\[5\]\[21\]
+ VGND VGND VPWR VPWR _0573_ sky130_fd_sc_hd__a22o_1
XTAP_TAPCELL_ROW_68_697 VGND VPWR sky130_fd_sc_hd__tapvpwrvgnd_1
X_2309_ _0893_ _1040_ _0909_ VGND VGND VPWR VPWR _1118_ sky130_fd_sc_hd__a21o_1
XTAP_TAPCELL_ROW_0_153 VGND VPWR sky130_fd_sc_hd__tapvpwrvgnd_1
XPHY_EDGE_ROW_13_Left_85 VGND VGND VPWR VPWR sky130_fd_sc_hd__decap_3
XFILLER_0_67_249 VPWR VGND VPWR VGND sky130_ef_sc_hd__decap_12
XTAP_TAPCELL_ROW_51_564 VGND VPWR sky130_fd_sc_hd__tapvpwrvgnd_1
XPHY_EDGE_ROW_48_Right_48 VGND VGND VPWR VPWR sky130_fd_sc_hd__decap_3
XPHY_EDGE_ROW_57_Right_57 VGND VGND VPWR VPWR sky130_fd_sc_hd__decap_3
XFILLER_0_50_105 VGND VGND VPWR VPWR sky130_fd_sc_hd__fill_1
XFILLER_0_31_374 VGND VGND VPWR VPWR sky130_fd_sc_hd__fill_2
XTAP_TAPCELL_ROW_8_220 VGND VPWR sky130_fd_sc_hd__tapvpwrvgnd_1
XFILLER_0_16_360 VGND VGND VPWR VPWR sky130_fd_sc_hd__decap_4
XTAP_TAPCELL_ROW_59_631 VGND VPWR sky130_fd_sc_hd__tapvpwrvgnd_1
XPHY_EDGE_ROW_66_Right_66 VGND VGND VPWR VPWR sky130_fd_sc_hd__decap_3
XFILLER_0_58_205 VGND VGND VPWR VPWR sky130_fd_sc_hd__fill_2
XFILLER_0_25_15 VPWR VGND VPWR VGND sky130_ef_sc_hd__decap_12
XFILLER_0_54_433 VGND VGND VPWR VPWR sky130_fd_sc_hd__fill_2
XFILLER_0_54_411 VGND VGND VPWR VPWR sky130_fd_sc_hd__decap_8
X_2660_ _1237_ _1368_ _1369_ _1254_ VGND VGND VPWR VPWR _1378_ sky130_fd_sc_hd__a22o_1
XFILLER_0_41_69 VGND VGND VPWR VPWR sky130_fd_sc_hd__decap_4
X_1611_ reg_file.registers\[10\]\[17\] _0438_ VGND VGND VPWR VPWR _0445_ sky130_fd_sc_hd__and2_1
XFILLER_0_26_157 VPWR VGND VPWR VGND sky130_ef_sc_hd__decap_12
XTAP_TAPCELL_ROW_14_266 VGND VPWR sky130_fd_sc_hd__tapvpwrvgnd_1
X_2591_ imem.address\[28\] _1336_ imem.address\[29\] VGND VGND VPWR VPWR _1341_ sky130_fd_sc_hd__a21oi_1
X_1542_ _0408_ VGND VGND VPWR VPWR _0335_ sky130_fd_sc_hd__clkbuf_1
XFILLER_0_22_374 VPWR VGND VPWR VGND sky130_ef_sc_hd__decap_12
XFILLER_0_22_363 VGND VGND VPWR VPWR sky130_fd_sc_hd__fill_1
XFILLER_0_5_69 VPWR VGND VPWR VGND sky130_ef_sc_hd__decap_12
XFILLER_0_1_279 VGND VGND VPWR VPWR sky130_fd_sc_hd__fill_1
X_3074_ clknet_leaf_6_clk _0297_ _0133_ VGND VGND VPWR VPWR reg_file.registers\[10\]\[12\]
+ sky130_fd_sc_hd__dfrtp_1
XFILLER_0_49_205 VGND VGND VPWR VPWR sky130_fd_sc_hd__fill_1
X_3143_ clknet_leaf_14_clk _0025_ VGND VGND VPWR VPWR display.counter\[8\] sky130_fd_sc_hd__dfxtp_1
X_2025_ _0826_ _0827_ _0835_ _0840_ VGND VGND VPWR VPWR _0841_ sky130_fd_sc_hd__a211o_1
XTAP_TAPCELL_ROW_65_678 VGND VPWR sky130_fd_sc_hd__tapvpwrvgnd_1
XFILLER_0_57_293 VPWR VGND VPWR VGND sky130_ef_sc_hd__decap_12
X_2927_ _1470_ VGND VGND VPWR VPWR _0170_ sky130_fd_sc_hd__inv_2
XFILLER_0_9_313 VGND VGND VPWR VPWR sky130_fd_sc_hd__decap_4
XFILLER_0_9_335 VGND VGND VPWR VPWR sky130_fd_sc_hd__fill_1
XFILLER_0_15_81 VGND VGND VPWR VPWR sky130_fd_sc_hd__decap_8
X_2789_ _1453_ VGND VGND VPWR VPWR _0049_ sky130_fd_sc_hd__inv_2
X_1809_ _0478_ _0624_ _0529_ VGND VGND VPWR VPWR _0625_ sky130_fd_sc_hd__a21oi_1
X_2858_ _1461_ VGND VGND VPWR VPWR _0110_ sky130_fd_sc_hd__inv_2
XTAP_TAPCELL_ROW_56_601 VGND VPWR sky130_fd_sc_hd__tapvpwrvgnd_1
XFILLER_0_51_436 VGND VGND VPWR VPWR sky130_fd_sc_hd__decap_8
XFILLER_0_51_414 VPWR VGND VPWR VGND sky130_ef_sc_hd__decap_12
XFILLER_0_36_411 VGND VGND VPWR VPWR sky130_fd_sc_hd__decap_8
XFILLER_0_11_39 VPWR VGND VPWR VGND sky130_ef_sc_hd__decap_12
XTAP_TAPCELL_ROW_11_247 VGND VPWR sky130_fd_sc_hd__tapvpwrvgnd_1
XTAP_TAPCELL_ROW_62_648 VGND VPWR sky130_fd_sc_hd__tapvpwrvgnd_1
XFILLER_0_27_400 VGND VGND VPWR VPWR sky130_fd_sc_hd__decap_6
X_2574_ imem.address\[12\] _1325_ VGND VGND VPWR VPWR _1326_ sky130_fd_sc_hd__and2_1
X_2712_ _1366_ VGND VGND VPWR VPWR _0361_ sky130_fd_sc_hd__inv_2
X_2643_ display.digit_sel\[0\] display.digit_sel\[2\] display.digit_sel\[1\] VGND
+ VGND VPWR VPWR _0364_ sky130_fd_sc_hd__nand3b_2
X_1525_ _0399_ VGND VGND VPWR VPWR _0343_ sky130_fd_sc_hd__clkbuf_1
X_3126_ clknet_leaf_2_clk _0349_ _0185_ VGND VGND VPWR VPWR reg_file.registers\[2\]\[0\]
+ sky130_fd_sc_hd__dfrtp_1
XFILLER_0_26_80 VGND VGND VPWR VPWR sky130_fd_sc_hd__decap_4
X_3057_ clknet_leaf_13_clk _0280_ _0116_ VGND VGND VPWR VPWR reg_file.registers\[11\]\[27\]
+ sky130_fd_sc_hd__dfrtp_1
X_2008_ _0793_ _0810_ _0817_ _0823_ VGND VGND VPWR VPWR _0824_ sky130_fd_sc_hd__a211oi_4
XFILLER_0_5_393 VPWR VGND VPWR VGND sky130_ef_sc_hd__decap_12
XFILLER_0_13_193 VPWR VGND VPWR VGND sky130_ef_sc_hd__decap_12
XFILLER_0_68_377 VPWR VGND VPWR VGND sky130_ef_sc_hd__decap_12
XFILLER_0_68_333 VPWR VGND VPWR VGND sky130_ef_sc_hd__decap_12
XFILLER_0_28_208 VGND VGND VPWR VPWR sky130_fd_sc_hd__fill_1
XTAP_TAPCELL_ROW_24_350 VGND VPWR sky130_fd_sc_hd__tapvpwrvgnd_1
XFILLER_0_22_27 VGND VGND VPWR VPWR sky130_fd_sc_hd__fill_1
XFILLER_0_51_222 VGND VGND VPWR VPWR sky130_fd_sc_hd__fill_2
XPHY_EDGE_ROW_47_Left_119 VGND VGND VPWR VPWR sky130_fd_sc_hd__decap_3
XFILLER_0_24_447 VGND VGND VPWR VPWR sky130_fd_sc_hd__decap_4
XFILLER_0_47_57 VGND VGND VPWR VPWR sky130_fd_sc_hd__decap_4
X_2290_ _1051_ _0471_ _1092_ _1100_ VGND VGND VPWR VPWR _1101_ sky130_fd_sc_hd__a31o_1
XPHY_EDGE_ROW_56_Left_128 VGND VGND VPWR VPWR sky130_fd_sc_hd__decap_3
XFILLER_0_2_15 VPWR VGND VPWR VGND sky130_ef_sc_hd__decap_12
XFILLER_0_27_241 VGND VGND VPWR VPWR sky130_fd_sc_hd__fill_1
X_2626_ imem.address\[7\] _1322_ imem.address\[8\] VGND VGND VPWR VPWR _1355_ sky130_fd_sc_hd__a21oi_1
XPHY_EDGE_ROW_65_Left_137 VGND VGND VPWR VPWR sky130_fd_sc_hd__decap_3
XFILLER_0_56_3 VPWR VGND VPWR VGND sky130_ef_sc_hd__decap_12
X_2557_ reg_file.registers\[15\]\[5\] _1285_ VGND VGND VPWR VPWR _1315_ sky130_fd_sc_hd__and2_1
XFILLER_0_42_288 VGND VGND VPWR VPWR sky130_fd_sc_hd__fill_2
XTAP_TAPCELL_ROW_30_397 VGND VPWR sky130_fd_sc_hd__tapvpwrvgnd_1
XFILLER_0_2_363 VGND VGND VPWR VPWR sky130_fd_sc_hd__fill_1
XFILLER_0_10_141 VPWR VGND VPWR VGND sky130_ef_sc_hd__decap_12
X_1508_ _0387_ VGND VGND VPWR VPWR _0388_ sky130_fd_sc_hd__buf_6
X_2488_ _0872_ _0674_ VGND VGND VPWR VPWR _1274_ sky130_fd_sc_hd__or2_1
X_3109_ clknet_leaf_21_clk _0332_ _0168_ VGND VGND VPWR VPWR reg_file.registers\[5\]\[15\]
+ sky130_fd_sc_hd__dfrtp_1
XFILLER_0_18_241 VGND VGND VPWR VPWR sky130_fd_sc_hd__decap_8
XTAP_TAPCELL_ROW_21_320 VGND VPWR sky130_fd_sc_hd__tapvpwrvgnd_1
XFILLER_0_33_15 VPWR VGND VPWR VGND sky130_ef_sc_hd__decap_12
XPHY_EDGE_ROW_1_Left_73 VGND VGND VPWR VPWR sky130_fd_sc_hd__decap_3
XFILLER_0_17_27 VPWR VGND VPWR VGND sky130_ef_sc_hd__decap_12
XFILLER_0_68_141 VGND VGND VPWR VPWR sky130_fd_sc_hd__decap_8
X_1790_ _0372_ _0388_ _0379_ VGND VGND VPWR VPWR _0606_ sky130_fd_sc_hd__nand3_2
XFILLER_0_58_56 VGND VGND VPWR VPWR sky130_fd_sc_hd__decap_8
XFILLER_0_58_34 VGND VGND VPWR VPWR sky130_fd_sc_hd__fill_2
X_2411_ _1209_ VGND VGND VPWR VPWR _0267_ sky130_fd_sc_hd__clkbuf_1
XFILLER_0_24_299 VGND VGND VPWR VPWR sky130_fd_sc_hd__decap_3
XFILLER_0_3_149 VPWR VGND VPWR VGND sky130_ef_sc_hd__decap_12
XFILLER_0_3_105 VGND VGND VPWR VPWR sky130_fd_sc_hd__decap_6
XFILLER_0_12_417 VGND VGND VPWR VPWR sky130_fd_sc_hd__decap_3
X_2273_ _1083_ _1084_ _0879_ VGND VGND VPWR VPWR _1085_ sky130_fd_sc_hd__mux2_1
X_2342_ _0947_ _1042_ _1139_ _0971_ VGND VGND VPWR VPWR _1149_ sky130_fd_sc_hd__a22o_1
XFILLER_0_59_185 VGND VGND VPWR VPWR sky130_fd_sc_hd__fill_1
XFILLER_0_59_152 VGND VGND VPWR VPWR sky130_fd_sc_hd__decap_3
XTAP_TAPCELL_ROW_35_434 VGND VPWR sky130_fd_sc_hd__tapvpwrvgnd_1
XFILLER_0_47_358 VPWR VGND VPWR VGND sky130_ef_sc_hd__decap_12
XFILLER_0_30_203 VGND VGND VPWR VPWR sky130_fd_sc_hd__decap_4
XFILLER_0_15_233 VGND VGND VPWR VPWR sky130_fd_sc_hd__decap_6
XFILLER_0_15_288 VGND VGND VPWR VPWR sky130_fd_sc_hd__fill_1
X_1988_ _0774_ _0777_ VGND VGND VPWR VPWR _0804_ sky130_fd_sc_hd__nor2_1
X_2609_ imem.address\[18\] _1329_ VGND VGND VPWR VPWR _1348_ sky130_fd_sc_hd__nor2_1
XFILLER_0_30_214 VPWR VGND VPWR VGND sky130_ef_sc_hd__decap_12
XFILLER_0_65_111 VGND VGND VPWR VPWR sky130_fd_sc_hd__fill_1
XFILLER_0_38_325 VGND VGND VPWR VPWR sky130_fd_sc_hd__decap_3
XFILLER_0_61_361 VGND VGND VPWR VPWR sky130_fd_sc_hd__decap_8
XFILLER_0_21_225 VGND VGND VPWR VPWR sky130_fd_sc_hd__decap_8
XTAP_TAPCELL_ROW_49_548 VGND VPWR sky130_fd_sc_hd__tapvpwrvgnd_1
XFILLER_0_28_48 VGND VGND VPWR VPWR sky130_fd_sc_hd__fill_2
XFILLER_0_28_15 VPWR VGND VPWR VGND sky130_ef_sc_hd__decap_12
X_2960_ clknet_leaf_5_clk net1 VGND VGND VPWR VPWR prev_control sky130_fd_sc_hd__dfxtp_1
XFILLER_0_56_100 VGND VGND VPWR VPWR sky130_fd_sc_hd__decap_3
XFILLER_0_44_58 VGND VGND VPWR VPWR sky130_fd_sc_hd__decap_8
XFILLER_0_71_169 VPWR VGND VPWR VGND sky130_ef_sc_hd__decap_12
XFILLER_0_71_125 VPWR VGND VPWR VGND sky130_ef_sc_hd__decap_12
XFILLER_0_60_57 VGND VGND VPWR VPWR sky130_fd_sc_hd__decap_3
X_1911_ _0723_ _0726_ VGND VGND VPWR VPWR _0727_ sky130_fd_sc_hd__nand2_1
X_1842_ _0502_ _0513_ VGND VGND VPWR VPWR _0658_ sky130_fd_sc_hd__nor2_1
XFILLER_0_44_317 VGND VGND VPWR VPWR sky130_fd_sc_hd__fill_2
XTAP_TAPCELL_ROW_32_415 VGND VPWR sky130_fd_sc_hd__tapvpwrvgnd_1
X_2891_ _1465_ VGND VGND VPWR VPWR _0139_ sky130_fd_sc_hd__inv_2
X_1773_ _0583_ _0586_ _0588_ VGND VGND VPWR VPWR _0589_ sky130_fd_sc_hd__or3_4
XFILLER_0_69_55 VGND VGND VPWR VPWR sky130_fd_sc_hd__fill_1
XFILLER_0_12_225 VGND VGND VPWR VPWR sky130_fd_sc_hd__fill_1
XFILLER_0_12_269 VGND VGND VPWR VPWR sky130_fd_sc_hd__fill_1
X_2187_ _0999_ _1000_ _0902_ VGND VGND VPWR VPWR _1001_ sky130_fd_sc_hd__mux2_1
X_2256_ _0898_ _1066_ _1067_ VGND VGND VPWR VPWR _1068_ sky130_fd_sc_hd__a21o_1
X_2325_ _0782_ _1132_ VGND VGND VPWR VPWR _1133_ sky130_fd_sc_hd__nor2_1
XFILLER_0_19_3 VPWR VGND VPWR VGND sky130_ef_sc_hd__decap_12
XFILLER_0_47_166 VGND VGND VPWR VPWR sky130_fd_sc_hd__fill_2
XFILLER_0_47_155 VGND VGND VPWR VPWR sky130_fd_sc_hd__fill_2
XFILLER_0_47_122 VGND VGND VPWR VPWR sky130_fd_sc_hd__fill_1
XFILLER_0_34_80 VGND VGND VPWR VPWR sky130_fd_sc_hd__decap_4
XFILLER_0_62_125 VPWR VGND VPWR VGND sky130_ef_sc_hd__decap_12
XFILLER_0_50_309 VPWR VGND VPWR VGND sky130_ef_sc_hd__decap_12
XFILLER_0_43_383 VGND VGND VPWR VPWR sky130_fd_sc_hd__decap_8
XFILLER_0_43_361 VPWR VGND VPWR VGND sky130_ef_sc_hd__decap_12
Xclone27 _1384_ VGND VGND VPWR VPWR net43 sky130_fd_sc_hd__buf_2
XTAP_TAPCELL_ROW_54_584 VGND VPWR sky130_fd_sc_hd__tapvpwrvgnd_1
XFILLER_0_53_169 VGND VGND VPWR VPWR sky130_fd_sc_hd__decap_8
XFILLER_0_34_361 VGND VGND VPWR VPWR sky130_fd_sc_hd__decap_3
XFILLER_0_30_27 VGND VGND VPWR VPWR sky130_fd_sc_hd__fill_1
XFILLER_0_39_69 VGND VGND VPWR VPWR sky130_fd_sc_hd__fill_2
XFILLER_0_1_417 VPWR VGND VPWR VGND sky130_ef_sc_hd__decap_12
XFILLER_0_55_68 VGND VGND VPWR VPWR sky130_fd_sc_hd__fill_2
X_2110_ _0891_ _0924_ _0925_ VGND VGND VPWR VPWR _0926_ sky130_fd_sc_hd__a21o_1
X_3090_ clknet_leaf_15_clk _0313_ _0149_ VGND VGND VPWR VPWR reg_file.registers\[10\]\[28\]
+ sky130_fd_sc_hd__dfrtp_1
X_2041_ reg_file.registers\[10\]\[31\] _0775_ _0776_ reg_file.registers\[11\]\[31\]
+ VGND VGND VPWR VPWR _0857_ sky130_fd_sc_hd__a22o_1
X_2943_ _1473_ VGND VGND VPWR VPWR _0183_ sky130_fd_sc_hd__inv_2
X_2874_ _1464_ VGND VGND VPWR VPWR _0123_ sky130_fd_sc_hd__inv_2
X_1825_ _0620_ VGND VGND VPWR VPWR _0641_ sky130_fd_sc_hd__clkbuf_4
XFILLER_0_44_158 VGND VGND VPWR VPWR sky130_fd_sc_hd__fill_1
XFILLER_0_44_125 VGND VGND VPWR VPWR sky130_fd_sc_hd__fill_1
XFILLER_0_29_199 VGND VGND VPWR VPWR sky130_fd_sc_hd__fill_2
X_1756_ _0566_ _0571_ VGND VGND VPWR VPWR _0572_ sky130_fd_sc_hd__nand2_1
XFILLER_0_4_277 VPWR VGND VPWR VGND sky130_ef_sc_hd__decap_12
XFILLER_0_4_233 VPWR VGND VPWR VGND sky130_ef_sc_hd__decap_12
X_1687_ reg_file.registers\[5\]\[0\] _0486_ VGND VGND VPWR VPWR _0503_ sky130_fd_sc_hd__nand2_1
X_2308_ _0910_ _1116_ VGND VGND VPWR VPWR _1117_ sky130_fd_sc_hd__nand2_1
XTAP_TAPCELL_ROW_68_698 VGND VPWR sky130_fd_sc_hd__tapvpwrvgnd_1
XTAP_TAPCELL_ROW_0_154 VGND VPWR sky130_fd_sc_hd__tapvpwrvgnd_1
X_2239_ _0824_ _0840_ _1050_ VGND VGND VPWR VPWR _1051_ sky130_fd_sc_hd__o21bai_1
XTAP_TAPCELL_ROW_51_565 VGND VPWR sky130_fd_sc_hd__tapvpwrvgnd_1
XFILLER_0_35_169 VGND VGND VPWR VPWR sky130_fd_sc_hd__fill_1
XFILLER_0_35_103 VGND VGND VPWR VPWR sky130_fd_sc_hd__fill_1
XFILLER_0_0_81 VGND VGND VPWR VPWR sky130_fd_sc_hd__decap_3
XFILLER_0_50_139 VGND VGND VPWR VPWR sky130_fd_sc_hd__fill_1
XFILLER_0_31_386 VGND VGND VPWR VPWR sky130_fd_sc_hd__decap_6
XFILLER_0_31_364 VGND VGND VPWR VPWR sky130_fd_sc_hd__fill_2
XFILLER_0_8_3 VPWR VGND VPWR VGND sky130_ef_sc_hd__decap_12
XTAP_TAPCELL_ROW_8_221 VGND VPWR sky130_fd_sc_hd__tapvpwrvgnd_1
XFILLER_0_25_27 VPWR VGND VPWR VGND sky130_ef_sc_hd__decap_12
XFILLER_0_41_15 VPWR VGND VPWR VGND sky130_ef_sc_hd__decap_12
X_2590_ _1340_ VGND VGND VPWR VPWR _0219_ sky130_fd_sc_hd__clkbuf_1
X_1610_ _0444_ VGND VGND VPWR VPWR _0303_ sky130_fd_sc_hd__clkbuf_1
XFILLER_0_26_169 VPWR VGND VPWR VGND sky130_ef_sc_hd__decap_12
XFILLER_0_1_225 VPWR VGND VPWR VGND sky130_ef_sc_hd__decap_12
XTAP_TAPCELL_ROW_14_267 VGND VPWR sky130_fd_sc_hd__tapvpwrvgnd_1
X_1541_ reg_file.registers\[5\]\[18\] _0403_ VGND VGND VPWR VPWR _0408_ sky130_fd_sc_hd__and2_1
XFILLER_0_22_386 VGND VGND VPWR VPWR sky130_fd_sc_hd__decap_8
XFILLER_0_5_15 VPWR VGND VPWR VGND sky130_ef_sc_hd__decap_12
X_3142_ clknet_leaf_14_clk _0024_ VGND VGND VPWR VPWR display.counter\[7\] sky130_fd_sc_hd__dfxtp_1
X_3073_ clknet_leaf_9_clk _0296_ _0132_ VGND VGND VPWR VPWR reg_file.registers\[10\]\[11\]
+ sky130_fd_sc_hd__dfrtp_1
XTAP_TAPCELL_ROW_65_679 VGND VPWR sky130_fd_sc_hd__tapvpwrvgnd_1
X_2024_ _0837_ _0839_ _0815_ VGND VGND VPWR VPWR _0840_ sky130_fd_sc_hd__a21oi_1
X_2926_ _1470_ VGND VGND VPWR VPWR _0169_ sky130_fd_sc_hd__inv_2
X_2857_ _1461_ VGND VGND VPWR VPWR _0109_ sky130_fd_sc_hd__inv_2
XFILLER_0_17_169 VGND VGND VPWR VPWR sky130_fd_sc_hd__decap_8
X_2788_ _1453_ VGND VGND VPWR VPWR _0048_ sky130_fd_sc_hd__inv_2
X_1808_ reg_file.registers\[15\]\[14\] _0543_ _0537_ reg_file.registers\[5\]\[14\]
+ VGND VGND VPWR VPWR _0624_ sky130_fd_sc_hd__a22o_1
X_1739_ reg_file.registers\[15\]\[17\] _0543_ _0537_ reg_file.registers\[5\]\[17\]
+ VGND VGND VPWR VPWR _0555_ sky130_fd_sc_hd__a22o_1
XTAP_TAPCELL_ROW_56_602 VGND VPWR sky130_fd_sc_hd__tapvpwrvgnd_1
XFILLER_0_55_209 VGND VGND VPWR VPWR sky130_fd_sc_hd__fill_2
XFILLER_0_36_401 VGND VGND VPWR VPWR sky130_fd_sc_hd__fill_1
XFILLER_0_63_253 VGND VGND VPWR VPWR sky130_fd_sc_hd__fill_1
XFILLER_0_51_426 VGND VGND VPWR VPWR sky130_fd_sc_hd__decap_4
XFILLER_0_48_294 VGND VGND VPWR VPWR sky130_fd_sc_hd__fill_1
XFILLER_0_23_128 VPWR VGND VPWR VGND sky130_ef_sc_hd__decap_12
XFILLER_0_16_180 VGND VGND VPWR VPWR sky130_fd_sc_hd__fill_2
XFILLER_0_31_194 VGND VGND VPWR VPWR sky130_fd_sc_hd__decap_8
XFILLER_0_36_15 VPWR VGND VPWR VGND sky130_ef_sc_hd__decap_12
XTAP_TAPCELL_ROW_19_304 VGND VPWR sky130_fd_sc_hd__tapvpwrvgnd_1
XTAP_TAPCELL_ROW_62_649 VGND VPWR sky130_fd_sc_hd__tapvpwrvgnd_1
X_2711_ _1369_ VGND VGND VPWR VPWR _0359_ sky130_fd_sc_hd__inv_2
XFILLER_0_54_231 VGND VGND VPWR VPWR sky130_fd_sc_hd__fill_1
XTAP_TAPCELL_ROW_27_370 VGND VPWR sky130_fd_sc_hd__tapvpwrvgnd_1
X_2573_ imem.address\[11\] imem.address\[10\] _1324_ VGND VGND VPWR VPWR _1325_ sky130_fd_sc_hd__and3_1
X_2642_ net38 _0362_ VGND VGND VPWR VPWR _1363_ sky130_fd_sc_hd__nor2_1
XFILLER_0_10_334 VPWR VGND VPWR VGND sky130_ef_sc_hd__decap_12
X_1524_ reg_file.registers\[5\]\[26\] _0393_ VGND VGND VPWR VPWR _0399_ sky130_fd_sc_hd__and2_1
XFILLER_0_22_161 VGND VGND VPWR VPWR sky130_fd_sc_hd__decap_4
X_3125_ clknet_leaf_0_clk _0348_ _0184_ VGND VGND VPWR VPWR reg_file.registers\[5\]\[31\]
+ sky130_fd_sc_hd__dfrtp_1
XFILLER_0_37_209 VGND VGND VPWR VPWR sky130_fd_sc_hd__decap_4
XFILLER_0_9_111 VGND VGND VPWR VPWR sky130_fd_sc_hd__fill_1
X_3056_ clknet_leaf_15_clk _0279_ _0115_ VGND VGND VPWR VPWR reg_file.registers\[11\]\[26\]
+ sky130_fd_sc_hd__dfrtp_1
X_2007_ _0821_ _0822_ VGND VGND VPWR VPWR _0823_ sky130_fd_sc_hd__nand2_1
X_2909_ _1469_ VGND VGND VPWR VPWR _0153_ sky130_fd_sc_hd__inv_2
XFILLER_0_42_80 VGND VGND VPWR VPWR sky130_fd_sc_hd__decap_4
XFILLER_0_5_361 VPWR VGND VPWR VGND sky130_ef_sc_hd__decap_12
XFILLER_0_68_301 VGND VGND VPWR VPWR sky130_fd_sc_hd__decap_6
XFILLER_0_68_389 VPWR VGND VPWR VGND sky130_ef_sc_hd__decap_12
XFILLER_0_68_345 VPWR VGND VPWR VGND sky130_ef_sc_hd__decap_12
XFILLER_0_36_253 VGND VGND VPWR VPWR sky130_fd_sc_hd__decap_6
XFILLER_0_36_231 VPWR VGND VPWR VGND sky130_ef_sc_hd__decap_12
XTAP_TAPCELL_ROW_24_351 VGND VPWR sky130_fd_sc_hd__tapvpwrvgnd_1
XFILLER_0_51_289 VPWR VGND VPWR VGND sky130_ef_sc_hd__decap_12
XFILLER_0_36_264 VGND VGND VPWR VPWR sky130_fd_sc_hd__decap_8
XFILLER_0_24_404 VGND VGND VPWR VPWR sky130_fd_sc_hd__decap_4
XFILLER_0_2_27 VGND VGND VPWR VPWR sky130_fd_sc_hd__fill_1
XFILLER_0_12_83 VGND VGND VPWR VPWR sky130_fd_sc_hd__fill_1
X_2625_ _1324_ _1354_ VGND VGND VPWR VPWR _0198_ sky130_fd_sc_hd__nor2_1
X_1507_ _0386_ _0381_ VGND VGND VPWR VPWR _0387_ sky130_fd_sc_hd__and2_4
X_2487_ _0672_ _0676_ VGND VGND VPWR VPWR _1273_ sky130_fd_sc_hd__and2b_1
X_2556_ _1314_ VGND VGND VPWR VPWR _0227_ sky130_fd_sc_hd__clkbuf_1
XTAP_TAPCELL_ROW_30_398 VGND VPWR sky130_fd_sc_hd__tapvpwrvgnd_1
XFILLER_0_10_153 VPWR VGND VPWR VGND sky130_ef_sc_hd__decap_12
XFILLER_0_49_3 VPWR VGND VPWR VGND sky130_ef_sc_hd__decap_12
X_3108_ clknet_leaf_21_clk _0331_ _0167_ VGND VGND VPWR VPWR reg_file.registers\[5\]\[14\]
+ sky130_fd_sc_hd__dfrtp_1
XFILLER_0_10_197 VPWR VGND VPWR VGND sky130_ef_sc_hd__decap_12
XFILLER_0_65_337 VPWR VGND VPWR VGND sky130_ef_sc_hd__decap_12
X_3039_ clknet_leaf_10_clk _0262_ _0098_ VGND VGND VPWR VPWR reg_file.registers\[11\]\[9\]
+ sky130_fd_sc_hd__dfrtp_1
XFILLER_0_18_253 VGND VGND VPWR VPWR sky130_fd_sc_hd__fill_1
XTAP_TAPCELL_ROW_21_321 VGND VPWR sky130_fd_sc_hd__tapvpwrvgnd_1
XFILLER_0_33_278 VGND VGND VPWR VPWR sky130_fd_sc_hd__fill_2
XFILLER_0_33_223 VGND VGND VPWR VPWR sky130_fd_sc_hd__fill_1
XFILLER_0_18_297 VGND VGND VPWR VPWR sky130_fd_sc_hd__decap_8
XFILLER_0_33_27 VGND VGND VPWR VPWR sky130_fd_sc_hd__decap_8
XFILLER_0_17_39 VPWR VGND VPWR VGND sky130_ef_sc_hd__decap_12
XFILLER_0_68_197 VPWR VGND VPWR VGND sky130_ef_sc_hd__decap_12
XFILLER_0_64_381 VPWR VGND VPWR VGND sky130_ef_sc_hd__decap_12
XFILLER_0_56_326 VPWR VGND VPWR VGND sky130_ef_sc_hd__decap_12
XFILLER_0_24_245 VGND VGND VPWR VPWR sky130_fd_sc_hd__decap_6
X_2410_ reg_file.registers\[11\]\[14\] _1208_ _1158_ VGND VGND VPWR VPWR _1209_ sky130_fd_sc_hd__mux2_1
X_2341_ _1133_ _1147_ _0470_ VGND VGND VPWR VPWR _1148_ sky130_fd_sc_hd__and3b_1
X_2272_ reg_file.registers\[11\]\[10\] _0828_ _0829_ reg_file.registers\[10\]\[10\]
+ VGND VGND VPWR VPWR _1084_ sky130_fd_sc_hd__a22o_1
XFILLER_0_62_307 VGND VGND VPWR VPWR sky130_fd_sc_hd__fill_1
XFILLER_0_59_164 VGND VGND VPWR VPWR sky130_fd_sc_hd__fill_1
XFILLER_0_47_337 VPWR VGND VPWR VGND sky130_ef_sc_hd__decap_12
XTAP_TAPCELL_ROW_35_435 VGND VPWR sky130_fd_sc_hd__tapvpwrvgnd_1
XFILLER_0_62_318 VGND VGND VPWR VPWR sky130_fd_sc_hd__decap_6
XFILLER_0_30_226 VPWR VGND VPWR VGND sky130_ef_sc_hd__decap_12
X_1987_ _0774_ _0801_ _0780_ _0802_ VGND VGND VPWR VPWR _0803_ sky130_fd_sc_hd__a22oi_1
X_2608_ imem.address\[19\] _1330_ VGND VGND VPWR VPWR _0208_ sky130_fd_sc_hd__xor2_1
X_2539_ reg_file.registers\[15\]\[14\] _1304_ VGND VGND VPWR VPWR _1306_ sky130_fd_sc_hd__and2_1
XFILLER_0_3_81 VPWR VGND VPWR VGND sky130_ef_sc_hd__decap_12
XFILLER_0_65_167 VGND VGND VPWR VPWR sky130_fd_sc_hd__fill_1
XFILLER_0_65_145 VGND VGND VPWR VPWR sky130_fd_sc_hd__decap_3
XFILLER_0_53_329 VGND VGND VPWR VPWR sky130_fd_sc_hd__decap_6
XFILLER_0_53_318 VGND VGND VPWR VPWR sky130_fd_sc_hd__decap_3
XFILLER_0_53_307 VGND VGND VPWR VPWR sky130_fd_sc_hd__decap_3
XFILLER_0_38_337 VPWR VGND VPWR VGND sky130_ef_sc_hd__decap_12
XFILLER_0_0_109 VGND VGND VPWR VPWR sky130_fd_sc_hd__decap_3
XTAP_TAPCELL_ROW_49_549 VGND VPWR sky130_fd_sc_hd__tapvpwrvgnd_1
XFILLER_0_44_15 VPWR VGND VPWR VGND sky130_ef_sc_hd__decap_12
XFILLER_0_28_27 VGND VGND VPWR VPWR sky130_fd_sc_hd__fill_1
X_1910_ reg_file.registers\[10\]\[8\] _0603_ _0608_ reg_file.registers\[11\]\[8\]
+ VGND VGND VPWR VPWR _0726_ sky130_fd_sc_hd__a22o_1
X_2890_ _1465_ VGND VGND VPWR VPWR _0138_ sky130_fd_sc_hd__inv_2
XFILLER_0_29_359 VPWR VGND VPWR VGND sky130_ef_sc_hd__decap_12
XFILLER_0_29_337 VPWR VGND VPWR VGND sky130_ef_sc_hd__decap_12
XFILLER_0_29_304 VGND VGND VPWR VPWR sky130_fd_sc_hd__fill_1
XFILLER_0_8_209 VPWR VGND VPWR VGND sky130_ef_sc_hd__decap_12
XFILLER_0_71_159 VGND VGND VPWR VPWR sky130_fd_sc_hd__decap_8
XFILLER_0_71_137 VGND VGND VPWR VPWR sky130_fd_sc_hd__decap_3
X_1841_ _0478_ _0496_ _0489_ _0620_ VGND VGND VPWR VPWR _0657_ sky130_fd_sc_hd__o2bb2a_2
XFILLER_0_37_381 VGND VGND VPWR VPWR sky130_fd_sc_hd__decap_8
XFILLER_0_8_15 VPWR VGND VPWR VGND sky130_ef_sc_hd__decap_12
X_1772_ _0566_ _0587_ VGND VGND VPWR VPWR _0588_ sky130_fd_sc_hd__and2_1
X_2324_ _0808_ _1131_ _0805_ VGND VGND VPWR VPWR _1132_ sky130_fd_sc_hd__o21ai_1
X_2186_ _0737_ _0734_ _0878_ VGND VGND VPWR VPWR _1000_ sky130_fd_sc_hd__mux2_1
X_2255_ _0894_ _0904_ _0910_ VGND VGND VPWR VPWR _1067_ sky130_fd_sc_hd__a21o_1
XFILLER_0_62_137 VGND VGND VPWR VPWR sky130_fd_sc_hd__decap_3
XFILLER_0_28_392 VGND VGND VPWR VPWR sky130_fd_sc_hd__fill_1
XFILLER_0_50_80 VGND VGND VPWR VPWR sky130_fd_sc_hd__decap_4
XFILLER_0_43_373 VGND VGND VPWR VPWR sky130_fd_sc_hd__decap_3
XFILLER_0_66_421 VPWR VGND VPWR VGND sky130_ef_sc_hd__decap_12
XTAP_TAPCELL_ROW_54_585 VGND VPWR sky130_fd_sc_hd__tapvpwrvgnd_1
XFILLER_0_38_101 VGND VGND VPWR VPWR sky130_fd_sc_hd__decap_3
XFILLER_0_14_29 VPWR VGND VPWR VGND sky130_ef_sc_hd__decap_12
XFILLER_0_61_181 VGND VGND VPWR VPWR sky130_fd_sc_hd__decap_8
XFILLER_0_26_307 VGND VGND VPWR VPWR sky130_fd_sc_hd__fill_1
XFILLER_0_39_15 VPWR VGND VPWR VGND sky130_ef_sc_hd__decap_12
XFILLER_0_1_429 VPWR VGND VPWR VGND sky130_ef_sc_hd__decap_12
X_2040_ _0592_ _0594_ _0601_ VGND VGND VPWR VPWR _0856_ sky130_fd_sc_hd__or3b_1
XFILLER_0_71_57 VPWR VGND VPWR VGND sky130_ef_sc_hd__decap_12
XFILLER_0_69_281 VPWR VGND VPWR VGND sky130_ef_sc_hd__decap_12
X_2873_ _1464_ VGND VGND VPWR VPWR _0122_ sky130_fd_sc_hd__inv_2
X_2942_ _1472_ VGND VGND VPWR VPWR _1473_ sky130_fd_sc_hd__buf_1
XFILLER_0_29_101 VGND VGND VPWR VPWR sky130_fd_sc_hd__fill_2
X_1686_ _0498_ _0484_ _0500_ _0501_ VGND VGND VPWR VPWR _0502_ sky130_fd_sc_hd__o22a_4
X_1824_ net21 _0639_ VGND VGND VPWR VPWR _0640_ sky130_fd_sc_hd__xor2_1
XFILLER_0_40_365 VGND VGND VPWR VPWR sky130_fd_sc_hd__decap_6
XFILLER_0_40_354 VGND VGND VPWR VPWR sky130_fd_sc_hd__fill_1
X_1755_ reg_file.registers\[15\]\[20\] _0569_ _0570_ reg_file.registers\[5\]\[20\]
+ VGND VGND VPWR VPWR _0571_ sky130_fd_sc_hd__a22o_1
XFILLER_0_4_289 VPWR VGND VPWR VGND sky130_ef_sc_hd__decap_12
XFILLER_0_4_245 VGND VGND VPWR VPWR sky130_fd_sc_hd__decap_6
XFILLER_0_20_83 VGND VGND VPWR VPWR sky130_fd_sc_hd__fill_1
X_2307_ _1025_ _1030_ net37 VGND VGND VPWR VPWR _1116_ sky130_fd_sc_hd__mux2_1
XFILLER_0_31_3 VPWR VGND VPWR VGND sky130_ef_sc_hd__decap_12
X_2238_ _0834_ _0844_ VGND VGND VPWR VPWR _1050_ sky130_fd_sc_hd__nand2_1
XTAP_TAPCELL_ROW_68_699 VGND VPWR sky130_fd_sc_hd__tapvpwrvgnd_1
XFILLER_0_48_421 VGND VGND VPWR VPWR sky130_fd_sc_hd__decap_8
X_2169_ reg_file.registers\[11\]\[30\] _0983_ _0933_ VGND VGND VPWR VPWR _0984_ sky130_fd_sc_hd__mux2_1
XTAP_TAPCELL_ROW_0_144 VGND VPWR sky130_fd_sc_hd__tapvpwrvgnd_1
XTAP_TAPCELL_ROW_0_155 VGND VPWR sky130_fd_sc_hd__tapvpwrvgnd_1
XTAP_TAPCELL_ROW_51_566 VGND VPWR sky130_fd_sc_hd__tapvpwrvgnd_1
XFILLER_0_35_126 VPWR VGND VPWR VGND sky130_ef_sc_hd__decap_12
XTAP_TAPCELL_ROW_8_222 VGND VPWR sky130_fd_sc_hd__tapvpwrvgnd_1
XFILLER_0_25_39 VPWR VGND VPWR VGND sky130_ef_sc_hd__decap_12
XFILLER_0_58_218 VGND VGND VPWR VPWR sky130_fd_sc_hd__fill_1
XFILLER_0_41_27 VGND VGND VPWR VPWR sky130_fd_sc_hd__decap_3
XFILLER_0_39_421 VGND VGND VPWR VPWR sky130_fd_sc_hd__fill_1
XTAP_TAPCELL_ROW_14_268 VGND VPWR sky130_fd_sc_hd__tapvpwrvgnd_1
X_1540_ _0407_ VGND VGND VPWR VPWR _0336_ sky130_fd_sc_hd__clkbuf_1
XFILLER_0_22_321 VGND VGND VPWR VPWR sky130_fd_sc_hd__decap_8
XFILLER_0_1_237 VPWR VGND VPWR VGND sky130_ef_sc_hd__decap_12
XFILLER_0_5_27 VPWR VGND VPWR VGND sky130_ef_sc_hd__decap_12
X_3141_ clknet_leaf_14_clk _0023_ VGND VGND VPWR VPWR display.counter\[6\] sky130_fd_sc_hd__dfxtp_1
X_3072_ clknet_leaf_9_clk _0295_ _0131_ VGND VGND VPWR VPWR reg_file.registers\[10\]\[10\]
+ sky130_fd_sc_hd__dfrtp_1
X_2023_ _0819_ _0838_ VGND VGND VPWR VPWR _0839_ sky130_fd_sc_hd__nand2_1
X_1807_ reg_file.registers\[10\]\[15\] _0620_ _0622_ reg_file.registers\[11\]\[15\]
+ VGND VGND VPWR VPWR _0623_ sky130_fd_sc_hd__a22o_1
X_2925_ _1470_ VGND VGND VPWR VPWR _0168_ sky130_fd_sc_hd__inv_2
X_2856_ _1461_ VGND VGND VPWR VPWR _0108_ sky130_fd_sc_hd__inv_2
XFILLER_0_9_348 VGND VGND VPWR VPWR sky130_fd_sc_hd__fill_2
X_2787_ _1453_ VGND VGND VPWR VPWR _0047_ sky130_fd_sc_hd__inv_2
X_1669_ _0484_ VGND VGND VPWR VPWR _0485_ sky130_fd_sc_hd__buf_2
X_1738_ _0478_ _0553_ VGND VGND VPWR VPWR _0554_ sky130_fd_sc_hd__nand2_1
XFILLER_0_0_281 VPWR VGND VPWR VGND sky130_ef_sc_hd__decap_12
XFILLER_0_13_332 VGND VGND VPWR VPWR sky130_fd_sc_hd__decap_4
XTAP_TAPCELL_ROW_56_603 VGND VPWR sky130_fd_sc_hd__tapvpwrvgnd_1
XFILLER_0_63_221 VGND VGND VPWR VPWR sky130_fd_sc_hd__decap_3
XFILLER_0_48_262 VGND VGND VPWR VPWR sky130_fd_sc_hd__decap_6
XFILLER_0_48_240 VGND VGND VPWR VPWR sky130_fd_sc_hd__decap_4
XFILLER_0_36_446 VGND VGND VPWR VPWR sky130_fd_sc_hd__fill_2
XFILLER_0_51_449 VGND VGND VPWR VPWR sky130_fd_sc_hd__fill_2
XFILLER_0_51_405 VGND VGND VPWR VPWR sky130_fd_sc_hd__decap_6
XFILLER_0_36_27 VGND VGND VPWR VPWR sky130_fd_sc_hd__fill_1
XFILLER_0_52_15 VPWR VGND VPWR VGND sky130_ef_sc_hd__decap_12
XTAP_TAPCELL_ROW_19_305 VGND VPWR sky130_fd_sc_hd__tapvpwrvgnd_1
XTAP_TAPCELL_ROW_27_371 VGND VPWR sky130_fd_sc_hd__tapvpwrvgnd_1
XFILLER_0_6_307 VGND VGND VPWR VPWR sky130_fd_sc_hd__fill_1
X_2710_ _1421_ VGND VGND VPWR VPWR _0006_ sky130_fd_sc_hd__clkbuf_1
X_2572_ imem.address\[9\] _1323_ VGND VGND VPWR VPWR _1324_ sky130_fd_sc_hd__and2_1
X_2641_ display.digit_sel\[2\] _1362_ VGND VGND VPWR VPWR _0362_ sky130_fd_sc_hd__nand2_1
XFILLER_0_10_346 VPWR VGND VPWR VGND sky130_ef_sc_hd__decap_12
X_1523_ _0398_ VGND VGND VPWR VPWR _0344_ sky130_fd_sc_hd__clkbuf_1
X_3124_ clknet_leaf_0_clk _0347_ _0183_ VGND VGND VPWR VPWR reg_file.registers\[5\]\[30\]
+ sky130_fd_sc_hd__dfrtp_1
X_3055_ clknet_leaf_16_clk _0278_ _0114_ VGND VGND VPWR VPWR reg_file.registers\[11\]\[25\]
+ sky130_fd_sc_hd__dfrtp_1
XFILLER_0_9_167 VGND VGND VPWR VPWR sky130_fd_sc_hd__fill_1
X_2006_ _0819_ _0820_ VGND VGND VPWR VPWR _0822_ sky130_fd_sc_hd__nand2_1
XFILLER_0_60_279 VGND VGND VPWR VPWR sky130_fd_sc_hd__fill_2
XFILLER_0_60_202 VGND VGND VPWR VPWR sky130_fd_sc_hd__decap_3
X_2839_ _1460_ VGND VGND VPWR VPWR _0092_ sky130_fd_sc_hd__inv_2
X_2908_ _1468_ VGND VGND VPWR VPWR _1469_ sky130_fd_sc_hd__buf_4
XFILLER_0_33_449 VGND VGND VPWR VPWR sky130_fd_sc_hd__fill_2
XFILLER_0_33_405 VPWR VGND VPWR VGND sky130_ef_sc_hd__decap_12
XFILLER_0_5_373 VPWR VGND VPWR VGND sky130_ef_sc_hd__decap_12
XFILLER_0_13_140 VGND VGND VPWR VPWR sky130_fd_sc_hd__decap_8
XFILLER_0_68_357 VGND VGND VPWR VPWR sky130_fd_sc_hd__decap_6
XFILLER_0_36_243 VGND VGND VPWR VPWR sky130_fd_sc_hd__decap_6
XFILLER_0_22_29 VPWR VGND VPWR VGND sky130_ef_sc_hd__decap_12
XFILLER_0_47_15 VPWR VGND VPWR VGND sky130_ef_sc_hd__decap_12
XFILLER_0_59_357 VGND VGND VPWR VPWR sky130_fd_sc_hd__decap_8
X_2624_ imem.address\[9\] _1323_ VGND VGND VPWR VPWR _1354_ sky130_fd_sc_hd__nor2_1
XFILLER_0_42_224 VPWR VGND VPWR VGND sky130_ef_sc_hd__decap_12
XFILLER_0_42_213 VGND VGND VPWR VPWR sky130_fd_sc_hd__fill_2
XTAP_TAPCELL_ROW_30_399 VGND VPWR sky130_fd_sc_hd__tapvpwrvgnd_1
XFILLER_0_30_419 VGND VGND VPWR VPWR sky130_fd_sc_hd__fill_1
XFILLER_0_2_321 VPWR VGND VPWR VGND sky130_ef_sc_hd__decap_12
XFILLER_0_15_449 VGND VGND VPWR VPWR sky130_fd_sc_hd__fill_2
XFILLER_0_63_6 VPWR VGND VPWR VGND sky130_ef_sc_hd__decap_12
X_1506_ _0382_ _0383_ _0384_ _0385_ VGND VGND VPWR VPWR _0386_ sky130_fd_sc_hd__and4bb_2
X_2486_ _1272_ VGND VGND VPWR VPWR _0255_ sky130_fd_sc_hd__clkbuf_1
X_2555_ reg_file.registers\[15\]\[6\] _1304_ VGND VGND VPWR VPWR _1314_ sky130_fd_sc_hd__and2_1
XFILLER_0_2_365 VPWR VGND VPWR VGND sky130_ef_sc_hd__decap_12
XFILLER_0_10_121 VPWR VGND VPWR VGND sky130_ef_sc_hd__decap_12
XFILLER_0_10_165 VPWR VGND VPWR VGND sky130_ef_sc_hd__decap_12
X_3038_ clknet_leaf_10_clk _0261_ _0097_ VGND VGND VPWR VPWR reg_file.registers\[11\]\[8\]
+ sky130_fd_sc_hd__dfrtp_1
X_3107_ clknet_leaf_21_clk _0330_ _0166_ VGND VGND VPWR VPWR reg_file.registers\[5\]\[13\]
+ sky130_fd_sc_hd__dfrtp_1
XFILLER_0_65_349 VPWR VGND VPWR VGND sky130_ef_sc_hd__decap_12
XFILLER_0_65_305 VGND VGND VPWR VPWR sky130_fd_sc_hd__decap_3
XFILLER_0_33_202 VGND VGND VPWR VPWR sky130_fd_sc_hd__decap_8
XTAP_TAPCELL_ROW_21_322 VGND VPWR sky130_fd_sc_hd__tapvpwrvgnd_1
XFILLER_0_5_181 VPWR VGND VPWR VGND sky130_ef_sc_hd__decap_12
XFILLER_0_56_338 VGND VGND VPWR VPWR sky130_fd_sc_hd__decap_4
XFILLER_0_64_393 VPWR VGND VPWR VGND sky130_ef_sc_hd__decap_12
X_2271_ reg_file.registers\[11\]\[11\] _0828_ _0829_ reg_file.registers\[10\]\[11\]
+ VGND VGND VPWR VPWR _1083_ sky130_fd_sc_hd__a22o_1
X_2340_ _0782_ _1132_ VGND VGND VPWR VPWR _1147_ sky130_fd_sc_hd__nand2_1
XFILLER_0_47_349 VGND VGND VPWR VPWR sky130_fd_sc_hd__decap_4
XTAP_TAPCELL_ROW_35_436 VGND VPWR sky130_fd_sc_hd__tapvpwrvgnd_1
X_1986_ reg_file.registers\[10\]\[22\] _0605_ _0610_ reg_file.registers\[11\]\[22\]
+ VGND VGND VPWR VPWR _0802_ sky130_fd_sc_hd__a22o_1
XFILLER_0_70_363 VGND VGND VPWR VPWR sky130_fd_sc_hd__fill_1
Xclkbuf_leaf_9_clk clknet_1_1__leaf_clk VGND VGND VPWR VPWR clknet_leaf_9_clk sky130_fd_sc_hd__clkbuf_8
X_2607_ _1331_ _1347_ VGND VGND VPWR VPWR _0209_ sky130_fd_sc_hd__nor2_1
XFILLER_0_61_3 VPWR VGND VPWR VGND sky130_ef_sc_hd__decap_12
XFILLER_0_30_238 VPWR VGND VPWR VGND sky130_ef_sc_hd__decap_12
XFILLER_0_15_279 VGND VGND VPWR VPWR sky130_fd_sc_hd__fill_1
X_2469_ _0664_ _1257_ _1256_ _0694_ VGND VGND VPWR VPWR _1259_ sky130_fd_sc_hd__o211ai_1
X_2538_ _1305_ VGND VGND VPWR VPWR _0236_ sky130_fd_sc_hd__clkbuf_1
XFILLER_0_2_195 VGND VGND VPWR VPWR sky130_fd_sc_hd__fill_1
XFILLER_0_65_113 VPWR VGND VPWR VGND sky130_ef_sc_hd__decap_12
XFILLER_0_38_305 VGND VGND VPWR VPWR sky130_fd_sc_hd__decap_3
XFILLER_0_3_93 VPWR VGND VPWR VGND sky130_ef_sc_hd__decap_12
XFILLER_0_38_349 VGND VGND VPWR VPWR sky130_fd_sc_hd__fill_2
XFILLER_0_44_27 VGND VGND VPWR VPWR sky130_fd_sc_hd__fill_1
XFILLER_0_69_441 VGND VGND VPWR VPWR sky130_fd_sc_hd__decap_6
XFILLER_0_60_15 VPWR VGND VPWR VGND sky130_ef_sc_hd__decap_12
XFILLER_0_56_168 VGND VGND VPWR VPWR sky130_fd_sc_hd__decap_8
X_1840_ _0654_ _0655_ VGND VGND VPWR VPWR _0656_ sky130_fd_sc_hd__nand2_1
XFILLER_0_29_349 VGND VGND VPWR VPWR sky130_fd_sc_hd__fill_1
XFILLER_0_69_57 VPWR VGND VPWR VGND sky130_ef_sc_hd__decap_12
XTAP_TAPCELL_ROW_40_472 VGND VPWR sky130_fd_sc_hd__tapvpwrvgnd_1
XFILLER_0_37_393 VPWR VGND VPWR VGND sky130_ef_sc_hd__decap_12
XFILLER_0_37_371 VGND VGND VPWR VPWR sky130_fd_sc_hd__decap_6
XFILLER_0_8_27 VGND VGND VPWR VPWR sky130_fd_sc_hd__fill_1
X_1771_ reg_file.registers\[15\]\[27\] _0569_ _0570_ reg_file.registers\[5\]\[27\]
+ VGND VGND VPWR VPWR _0587_ sky130_fd_sc_hd__a22o_1
X_2254_ _0994_ _0986_ _0903_ VGND VGND VPWR VPWR _1066_ sky130_fd_sc_hd__mux2_1
X_2323_ _1129_ _1130_ _0786_ VGND VGND VPWR VPWR _1131_ sky130_fd_sc_hd__o21a_1
XFILLER_0_20_282 VGND VGND VPWR VPWR sky130_fd_sc_hd__decap_6
X_2185_ _0645_ _0741_ _0871_ VGND VGND VPWR VPWR _0999_ sky130_fd_sc_hd__mux2_1
XFILLER_0_18_83 VGND VGND VPWR VPWR sky130_fd_sc_hd__fill_1
XFILLER_0_47_179 VGND VGND VPWR VPWR sky130_fd_sc_hd__decap_8
XFILLER_0_35_319 VGND VGND VPWR VPWR sky130_fd_sc_hd__fill_1
X_1969_ reg_file.registers\[10\]\[20\] _0603_ _0608_ reg_file.registers\[11\]\[20\]
+ VGND VGND VPWR VPWR _0785_ sky130_fd_sc_hd__a22o_1
XFILLER_0_66_433 VPWR VGND VPWR VGND sky130_ef_sc_hd__decap_12
XTAP_TAPCELL_ROW_54_586 VGND VPWR sky130_fd_sc_hd__tapvpwrvgnd_1
XFILLER_0_19_360 VGND VGND VPWR VPWR sky130_fd_sc_hd__fill_1
XFILLER_0_53_138 VGND VGND VPWR VPWR sky130_fd_sc_hd__decap_3
XFILLER_0_30_29 VPWR VGND VPWR VGND sky130_ef_sc_hd__decap_12
XFILLER_0_19_393 VPWR VGND VPWR VGND sky130_ef_sc_hd__decap_12
XFILLER_0_55_15 VGND VGND VPWR VPWR sky130_fd_sc_hd__decap_8
XFILLER_0_39_27 VGND VGND VPWR VPWR sky130_fd_sc_hd__decap_3
XFILLER_0_71_69 VPWR VGND VPWR VGND sky130_ef_sc_hd__decap_12
XFILLER_0_69_293 VPWR VGND VPWR VGND sky130_ef_sc_hd__decap_12
X_2872_ _1464_ VGND VGND VPWR VPWR _0121_ sky130_fd_sc_hd__inv_2
X_1823_ _0638_ _0548_ VGND VGND VPWR VPWR _0639_ sky130_fd_sc_hd__nand2_1
X_2941_ reset VGND VGND VPWR VPWR _1472_ sky130_fd_sc_hd__buf_1
XFILLER_0_29_113 VGND VGND VPWR VPWR sky130_fd_sc_hd__fill_2
XTAP_TAPCELL_ROW_17_288 VGND VPWR sky130_fd_sc_hd__tapvpwrvgnd_1
X_1685_ _0390_ _0476_ VGND VGND VPWR VPWR _0501_ sky130_fd_sc_hd__nor2_2
X_1754_ _0537_ VGND VGND VPWR VPWR _0570_ sky130_fd_sc_hd__buf_2
XFILLER_0_29_60 VGND VGND VPWR VPWR sky130_fd_sc_hd__decap_6
XFILLER_0_24_3 VPWR VGND VPWR VGND sky130_ef_sc_hd__decap_12
X_2237_ _0831_ _0842_ VGND VGND VPWR VPWR _1049_ sky130_fd_sc_hd__or2b_1
X_2306_ _0793_ _0810_ _0823_ VGND VGND VPWR VPWR _1115_ sky130_fd_sc_hd__nand3_1
XFILLER_0_45_70 VGND VGND VPWR VPWR sky130_fd_sc_hd__decap_8
X_2099_ _0913_ _0914_ _0903_ VGND VGND VPWR VPWR _0915_ sky130_fd_sc_hd__mux2_1
X_2168_ _0472_ _0855_ _0935_ _0982_ VGND VGND VPWR VPWR _0983_ sky130_fd_sc_hd__a31o_1
XTAP_TAPCELL_ROW_0_156 VGND VPWR sky130_fd_sc_hd__tapvpwrvgnd_1
XTAP_TAPCELL_ROW_0_145 VGND VPWR sky130_fd_sc_hd__tapvpwrvgnd_1
XFILLER_0_63_447 VGND VGND VPWR VPWR sky130_fd_sc_hd__fill_1
XTAP_TAPCELL_ROW_51_567 VGND VPWR sky130_fd_sc_hd__tapvpwrvgnd_1
XFILLER_0_35_138 VGND VGND VPWR VPWR sky130_fd_sc_hd__fill_1
XFILLER_0_35_116 VGND VGND VPWR VPWR sky130_fd_sc_hd__decap_6
XFILLER_0_9_81 VPWR VGND VPWR VGND sky130_ef_sc_hd__decap_12
XPHY_EDGE_ROW_17_Right_17 VGND VGND VPWR VPWR sky130_fd_sc_hd__decap_3
XFILLER_0_31_355 VGND VGND VPWR VPWR sky130_fd_sc_hd__fill_1
XPHY_EDGE_ROW_26_Right_26 VGND VGND VPWR VPWR sky130_fd_sc_hd__decap_3
XTAP_TAPCELL_ROW_8_223 VGND VPWR sky130_fd_sc_hd__tapvpwrvgnd_1
XPHY_EDGE_ROW_35_Right_35 VGND VGND VPWR VPWR sky130_fd_sc_hd__decap_3
XTAP_TAPCELL_ROW_14_269 VGND VPWR sky130_fd_sc_hd__tapvpwrvgnd_1
XFILLER_0_41_119 VPWR VGND VPWR VGND sky130_ef_sc_hd__decap_12
XFILLER_0_1_205 VPWR VGND VPWR VGND sky130_ef_sc_hd__decap_12
XFILLER_0_1_249 VPWR VGND VPWR VGND sky130_ef_sc_hd__decap_12
X_3071_ clknet_leaf_9_clk _0294_ _0130_ VGND VGND VPWR VPWR reg_file.registers\[10\]\[9\]
+ sky130_fd_sc_hd__dfrtp_1
XPHY_EDGE_ROW_44_Right_44 VGND VGND VPWR VPWR sky130_fd_sc_hd__decap_3
XFILLER_0_5_39 VPWR VGND VPWR VGND sky130_ef_sc_hd__decap_12
X_3140_ clknet_leaf_14_clk _0022_ VGND VGND VPWR VPWR display.counter\[5\] sky130_fd_sc_hd__dfxtp_1
XPHY_EDGE_ROW_53_Right_53 VGND VGND VPWR VPWR sky130_fd_sc_hd__decap_3
X_2022_ reg_file.registers\[10\]\[24\] _0605_ _0610_ reg_file.registers\[11\]\[24\]
+ VGND VGND VPWR VPWR _0838_ sky130_fd_sc_hd__a22o_1
XFILLER_0_15_51 VGND VGND VPWR VPWR sky130_fd_sc_hd__decap_4
XFILLER_0_60_406 VPWR VGND VPWR VGND sky130_ef_sc_hd__decap_12
X_2786_ _1450_ VGND VGND VPWR VPWR _1453_ sky130_fd_sc_hd__buf_4
X_1806_ _0621_ VGND VGND VPWR VPWR _0622_ sky130_fd_sc_hd__buf_2
X_2924_ _1470_ VGND VGND VPWR VPWR _0167_ sky130_fd_sc_hd__inv_2
X_2855_ _1461_ VGND VGND VPWR VPWR _0107_ sky130_fd_sc_hd__inv_2
XFILLER_0_25_182 VPWR VGND VPWR VGND sky130_ef_sc_hd__decap_12
XPHY_EDGE_ROW_17_Left_89 VGND VGND VPWR VPWR sky130_fd_sc_hd__decap_3
XPHY_EDGE_ROW_62_Right_62 VGND VGND VPWR VPWR sky130_fd_sc_hd__decap_3
X_1668_ _0483_ VGND VGND VPWR VPWR _0484_ sky130_fd_sc_hd__buf_2
XFILLER_0_40_141 VGND VGND VPWR VPWR sky130_fd_sc_hd__fill_2
X_1737_ reg_file.registers\[15\]\[16\] _0543_ _0537_ reg_file.registers\[5\]\[16\]
+ VGND VGND VPWR VPWR _0553_ sky130_fd_sc_hd__a22o_1
XFILLER_0_0_293 VPWR VGND VPWR VGND sky130_ef_sc_hd__decap_12
X_1599_ reg_file.registers\[10\]\[23\] _0438_ VGND VGND VPWR VPWR _0439_ sky130_fd_sc_hd__and2_1
XTAP_TAPCELL_ROW_56_604 VGND VPWR sky130_fd_sc_hd__tapvpwrvgnd_1
XPHY_EDGE_ROW_71_Right_71 VGND VGND VPWR VPWR sky130_fd_sc_hd__decap_3
XTAP_TAPCELL_ROW_64_670 VGND VPWR sky130_fd_sc_hd__tapvpwrvgnd_1
XFILLER_0_23_119 VGND VGND VPWR VPWR sky130_fd_sc_hd__fill_2
XFILLER_0_52_27 VGND VGND VPWR VPWR sky130_fd_sc_hd__fill_1
XTAP_TAPCELL_ROW_27_372 VGND VPWR sky130_fd_sc_hd__tapvpwrvgnd_1
XTAP_TAPCELL_ROW_19_306 VGND VPWR sky130_fd_sc_hd__tapvpwrvgnd_1
X_2640_ display.digit_sel\[1\] display.digit_sel\[0\] VGND VGND VPWR VPWR _1362_ sky130_fd_sc_hd__nor2_1
XFILLER_0_39_274 VGND VGND VPWR VPWR sky130_fd_sc_hd__decap_6
XFILLER_0_27_425 VPWR VGND VPWR VGND sky130_ef_sc_hd__decap_12
XFILLER_0_27_414 VGND VGND VPWR VPWR sky130_fd_sc_hd__decap_6
X_2571_ imem.address\[8\] imem.address\[7\] _1322_ VGND VGND VPWR VPWR _1323_ sky130_fd_sc_hd__and3_1
XFILLER_0_10_358 VGND VGND VPWR VPWR sky130_fd_sc_hd__decap_6
X_1522_ reg_file.registers\[5\]\[27\] _0393_ VGND VGND VPWR VPWR _0398_ sky130_fd_sc_hd__and2_1
XFILLER_0_22_130 VGND VGND VPWR VPWR sky130_fd_sc_hd__fill_1
XFILLER_0_26_72 VGND VGND VPWR VPWR sky130_fd_sc_hd__decap_3
X_3054_ clknet_leaf_14_clk _0277_ _0113_ VGND VGND VPWR VPWR reg_file.registers\[11\]\[24\]
+ sky130_fd_sc_hd__dfrtp_1
X_2005_ _0819_ _0820_ VGND VGND VPWR VPWR _0821_ sky130_fd_sc_hd__or2_1
X_3123_ clknet_leaf_20_clk _0346_ _0182_ VGND VGND VPWR VPWR reg_file.registers\[5\]\[29\]
+ sky130_fd_sc_hd__dfrtp_1
XTAP_TAPCELL_ROW_61_640 VGND VPWR sky130_fd_sc_hd__tapvpwrvgnd_1
X_2907_ _1449_ VGND VGND VPWR VPWR _1468_ sky130_fd_sc_hd__buf_1
XFILLER_0_9_113 VPWR VGND VPWR VGND sky130_ef_sc_hd__decap_12
X_2769_ _1451_ VGND VGND VPWR VPWR _0031_ sky130_fd_sc_hd__inv_2
XFILLER_0_60_236 VGND VGND VPWR VPWR sky130_fd_sc_hd__decap_6
X_2838_ _1460_ VGND VGND VPWR VPWR _0091_ sky130_fd_sc_hd__inv_2
XFILLER_0_33_417 VGND VGND VPWR VPWR sky130_fd_sc_hd__fill_1
XFILLER_0_5_385 VGND VGND VPWR VPWR sky130_fd_sc_hd__decap_6
XFILLER_0_51_225 VPWR VGND VPWR VGND sky130_ef_sc_hd__decap_12
XFILLER_0_51_214 VGND VGND VPWR VPWR sky130_fd_sc_hd__decap_8
XFILLER_0_47_27 VGND VGND VPWR VPWR sky130_fd_sc_hd__decap_3
XFILLER_0_2_29 VPWR VGND VPWR VGND sky130_ef_sc_hd__decap_12
XFILLER_0_67_391 VGND VGND VPWR VPWR sky130_fd_sc_hd__fill_1
X_2623_ imem.address\[10\] _1324_ VGND VGND VPWR VPWR _0199_ sky130_fd_sc_hd__xor2_1
X_2554_ _1313_ VGND VGND VPWR VPWR _0228_ sky130_fd_sc_hd__clkbuf_1
XFILLER_0_42_236 VPWR VGND VPWR VGND sky130_ef_sc_hd__decap_12
XFILLER_0_2_333 VPWR VGND VPWR VGND sky130_ef_sc_hd__decap_12
XFILLER_0_12_41 VPWR VGND VPWR VGND sky130_ef_sc_hd__decap_12
XFILLER_0_12_85 VPWR VGND VPWR VGND sky130_ef_sc_hd__decap_12
X_1505_ imem.address\[21\] imem.address\[20\] imem.address\[19\] imem.address\[18\]
+ VGND VGND VPWR VPWR _0385_ sky130_fd_sc_hd__nor4_1
X_2485_ reg_file.registers\[11\]\[2\] _1271_ _1234_ VGND VGND VPWR VPWR _1272_ sky130_fd_sc_hd__mux2_1
XFILLER_0_50_280 VGND VGND VPWR VPWR sky130_fd_sc_hd__decap_3
XFILLER_0_37_60 VGND VGND VPWR VPWR sky130_fd_sc_hd__decap_3
XPHY_EDGE_ROW_34_Left_106 VGND VGND VPWR VPWR sky130_fd_sc_hd__decap_3
XFILLER_0_2_377 VPWR VGND VPWR VGND sky130_ef_sc_hd__decap_12
XFILLER_0_10_133 VGND VGND VPWR VPWR sky130_fd_sc_hd__decap_6
XFILLER_0_10_177 VPWR VGND VPWR VGND sky130_ef_sc_hd__decap_12
X_3037_ clknet_leaf_10_clk _0260_ _0096_ VGND VGND VPWR VPWR reg_file.registers\[11\]\[7\]
+ sky130_fd_sc_hd__dfrtp_1
XPHY_EDGE_ROW_43_Left_115 VGND VGND VPWR VPWR sky130_fd_sc_hd__decap_3
X_3106_ clknet_leaf_3_clk _0329_ _0165_ VGND VGND VPWR VPWR reg_file.registers\[5\]\[12\]
+ sky130_fd_sc_hd__dfrtp_1
XTAP_TAPCELL_ROW_38_456 VGND VPWR sky130_fd_sc_hd__tapvpwrvgnd_1
XFILLER_0_65_328 VGND VGND VPWR VPWR sky130_fd_sc_hd__decap_8
XFILLER_0_33_225 VPWR VGND VPWR VGND sky130_ef_sc_hd__decap_12
XFILLER_0_18_288 VGND VGND VPWR VPWR sky130_fd_sc_hd__fill_2
XTAP_TAPCELL_ROW_21_323 VGND VPWR sky130_fd_sc_hd__tapvpwrvgnd_1
XPHY_EDGE_ROW_52_Left_124 VGND VGND VPWR VPWR sky130_fd_sc_hd__decap_3
XFILLER_0_5_193 VPWR VGND VPWR VGND sky130_ef_sc_hd__decap_12
XFILLER_0_14_450 VGND VGND VPWR VPWR sky130_fd_sc_hd__fill_1
XFILLER_0_21_409 VGND VGND VPWR VPWR sky130_fd_sc_hd__fill_2
XPHY_EDGE_ROW_61_Left_133 VGND VGND VPWR VPWR sky130_fd_sc_hd__decap_3
XFILLER_0_56_306 VGND VGND VPWR VPWR sky130_fd_sc_hd__fill_2
XFILLER_0_49_380 VGND VGND VPWR VPWR sky130_fd_sc_hd__decap_3
XFILLER_0_71_309 VPWR VGND VPWR VGND sky130_ef_sc_hd__decap_12
XPHY_EDGE_ROW_70_Left_142 VGND VGND VPWR VPWR sky130_fd_sc_hd__decap_3
XFILLER_0_24_269 VGND VGND VPWR VPWR sky130_fd_sc_hd__decap_3
X_2270_ _1080_ _1081_ _0878_ VGND VGND VPWR VPWR _1082_ sky130_fd_sc_hd__mux2_1
XFILLER_0_58_15 VPWR VGND VPWR VGND sky130_ef_sc_hd__decap_12
XFILLER_0_20_442 VGND VGND VPWR VPWR sky130_fd_sc_hd__decap_6
XTAP_TAPCELL_ROW_35_437 VGND VPWR sky130_fd_sc_hd__tapvpwrvgnd_1
XFILLER_0_47_317 VGND VGND VPWR VPWR sky130_fd_sc_hd__decap_4
XFILLER_0_23_51 VGND VGND VPWR VPWR sky130_fd_sc_hd__decap_4
XFILLER_0_7_447 VGND VGND VPWR VPWR sky130_fd_sc_hd__fill_1
XFILLER_0_15_225 VGND VGND VPWR VPWR sky130_fd_sc_hd__decap_4
X_1985_ reg_file.registers\[10\]\[23\] _0605_ _0610_ reg_file.registers\[11\]\[23\]
+ VGND VGND VPWR VPWR _0801_ sky130_fd_sc_hd__a22o_1
X_2606_ imem.address\[19\] _1330_ imem.address\[20\] VGND VGND VPWR VPWR _1347_ sky130_fd_sc_hd__a21oi_1
X_2537_ reg_file.registers\[15\]\[15\] _1304_ VGND VGND VPWR VPWR _1305_ sky130_fd_sc_hd__and2_1
XFILLER_0_2_141 VPWR VGND VPWR VGND sky130_ef_sc_hd__decap_12
XFILLER_0_11_442 VGND VGND VPWR VPWR sky130_fd_sc_hd__decap_3
XFILLER_0_54_3 VPWR VGND VPWR VGND sky130_ef_sc_hd__decap_12
X_2468_ _0694_ _1256_ _1257_ _0664_ VGND VGND VPWR VPWR _1258_ sky130_fd_sc_hd__a211o_1
X_2399_ _1197_ _1198_ _0898_ VGND VGND VPWR VPWR _1199_ sky130_fd_sc_hd__mux2_1
XFILLER_0_65_125 VPWR VGND VPWR VGND sky130_ef_sc_hd__decap_12
XFILLER_0_38_317 VGND VGND VPWR VPWR sky130_fd_sc_hd__decap_8
XFILLER_0_65_169 VGND VGND VPWR VPWR sky130_fd_sc_hd__fill_2
XFILLER_0_28_29 VPWR VGND VPWR VGND sky130_ef_sc_hd__decap_12
XPHY_EDGE_ROW_5_Left_77 VGND VGND VPWR VPWR sky130_fd_sc_hd__decap_3
XFILLER_0_60_27 VGND VGND VPWR VPWR sky130_fd_sc_hd__fill_1
XFILLER_0_44_309 VGND VGND VPWR VPWR sky130_fd_sc_hd__decap_8
XFILLER_0_37_350 VGND VGND VPWR VPWR sky130_fd_sc_hd__fill_1
X_1770_ _0585_ VGND VGND VPWR VPWR _0586_ sky130_fd_sc_hd__inv_2
XFILLER_0_69_69 VPWR VGND VPWR VGND sky130_ef_sc_hd__decap_12
XTAP_TAPCELL_ROW_40_473 VGND VPWR sky130_fd_sc_hd__tapvpwrvgnd_1
X_2322_ _0730_ _0745_ _0770_ _0751_ VGND VGND VPWR VPWR _1130_ sky130_fd_sc_hd__o211a_1
X_2253_ _0866_ _1064_ VGND VGND VPWR VPWR _1065_ sky130_fd_sc_hd__or2_1
X_2184_ _0898_ _0995_ _0996_ _0997_ _0910_ VGND VGND VPWR VPWR _0998_ sky130_fd_sc_hd__a221o_1
XTAP_TAPCELL_ROW_48_540 VGND VPWR sky130_fd_sc_hd__tapvpwrvgnd_1
XFILLER_0_47_103 VGND VGND VPWR VPWR sky130_fd_sc_hd__decap_6
X_1899_ _0713_ _0714_ VGND VGND VPWR VPWR _0715_ sky130_fd_sc_hd__nor2_1
XFILLER_0_47_169 VGND VGND VPWR VPWR sky130_fd_sc_hd__fill_1
XFILLER_0_43_320 VPWR VGND VPWR VGND sky130_ef_sc_hd__decap_12
X_1968_ _0565_ _0783_ VGND VGND VPWR VPWR _0784_ sky130_fd_sc_hd__xor2_2
XTAP_TAPCELL_ROW_3_176 VGND VPWR sky130_fd_sc_hd__tapvpwrvgnd_1
XFILLER_0_66_445 VGND VGND VPWR VPWR sky130_fd_sc_hd__decap_3
XFILLER_0_66_401 VPWR VGND VPWR VGND sky130_ef_sc_hd__decap_12
XTAP_TAPCELL_ROW_54_587 VGND VPWR sky130_fd_sc_hd__tapvpwrvgnd_1
XFILLER_0_26_309 VGND VGND VPWR VPWR sky130_fd_sc_hd__decap_4
XFILLER_0_34_386 VPWR VGND VPWR VGND sky130_ef_sc_hd__decap_12
XFILLER_0_34_353 VGND VGND VPWR VPWR sky130_fd_sc_hd__decap_8
XFILLER_0_71_15 VPWR VGND VPWR VGND sky130_ef_sc_hd__decap_12
XFILLER_0_69_261 VPWR VGND VPWR VGND sky130_ef_sc_hd__decap_12
X_2940_ _1471_ VGND VGND VPWR VPWR _0182_ sky130_fd_sc_hd__inv_2
X_2871_ _1462_ VGND VGND VPWR VPWR _1464_ sky130_fd_sc_hd__buf_4
X_1822_ _0517_ _0518_ _0378_ _0481_ VGND VGND VPWR VPWR _0638_ sky130_fd_sc_hd__nand4_2
X_1753_ _0543_ VGND VGND VPWR VPWR _0569_ sky130_fd_sc_hd__buf_2
XTAP_TAPCELL_ROW_17_289 VGND VPWR sky130_fd_sc_hd__tapvpwrvgnd_1
XFILLER_0_20_41 VPWR VGND VPWR VGND sky130_ef_sc_hd__decap_12
XFILLER_0_52_183 VPWR VGND VPWR VGND sky130_ef_sc_hd__decap_12
X_1684_ reg_file.registers\[15\]\[2\] _0484_ _0494_ reg_file.registers\[2\]\[2\] _0499_
+ VGND VGND VPWR VPWR _0500_ sky130_fd_sc_hd__a221o_2
XFILLER_0_20_85 VGND VGND VPWR VPWR sky130_fd_sc_hd__decap_6
XFILLER_0_45_60 VGND VGND VPWR VPWR sky130_fd_sc_hd__fill_2
X_2167_ _0940_ _0948_ _0956_ _0981_ _0937_ VGND VGND VPWR VPWR _0982_ sky130_fd_sc_hd__a32o_1
X_2305_ _1114_ VGND VGND VPWR VPWR _0278_ sky130_fd_sc_hd__clkbuf_1
X_2236_ _1048_ VGND VGND VPWR VPWR _0281_ sky130_fd_sc_hd__clkbuf_1
XFILLER_0_17_3 VPWR VGND VPWR VGND sky130_ef_sc_hd__decap_12
X_2098_ _0643_ _0649_ _0872_ VGND VGND VPWR VPWR _0914_ sky130_fd_sc_hd__mux2_1
XTAP_TAPCELL_ROW_0_157 VGND VPWR sky130_fd_sc_hd__tapvpwrvgnd_1
XTAP_TAPCELL_ROW_0_146 VGND VPWR sky130_fd_sc_hd__tapvpwrvgnd_1
XFILLER_0_31_345 VGND VGND VPWR VPWR sky130_fd_sc_hd__decap_4
XFILLER_0_9_93 VPWR VGND VPWR VGND sky130_ef_sc_hd__decap_12
XTAP_TAPCELL_ROW_59_624 VGND VPWR sky130_fd_sc_hd__tapvpwrvgnd_1
XTAP_TAPCELL_ROW_67_690 VGND VPWR sky130_fd_sc_hd__tapvpwrvgnd_1
XFILLER_0_39_445 VGND VGND VPWR VPWR sky130_fd_sc_hd__decap_3
XFILLER_0_66_253 VGND VGND VPWR VPWR sky130_fd_sc_hd__decap_6
XFILLER_0_66_15 VPWR VGND VPWR VGND sky130_ef_sc_hd__decap_12
XFILLER_0_1_217 VGND VGND VPWR VPWR sky130_fd_sc_hd__decap_6
X_3070_ clknet_leaf_9_clk _0293_ _0129_ VGND VGND VPWR VPWR reg_file.registers\[10\]\[8\]
+ sky130_fd_sc_hd__dfrtp_1
XPHY_EDGE_ROW_8_Left_80 VGND VGND VPWR VPWR sky130_fd_sc_hd__decap_3
X_2021_ _0813_ _0836_ VGND VGND VPWR VPWR _0837_ sky130_fd_sc_hd__nand2_1
X_2923_ _1470_ VGND VGND VPWR VPWR _0166_ sky130_fd_sc_hd__inv_2
XFILLER_0_9_317 VGND VGND VPWR VPWR sky130_fd_sc_hd__fill_1
X_2785_ _1452_ VGND VGND VPWR VPWR _0046_ sky130_fd_sc_hd__inv_2
XFILLER_0_60_418 VGND VGND VPWR VPWR sky130_fd_sc_hd__fill_2
X_1805_ _0519_ _0468_ VGND VGND VPWR VPWR _0621_ sky130_fd_sc_hd__or2_1
X_1736_ _0501_ _0544_ _0546_ _0551_ VGND VGND VPWR VPWR _0552_ sky130_fd_sc_hd__o211a_1
X_2854_ _1461_ VGND VGND VPWR VPWR _0106_ sky130_fd_sc_hd__inv_2
XFILLER_0_31_51 VGND VGND VPWR VPWR sky130_fd_sc_hd__fill_1
XFILLER_0_25_194 VGND VGND VPWR VPWR sky130_fd_sc_hd__decap_6
X_1598_ _0428_ VGND VGND VPWR VPWR _0438_ sky130_fd_sc_hd__buf_2
X_1667_ _0381_ net22 _0482_ VGND VGND VPWR VPWR _0483_ sky130_fd_sc_hd__and3_1
XFILLER_0_40_197 VGND VGND VPWR VPWR sky130_fd_sc_hd__fill_1
XFILLER_0_40_175 VGND VGND VPWR VPWR sky130_fd_sc_hd__fill_2
XTAP_TAPCELL_ROW_64_671 VGND VPWR sky130_fd_sc_hd__tapvpwrvgnd_1
XTAP_TAPCELL_ROW_56_605 VGND VPWR sky130_fd_sc_hd__tapvpwrvgnd_1
X_2219_ _0976_ _0959_ _0901_ VGND VGND VPWR VPWR _1032_ sky130_fd_sc_hd__mux2_1
XFILLER_0_63_278 VGND VGND VPWR VPWR sky130_fd_sc_hd__fill_2
XFILLER_0_48_275 VGND VGND VPWR VPWR sky130_fd_sc_hd__decap_4
XFILLER_0_48_253 VGND VGND VPWR VPWR sky130_fd_sc_hd__decap_4
XFILLER_0_8_372 VPWR VGND VPWR VGND sky130_ef_sc_hd__decap_12
XFILLER_0_6_3 VPWR VGND VPWR VGND sky130_ef_sc_hd__decap_12
XFILLER_0_36_29 VGND VGND VPWR VPWR sky130_fd_sc_hd__decap_8
XTAP_TAPCELL_ROW_19_307 VGND VPWR sky130_fd_sc_hd__tapvpwrvgnd_1
XTAP_TAPCELL_ROW_27_373 VGND VPWR sky130_fd_sc_hd__tapvpwrvgnd_1
X_2570_ imem.address\[6\] _1321_ VGND VGND VPWR VPWR _1322_ sky130_fd_sc_hd__and2_1
XFILLER_0_27_437 VGND VGND VPWR VPWR sky130_fd_sc_hd__decap_8
XFILLER_0_6_309 VPWR VGND VPWR VGND sky130_ef_sc_hd__decap_12
X_1521_ _0397_ VGND VGND VPWR VPWR _0345_ sky130_fd_sc_hd__clkbuf_1
X_3122_ clknet_leaf_20_clk _0345_ _0181_ VGND VGND VPWR VPWR reg_file.registers\[5\]\[28\]
+ sky130_fd_sc_hd__dfrtp_1
X_2004_ reg_file.registers\[10\]\[24\] _0775_ _0776_ reg_file.registers\[11\]\[24\]
+ VGND VGND VPWR VPWR _0820_ sky130_fd_sc_hd__a22o_1
X_3053_ clknet_leaf_19_clk _0276_ _0112_ VGND VGND VPWR VPWR reg_file.registers\[11\]\[23\]
+ sky130_fd_sc_hd__dfrtp_1
XTAP_TAPCELL_ROW_61_641 VGND VPWR sky130_fd_sc_hd__tapvpwrvgnd_1
XFILLER_0_45_278 VGND VGND VPWR VPWR sky130_fd_sc_hd__fill_2
XFILLER_0_45_267 VGND VGND VPWR VPWR sky130_fd_sc_hd__fill_2
XFILLER_0_9_125 VPWR VGND VPWR VGND sky130_ef_sc_hd__decap_12
XFILLER_0_9_169 VPWR VGND VPWR VGND sky130_ef_sc_hd__decap_12
X_2906_ _1467_ VGND VGND VPWR VPWR _0152_ sky130_fd_sc_hd__inv_2
XFILLER_0_18_415 VGND VGND VPWR VPWR sky130_fd_sc_hd__decap_4
X_2768_ _1451_ VGND VGND VPWR VPWR _0030_ sky130_fd_sc_hd__inv_2
X_2837_ _1458_ VGND VGND VPWR VPWR _1460_ sky130_fd_sc_hd__buf_4
X_1719_ _0477_ _0534_ _0519_ VGND VGND VPWR VPWR _0535_ sky130_fd_sc_hd__a21o_1
X_2699_ _1385_ _1413_ _1412_ _1403_ VGND VGND VPWR VPWR _1414_ sky130_fd_sc_hd__a22o_1
XFILLER_0_6_83 VGND VGND VPWR VPWR sky130_fd_sc_hd__fill_1
XFILLER_0_51_248 VPWR VGND VPWR VGND sky130_ef_sc_hd__decap_12
XFILLER_0_51_237 VGND VGND VPWR VPWR sky130_fd_sc_hd__decap_4
XFILLER_0_51_204 VGND VGND VPWR VPWR sky130_fd_sc_hd__decap_3
XFILLER_0_36_223 VGND VGND VPWR VPWR sky130_fd_sc_hd__fill_1
XFILLER_0_63_49 VGND VGND VPWR VPWR sky130_fd_sc_hd__decap_3
XFILLER_0_59_337 VGND VGND VPWR VPWR sky130_fd_sc_hd__decap_4
XFILLER_0_42_204 VGND VGND VPWR VPWR sky130_fd_sc_hd__fill_1
XFILLER_0_27_223 VGND VGND VPWR VPWR sky130_fd_sc_hd__fill_1
XFILLER_0_6_139 VGND VGND VPWR VPWR sky130_fd_sc_hd__fill_1
XFILLER_0_12_53 VPWR VGND VPWR VGND sky130_ef_sc_hd__decap_12
X_2622_ _1325_ _1353_ VGND VGND VPWR VPWR _0200_ sky130_fd_sc_hd__nor2_1
X_1504_ imem.address\[25\] imem.address\[24\] imem.address\[23\] imem.address\[22\]
+ VGND VGND VPWR VPWR _0384_ sky130_fd_sc_hd__nor4_1
XFILLER_0_50_292 VGND VGND VPWR VPWR sky130_fd_sc_hd__decap_8
X_2553_ reg_file.registers\[15\]\[7\] _1304_ VGND VGND VPWR VPWR _1313_ sky130_fd_sc_hd__and2_1
XFILLER_0_42_248 VGND VGND VPWR VPWR sky130_fd_sc_hd__decap_4
XFILLER_0_2_389 VPWR VGND VPWR VGND sky130_ef_sc_hd__decap_12
XFILLER_0_2_345 VPWR VGND VPWR VGND sky130_ef_sc_hd__decap_12
XFILLER_0_2_301 VGND VGND VPWR VPWR sky130_fd_sc_hd__decap_6
XFILLER_0_12_97 VPWR VGND VPWR VGND sky130_ef_sc_hd__decap_12
X_2484_ _1042_ _1098_ _1270_ _0472_ VGND VGND VPWR VPWR _1271_ sky130_fd_sc_hd__a22o_1
X_3105_ clknet_leaf_3_clk _0328_ _0164_ VGND VGND VPWR VPWR reg_file.registers\[5\]\[11\]
+ sky130_fd_sc_hd__dfrtp_1
XFILLER_0_10_189 VGND VGND VPWR VPWR sky130_fd_sc_hd__decap_6
X_3036_ clknet_leaf_10_clk _0259_ _0095_ VGND VGND VPWR VPWR reg_file.registers\[11\]\[6\]
+ sky130_fd_sc_hd__dfrtp_1
XTAP_TAPCELL_ROW_38_457 VGND VPWR sky130_fd_sc_hd__tapvpwrvgnd_1
XFILLER_0_33_259 VGND VGND VPWR VPWR sky130_fd_sc_hd__fill_2
XFILLER_0_33_237 VGND VGND VPWR VPWR sky130_fd_sc_hd__decap_6
XFILLER_0_33_215 VGND VGND VPWR VPWR sky130_fd_sc_hd__decap_8
XFILLER_0_5_161 VGND VGND VPWR VPWR sky130_fd_sc_hd__decap_6
XFILLER_0_18_212 VPWR VGND VPWR VGND sky130_ef_sc_hd__decap_12
XTAP_TAPCELL_ROW_21_324 VGND VPWR sky130_fd_sc_hd__tapvpwrvgnd_1
XFILLER_0_68_112 VGND VGND VPWR VPWR sky130_fd_sc_hd__decap_4
XFILLER_0_68_167 VGND VGND VPWR VPWR sky130_fd_sc_hd__decap_3
XFILLER_0_64_362 VGND VGND VPWR VPWR sky130_fd_sc_hd__fill_2
XFILLER_0_58_27 VGND VGND VPWR VPWR sky130_fd_sc_hd__fill_1
XTAP_TAPCELL_ROW_35_438 VGND VPWR sky130_fd_sc_hd__tapvpwrvgnd_1
XFILLER_0_70_321 VPWR VGND VPWR VGND sky130_ef_sc_hd__decap_12
X_1984_ _0754_ _0794_ _0795_ _0798_ _0799_ VGND VGND VPWR VPWR _0800_ sky130_fd_sc_hd__a221oi_1
XPHY_EDGE_ROW_21_Left_93 VGND VGND VPWR VPWR sky130_fd_sc_hd__decap_3
XFILLER_0_70_365 VPWR VGND VPWR VGND sky130_ef_sc_hd__decap_12
X_2605_ _1332_ _1346_ VGND VGND VPWR VPWR _0210_ sky130_fd_sc_hd__nor2_1
X_2467_ _0662_ _0957_ VGND VGND VPWR VPWR _1257_ sky130_fd_sc_hd__and2_1
X_2536_ _1285_ VGND VGND VPWR VPWR _1304_ sky130_fd_sc_hd__clkbuf_2
XFILLER_0_30_207 VGND VGND VPWR VPWR sky130_fd_sc_hd__fill_1
XFILLER_0_23_281 VPWR VGND VPWR VGND sky130_ef_sc_hd__decap_12
XFILLER_0_2_197 VPWR VGND VPWR VGND sky130_ef_sc_hd__decap_12
XFILLER_0_2_153 VPWR VGND VPWR VGND sky130_ef_sc_hd__decap_12
XFILLER_0_11_432 VGND VGND VPWR VPWR sky130_fd_sc_hd__fill_1
XFILLER_0_64_81 VGND VGND VPWR VPWR sky130_fd_sc_hd__decap_3
XFILLER_0_47_3 VPWR VGND VPWR VGND sky130_ef_sc_hd__decap_12
X_2398_ _1000_ _1002_ _0902_ VGND VGND VPWR VPWR _1198_ sky130_fd_sc_hd__mux2_1
XFILLER_0_3_51 VGND VGND VPWR VPWR sky130_fd_sc_hd__decap_4
XFILLER_0_65_137 VGND VGND VPWR VPWR sky130_fd_sc_hd__decap_8
X_3019_ clknet_leaf_20_clk _0242_ _0078_ VGND VGND VPWR VPWR reg_file.registers\[15\]\[21\]
+ sky130_fd_sc_hd__dfrtp_1
XFILLER_0_21_207 VPWR VGND VPWR VGND sky130_ef_sc_hd__decap_12
XFILLER_0_44_29 VGND VGND VPWR VPWR sky130_fd_sc_hd__decap_8
XFILLER_0_29_318 VGND VGND VPWR VPWR sky130_fd_sc_hd__decap_3
XFILLER_0_52_321 VPWR VGND VPWR VGND sky130_ef_sc_hd__decap_12
XTAP_TAPCELL_ROW_40_474 VGND VPWR sky130_fd_sc_hd__tapvpwrvgnd_1
XTAP_TAPCELL_ROW_32_408 VGND VPWR sky130_fd_sc_hd__tapvpwrvgnd_1
XFILLER_0_8_29 VPWR VGND VPWR VGND sky130_ef_sc_hd__decap_12
XFILLER_0_69_15 VPWR VGND VPWR VGND sky130_ef_sc_hd__decap_12
X_2321_ _0754_ _0755_ _0795_ _1127_ _1128_ VGND VGND VPWR VPWR _1129_ sky130_fd_sc_hd__a221o_1
XTAP_TAPCELL_ROW_48_541 VGND VPWR sky130_fd_sc_hd__tapvpwrvgnd_1
X_2252_ _1063_ _0883_ _0893_ VGND VGND VPWR VPWR _1064_ sky130_fd_sc_hd__mux2_1
X_2183_ _0891_ _0899_ _0894_ VGND VGND VPWR VPWR _0997_ sky130_fd_sc_hd__o21a_1
XFILLER_0_18_41 VPWR VGND VPWR VGND sky130_ef_sc_hd__decap_12
XFILLER_0_18_85 VPWR VGND VPWR VGND sky130_ef_sc_hd__decap_12
XFILLER_0_20_295 VGND VGND VPWR VPWR sky130_fd_sc_hd__fill_1
XFILLER_0_7_223 VGND VGND VPWR VPWR sky130_fd_sc_hd__fill_1
X_1898_ reg_file.registers\[10\]\[9\] _0641_ _0642_ reg_file.registers\[11\]\[9\]
+ VGND VGND VPWR VPWR _0714_ sky130_fd_sc_hd__a22o_1
XFILLER_0_43_332 VGND VGND VPWR VPWR sky130_fd_sc_hd__decap_4
XFILLER_0_28_384 VGND VGND VPWR VPWR sky130_fd_sc_hd__decap_8
X_1967_ _0596_ _0572_ VGND VGND VPWR VPWR _0783_ sky130_fd_sc_hd__nand2_1
X_2519_ _1295_ VGND VGND VPWR VPWR _0245_ sky130_fd_sc_hd__clkbuf_1
XFILLER_0_66_413 VGND VGND VPWR VPWR sky130_fd_sc_hd__decap_6
XTAP_TAPCELL_ROW_3_177 VGND VPWR sky130_fd_sc_hd__tapvpwrvgnd_1
XTAP_TAPCELL_ROW_54_588 VGND VPWR sky130_fd_sc_hd__tapvpwrvgnd_1
XFILLER_0_53_118 VPWR VGND VPWR VGND sky130_ef_sc_hd__decap_12
XFILLER_0_34_321 VGND VGND VPWR VPWR sky130_fd_sc_hd__decap_4
XFILLER_0_34_365 VPWR VGND VPWR VGND sky130_ef_sc_hd__decap_12
XFILLER_0_71_27 VGND VGND VPWR VPWR sky130_fd_sc_hd__fill_1
XFILLER_0_69_273 VGND VGND VPWR VPWR sky130_fd_sc_hd__decap_6
X_2870_ _1463_ VGND VGND VPWR VPWR _0120_ sky130_fd_sc_hd__inv_2
Xclkbuf_leaf_10_clk clknet_1_1__leaf_clk VGND VGND VPWR VPWR clknet_leaf_10_clk sky130_fd_sc_hd__clkbuf_8
X_1683_ reg_file.registers\[10\]\[2\] _0492_ _0486_ reg_file.registers\[5\]\[2\] VGND
+ VGND VPWR VPWR _0499_ sky130_fd_sc_hd__a22o_1
XFILLER_0_52_195 VGND VGND VPWR VPWR sky130_fd_sc_hd__fill_1
XFILLER_0_44_129 VGND VGND VPWR VPWR sky130_fd_sc_hd__fill_2
X_1821_ _0628_ _0630_ _0634_ _0636_ VGND VGND VPWR VPWR _0637_ sky130_fd_sc_hd__or4_4
X_1752_ _0566_ _0567_ _0529_ VGND VGND VPWR VPWR _0568_ sky130_fd_sc_hd__a21o_1
XFILLER_0_20_53 VPWR VGND VPWR VGND sky130_ef_sc_hd__decap_12
XFILLER_0_40_379 VGND VGND VPWR VPWR sky130_fd_sc_hd__fill_2
XFILLER_0_0_421 VPWR VGND VPWR VGND sky130_ef_sc_hd__decap_12
X_2304_ reg_file.registers\[11\]\[25\] _1113_ _0933_ VGND VGND VPWR VPWR _1114_ sky130_fd_sc_hd__mux2_1
XFILLER_0_45_50 VGND VGND VPWR VPWR sky130_fd_sc_hd__decap_6
X_2097_ _0623_ _0631_ _0889_ VGND VGND VPWR VPWR _0913_ sky130_fd_sc_hd__mux2_1
X_2166_ _0980_ VGND VGND VPWR VPWR _0981_ sky130_fd_sc_hd__inv_2
XTAP_TAPCELL_ROW_0_158 VGND VPWR sky130_fd_sc_hd__tapvpwrvgnd_1
XTAP_TAPCELL_ROW_0_147 VGND VPWR sky130_fd_sc_hd__tapvpwrvgnd_1
X_2235_ reg_file.registers\[11\]\[28\] _1047_ _0933_ VGND VGND VPWR VPWR _1048_ sky130_fd_sc_hd__mux2_1
XFILLER_0_63_449 VGND VGND VPWR VPWR sky130_fd_sc_hd__fill_2
XFILLER_0_63_405 VPWR VGND VPWR VGND sky130_ef_sc_hd__decap_12
XFILLER_0_61_93 VGND VGND VPWR VPWR sky130_fd_sc_hd__fill_2
X_2999_ clknet_leaf_2_clk _0222_ _0058_ VGND VGND VPWR VPWR reg_file.registers\[15\]\[1\]
+ sky130_fd_sc_hd__dfrtp_1
XPHY_EDGE_ROW_3_Right_3 VGND VGND VPWR VPWR sky130_fd_sc_hd__decap_3
XFILLER_0_0_41 VPWR VGND VPWR VGND sky130_ef_sc_hd__decap_12
XFILLER_0_0_85 VPWR VGND VPWR VGND sky130_ef_sc_hd__decap_12
XFILLER_0_43_195 VGND VGND VPWR VPWR sky130_fd_sc_hd__decap_4
XFILLER_0_3_281 VPWR VGND VPWR VGND sky130_ef_sc_hd__decap_12
XFILLER_0_16_365 VPWR VGND VPWR VGND sky130_ef_sc_hd__decap_12
XTAP_TAPCELL_ROW_59_625 VGND VPWR sky130_fd_sc_hd__tapvpwrvgnd_1
Xclkbuf_1_1__f_clk clknet_0_clk VGND VGND VPWR VPWR clknet_1_1__leaf_clk sky130_fd_sc_hd__clkbuf_16
XTAP_TAPCELL_ROW_67_691 VGND VPWR sky130_fd_sc_hd__tapvpwrvgnd_1
XFILLER_0_66_210 VPWR VGND VPWR VGND sky130_ef_sc_hd__decap_12
XFILLER_0_39_413 VGND VGND VPWR VPWR sky130_fd_sc_hd__fill_1
XFILLER_0_22_302 VGND VGND VPWR VPWR sky130_fd_sc_hd__decap_3
XFILLER_0_66_27 VGND VGND VPWR VPWR sky130_fd_sc_hd__fill_1
X_2020_ reg_file.registers\[10\]\[25\] _0605_ _0610_ reg_file.registers\[11\]\[25\]
+ VGND VGND VPWR VPWR _0836_ sky130_fd_sc_hd__a22o_1
XFILLER_0_57_254 VGND VGND VPWR VPWR sky130_fd_sc_hd__fill_2
XFILLER_0_45_449 VGND VGND VPWR VPWR sky130_fd_sc_hd__fill_2
XFILLER_0_45_416 VPWR VGND VPWR VGND sky130_ef_sc_hd__decap_12
XFILLER_0_45_405 VGND VGND VPWR VPWR sky130_fd_sc_hd__decap_4
X_2922_ _1470_ VGND VGND VPWR VPWR _0165_ sky130_fd_sc_hd__inv_2
X_2853_ _1461_ VGND VGND VPWR VPWR _0105_ sky130_fd_sc_hd__inv_2
XFILLER_0_9_329 VGND VGND VPWR VPWR sky130_fd_sc_hd__decap_6
XTAP_TAPCELL_ROW_13_260 VGND VPWR sky130_fd_sc_hd__tapvpwrvgnd_1
XFILLER_0_17_118 VGND VGND VPWR VPWR sky130_fd_sc_hd__fill_2
X_2784_ _1452_ VGND VGND VPWR VPWR _0045_ sky130_fd_sc_hd__inv_2
X_1666_ _0375_ _0376_ _0479_ _0481_ VGND VGND VPWR VPWR _0482_ sky130_fd_sc_hd__nor4_1
X_1804_ _0490_ VGND VGND VPWR VPWR _0620_ sky130_fd_sc_hd__clkbuf_4
X_1735_ _0548_ _0550_ VGND VGND VPWR VPWR _0551_ sky130_fd_sc_hd__and2_1
XFILLER_0_40_121 VPWR VGND VPWR VGND sky130_ef_sc_hd__decap_12
XFILLER_0_13_324 VGND VGND VPWR VPWR sky130_fd_sc_hd__fill_1
X_1597_ _0437_ VGND VGND VPWR VPWR _0309_ sky130_fd_sc_hd__clkbuf_1
XTAP_TAPCELL_ROW_56_606 VGND VPWR sky130_fd_sc_hd__tapvpwrvgnd_1
X_2149_ reg_file.registers\[10\]\[1\] _0603_ _0608_ reg_file.registers\[11\]\[1\]
+ VGND VGND VPWR VPWR _0964_ sky130_fd_sc_hd__a22o_1
X_2218_ _1030_ VGND VGND VPWR VPWR _1031_ sky130_fd_sc_hd__inv_2
XFILLER_0_8_362 VGND VGND VPWR VPWR sky130_fd_sc_hd__fill_2
XFILLER_0_8_384 VPWR VGND VPWR VGND sky130_ef_sc_hd__decap_12
XFILLER_0_31_132 VGND VGND VPWR VPWR sky130_fd_sc_hd__fill_2
XFILLER_0_16_195 VGND VGND VPWR VPWR sky130_fd_sc_hd__fill_1
XTAP_TAPCELL_ROW_19_308 VGND VPWR sky130_fd_sc_hd__tapvpwrvgnd_1
XFILLER_0_52_29 VGND VGND VPWR VPWR sky130_fd_sc_hd__fill_2
XFILLER_0_39_298 VGND VGND VPWR VPWR sky130_fd_sc_hd__decap_3
XFILLER_0_39_232 VGND VGND VPWR VPWR sky130_fd_sc_hd__decap_3
XFILLER_0_27_449 VGND VGND VPWR VPWR sky130_fd_sc_hd__fill_2
XTAP_TAPCELL_ROW_27_374 VGND VPWR sky130_fd_sc_hd__tapvpwrvgnd_1
XFILLER_0_42_419 VGND VGND VPWR VPWR sky130_fd_sc_hd__fill_1
XFILLER_0_22_165 VGND VGND VPWR VPWR sky130_fd_sc_hd__fill_1
X_1520_ reg_file.registers\[5\]\[28\] _0393_ VGND VGND VPWR VPWR _0397_ sky130_fd_sc_hd__and2_1
X_3121_ clknet_leaf_20_clk _0344_ _0180_ VGND VGND VPWR VPWR reg_file.registers\[5\]\[27\]
+ sky130_fd_sc_hd__dfrtp_1
XFILLER_0_26_85 VGND VGND VPWR VPWR sky130_fd_sc_hd__decap_4
XFILLER_0_26_41 VGND VGND VPWR VPWR sky130_fd_sc_hd__decap_4
X_2003_ _0812_ _0818_ VGND VGND VPWR VPWR _0819_ sky130_fd_sc_hd__nand2_1
X_3052_ clknet_leaf_13_clk _0275_ _0111_ VGND VGND VPWR VPWR reg_file.registers\[11\]\[22\]
+ sky130_fd_sc_hd__dfrtp_1
XTAP_TAPCELL_ROW_61_642 VGND VPWR sky130_fd_sc_hd__tapvpwrvgnd_1
X_2836_ _1459_ VGND VGND VPWR VPWR _0090_ sky130_fd_sc_hd__inv_2
XFILLER_0_45_235 VGND VGND VPWR VPWR sky130_fd_sc_hd__decap_4
XFILLER_0_45_213 VGND VGND VPWR VPWR sky130_fd_sc_hd__fill_2
XFILLER_0_9_137 VPWR VGND VPWR VGND sky130_ef_sc_hd__decap_12
X_2905_ _1467_ VGND VGND VPWR VPWR _0151_ sky130_fd_sc_hd__inv_2
XFILLER_0_18_449 VGND VGND VPWR VPWR sky130_fd_sc_hd__fill_2
X_2767_ _1451_ VGND VGND VPWR VPWR _0029_ sky130_fd_sc_hd__inv_2
XFILLER_0_60_249 VGND VGND VPWR VPWR sky130_fd_sc_hd__decap_3
X_1649_ _0382_ _0383_ _0375_ _0373_ VGND VGND VPWR VPWR _0465_ sky130_fd_sc_hd__nor4_2
X_1718_ reg_file.registers\[15\]\[8\] _0485_ _0467_ reg_file.registers\[5\]\[8\] VGND
+ VGND VPWR VPWR _0534_ sky130_fd_sc_hd__a22o_1
XFILLER_0_41_441 VGND VGND VPWR VPWR sky130_fd_sc_hd__decap_4
X_2698_ _1393_ _1403_ VGND VGND VPWR VPWR _1413_ sky130_fd_sc_hd__nor2_1
XTAP_TAPCELL_ROW_24_344 VGND VPWR sky130_fd_sc_hd__tapvpwrvgnd_1
XFILLER_0_24_408 VGND VGND VPWR VPWR sky130_fd_sc_hd__fill_1
XFILLER_0_59_349 VGND VGND VPWR VPWR sky130_fd_sc_hd__fill_1
XFILLER_0_67_393 VPWR VGND VPWR VGND sky130_ef_sc_hd__decap_12
XFILLER_0_27_235 VGND VGND VPWR VPWR sky130_fd_sc_hd__decap_6
XFILLER_0_12_65 VPWR VGND VPWR VGND sky130_ef_sc_hd__decap_12
X_2621_ imem.address\[10\] _1324_ imem.address\[11\] VGND VGND VPWR VPWR _1353_ sky130_fd_sc_hd__a21oi_1
X_1503_ imem.address\[17\] imem.address\[16\] imem.address\[15\] imem.address\[14\]
+ VGND VGND VPWR VPWR _0383_ sky130_fd_sc_hd__or4_4
X_2552_ _1312_ VGND VGND VPWR VPWR _0229_ sky130_fd_sc_hd__clkbuf_1
X_2483_ _1269_ _0677_ VGND VGND VPWR VPWR _1270_ sky130_fd_sc_hd__xnor2_1
XFILLER_0_50_260 VGND VGND VPWR VPWR sky130_fd_sc_hd__fill_2
XFILLER_0_2_357 VGND VGND VPWR VPWR sky130_fd_sc_hd__decap_6
X_3035_ clknet_leaf_9_clk _0258_ _0094_ VGND VGND VPWR VPWR reg_file.registers\[11\]\[5\]
+ sky130_fd_sc_hd__dfrtp_1
X_3104_ clknet_leaf_3_clk _0327_ _0163_ VGND VGND VPWR VPWR reg_file.registers\[5\]\[10\]
+ sky130_fd_sc_hd__dfrtp_1
XFILLER_0_37_95 VGND VGND VPWR VPWR sky130_fd_sc_hd__decap_6
XFILLER_0_37_51 VGND VGND VPWR VPWR sky130_fd_sc_hd__decap_4
XTAP_TAPCELL_ROW_38_458 VGND VPWR sky130_fd_sc_hd__tapvpwrvgnd_1
XFILLER_0_33_249 VGND VGND VPWR VPWR sky130_fd_sc_hd__fill_2
X_2819_ _1450_ VGND VGND VPWR VPWR _1456_ sky130_fd_sc_hd__buf_4
XFILLER_0_18_268 VPWR VGND VPWR VGND sky130_ef_sc_hd__decap_12
XTAP_TAPCELL_ROW_21_325 VGND VPWR sky130_fd_sc_hd__tapvpwrvgnd_1
XFILLER_0_20_411 VGND VGND VPWR VPWR sky130_fd_sc_hd__fill_2
XFILLER_0_59_113 VGND VGND VPWR VPWR sky130_fd_sc_hd__decap_6
XTAP_TAPCELL_ROW_35_439 VGND VPWR sky130_fd_sc_hd__tapvpwrvgnd_1
XFILLER_0_7_405 VGND VGND VPWR VPWR sky130_fd_sc_hd__decap_4
XFILLER_0_70_377 VPWR VGND VPWR VGND sky130_ef_sc_hd__decap_12
XFILLER_0_70_333 VPWR VGND VPWR VGND sky130_ef_sc_hd__decap_12
X_2604_ imem.address\[21\] _1331_ VGND VGND VPWR VPWR _1346_ sky130_fd_sc_hd__nor2_1
X_1983_ _0754_ _0794_ _0761_ VGND VGND VPWR VPWR _0799_ sky130_fd_sc_hd__o21ba_1
XFILLER_0_2_121 VPWR VGND VPWR VGND sky130_ef_sc_hd__decap_12
XFILLER_0_7_449 VGND VGND VPWR VPWR sky130_fd_sc_hd__fill_2
XFILLER_0_15_249 VGND VGND VPWR VPWR sky130_fd_sc_hd__fill_1
X_2466_ _0688_ _0692_ VGND VGND VPWR VPWR _1256_ sky130_fd_sc_hd__or2_1
X_2535_ _1303_ VGND VGND VPWR VPWR _0237_ sky130_fd_sc_hd__clkbuf_1
XFILLER_0_23_293 VPWR VGND VPWR VGND sky130_ef_sc_hd__decap_12
XFILLER_0_23_271 VGND VGND VPWR VPWR sky130_fd_sc_hd__fill_2
XFILLER_0_2_165 VPWR VGND VPWR VGND sky130_ef_sc_hd__decap_12
XFILLER_0_64_93 VGND VGND VPWR VPWR sky130_fd_sc_hd__fill_2
X_2397_ _0990_ _0999_ _0903_ VGND VGND VPWR VPWR _1197_ sky130_fd_sc_hd__mux2_1
X_3018_ clknet_leaf_20_clk _0241_ _0077_ VGND VGND VPWR VPWR reg_file.registers\[15\]\[20\]
+ sky130_fd_sc_hd__dfrtp_1
XFILLER_0_46_363 VGND VGND VPWR VPWR sky130_fd_sc_hd__fill_1
XFILLER_0_46_341 VGND VGND VPWR VPWR sky130_fd_sc_hd__decap_8
XFILLER_0_14_271 VGND VGND VPWR VPWR sky130_fd_sc_hd__fill_1
XFILLER_0_21_219 VGND VGND VPWR VPWR sky130_fd_sc_hd__decap_4
XTAP_TAPCELL_ROW_32_409 VGND VPWR sky130_fd_sc_hd__tapvpwrvgnd_1
XFILLER_0_69_27 VPWR VGND VPWR VGND sky130_ef_sc_hd__decap_12
XFILLER_0_52_333 VPWR VGND VPWR VGND sky130_ef_sc_hd__decap_12
XTAP_TAPCELL_ROW_40_475 VGND VPWR sky130_fd_sc_hd__tapvpwrvgnd_1
XFILLER_0_4_419 VGND VGND VPWR VPWR sky130_fd_sc_hd__fill_1
X_2251_ _1059_ _1062_ _0882_ VGND VGND VPWR VPWR _1063_ sky130_fd_sc_hd__mux2_1
X_2320_ _0754_ _0794_ _0757_ _0758_ VGND VGND VPWR VPWR _1128_ sky130_fd_sc_hd__o211a_1
XTAP_TAPCELL_ROW_48_542 VGND VPWR sky130_fd_sc_hd__tapvpwrvgnd_1
X_2182_ _0903_ _0905_ VGND VGND VPWR VPWR _0996_ sky130_fd_sc_hd__or2_1
XFILLER_0_18_53 VPWR VGND VPWR VGND sky130_ef_sc_hd__decap_12
XFILLER_0_18_97 VGND VGND VPWR VPWR sky130_fd_sc_hd__decap_4
XFILLER_0_34_85 VGND VGND VPWR VPWR sky130_fd_sc_hd__fill_2
XFILLER_0_34_41 VPWR VGND VPWR VGND sky130_ef_sc_hd__decap_12
XFILLER_0_28_363 VGND VGND VPWR VPWR sky130_fd_sc_hd__fill_1
X_1966_ _0780_ _0781_ VGND VGND VPWR VPWR _0782_ sky130_fd_sc_hd__xnor2_1
XFILLER_0_70_141 VGND VGND VPWR VPWR sky130_fd_sc_hd__decap_4
X_1897_ _0711_ _0712_ VGND VGND VPWR VPWR _0713_ sky130_fd_sc_hd__or2_1
XFILLER_0_3_441 VGND VGND VPWR VPWR sky130_fd_sc_hd__decap_6
XFILLER_0_7_279 VGND VGND VPWR VPWR sky130_fd_sc_hd__fill_1
XFILLER_0_59_93 VGND VGND VPWR VPWR sky130_fd_sc_hd__fill_1
X_2449_ _0470_ _1239_ _1240_ _1056_ _1242_ VGND VGND VPWR VPWR _1243_ sky130_fd_sc_hd__a32o_1
X_2518_ reg_file.registers\[15\]\[24\] _1293_ VGND VGND VPWR VPWR _1295_ sky130_fd_sc_hd__and2_1
XFILLER_0_38_116 VGND VGND VPWR VPWR sky130_fd_sc_hd__fill_1
XTAP_TAPCELL_ROW_3_178 VGND VPWR sky130_fd_sc_hd__tapvpwrvgnd_1
XFILLER_0_61_163 VGND VGND VPWR VPWR sky130_fd_sc_hd__decap_4
XTAP_TAPCELL_ROW_54_589 VGND VPWR sky130_fd_sc_hd__tapvpwrvgnd_1
XPHY_EDGE_ROW_49_Left_121 VGND VGND VPWR VPWR sky130_fd_sc_hd__decap_3
XFILLER_0_38_149 VGND VGND VPWR VPWR sky130_fd_sc_hd__decap_8
XFILLER_0_34_377 VGND VGND VPWR VPWR sky130_fd_sc_hd__fill_2
XFILLER_0_19_352 VGND VGND VPWR VPWR sky130_fd_sc_hd__decap_8
XPHY_EDGE_ROW_58_Left_130 VGND VGND VPWR VPWR sky130_fd_sc_hd__decap_3
XTAP_TAPCELL_ROW_45_512 VGND VPWR sky130_fd_sc_hd__tapvpwrvgnd_1
X_1820_ _0633_ _0632_ _0635_ VGND VGND VPWR VPWR _0636_ sky130_fd_sc_hd__a21boi_2
XFILLER_0_52_141 VGND VGND VPWR VPWR sky130_fd_sc_hd__decap_8
X_1682_ _0389_ _0467_ VGND VGND VPWR VPWR _0498_ sky130_fd_sc_hd__or2_4
XFILLER_0_40_347 VGND VGND VPWR VPWR sky130_fd_sc_hd__decap_3
XFILLER_0_25_366 VGND VGND VPWR VPWR sky130_fd_sc_hd__fill_2
X_1751_ reg_file.registers\[15\]\[22\] _0543_ _0537_ reg_file.registers\[5\]\[22\]
+ VGND VGND VPWR VPWR _0567_ sky130_fd_sc_hd__a22o_1
XFILLER_0_20_65 VPWR VGND VPWR VGND sky130_ef_sc_hd__decap_12
XFILLER_0_0_433 VPWR VGND VPWR VGND sky130_ef_sc_hd__decap_12
X_2303_ _0471_ _1104_ _1105_ _1112_ VGND VGND VPWR VPWR _1113_ sky130_fd_sc_hd__a31o_1
X_2234_ _0471_ _1017_ _1022_ _1046_ VGND VGND VPWR VPWR _1047_ sky130_fd_sc_hd__a31o_1
X_2096_ _0468_ _0659_ VGND VGND VPWR VPWR _0912_ sky130_fd_sc_hd__and2_1
X_2165_ _0657_ _0971_ _0979_ VGND VGND VPWR VPWR _0980_ sky130_fd_sc_hd__o21ai_1
XTAP_TAPCELL_ROW_0_159 VGND VPWR sky130_fd_sc_hd__tapvpwrvgnd_1
XTAP_TAPCELL_ROW_0_148 VGND VPWR sky130_fd_sc_hd__tapvpwrvgnd_1
XFILLER_0_63_417 VPWR VGND VPWR VGND sky130_ef_sc_hd__decap_12
X_2998_ clknet_leaf_2_clk _0221_ _0057_ VGND VGND VPWR VPWR reg_file.registers\[15\]\[0\]
+ sky130_fd_sc_hd__dfrtp_1
X_1949_ reg_file.registers\[10\]\[17\] _0641_ _0642_ reg_file.registers\[11\]\[17\]
+ VGND VGND VPWR VPWR _0765_ sky130_fd_sc_hd__a22o_1
XFILLER_0_28_182 VGND VGND VPWR VPWR sky130_fd_sc_hd__decap_3
XFILLER_0_28_160 VGND VGND VPWR VPWR sky130_fd_sc_hd__fill_1
XFILLER_0_0_53 VGND VGND VPWR VPWR sky130_fd_sc_hd__decap_3
XFILLER_0_0_97 VPWR VGND VPWR VGND sky130_ef_sc_hd__decap_12
XFILLER_0_9_51 VGND VGND VPWR VPWR sky130_fd_sc_hd__decap_4
XTAP_TAPCELL_ROW_16_280 VGND VPWR sky130_fd_sc_hd__tapvpwrvgnd_1
XFILLER_0_3_293 VPWR VGND VPWR VGND sky130_ef_sc_hd__decap_12
XFILLER_0_16_377 VPWR VGND VPWR VGND sky130_ef_sc_hd__decap_12
XTAP_TAPCELL_ROW_59_626 VGND VPWR sky130_fd_sc_hd__tapvpwrvgnd_1
XTAP_TAPCELL_ROW_67_692 VGND VPWR sky130_fd_sc_hd__tapvpwrvgnd_1
XFILLER_0_66_244 VGND VGND VPWR VPWR sky130_fd_sc_hd__decap_8
XFILLER_0_66_222 VGND VGND VPWR VPWR sky130_fd_sc_hd__decap_6
XFILLER_0_39_425 VGND VGND VPWR VPWR sky130_fd_sc_hd__decap_3
XFILLER_0_34_130 VGND VGND VPWR VPWR sky130_fd_sc_hd__decap_6
XFILLER_0_30_391 VPWR VGND VPWR VGND sky130_ef_sc_hd__decap_12
XPHY_EDGE_ROW_13_Right_13 VGND VGND VPWR VPWR sky130_fd_sc_hd__decap_3
X_2783_ _1452_ VGND VGND VPWR VPWR _0044_ sky130_fd_sc_hd__inv_2
XFILLER_0_57_277 VGND VGND VPWR VPWR sky130_fd_sc_hd__decap_3
XFILLER_0_45_428 VGND VGND VPWR VPWR sky130_fd_sc_hd__decap_4
X_2921_ _1470_ VGND VGND VPWR VPWR _0164_ sky130_fd_sc_hd__inv_2
X_2852_ _1461_ VGND VGND VPWR VPWR _0104_ sky130_fd_sc_hd__inv_2
XPHY_EDGE_ROW_22_Right_22 VGND VGND VPWR VPWR sky130_fd_sc_hd__decap_3
XTAP_TAPCELL_ROW_13_261 VGND VPWR sky130_fd_sc_hd__tapvpwrvgnd_1
X_1803_ _0617_ _0618_ VGND VGND VPWR VPWR _0619_ sky130_fd_sc_hd__and2_1
X_1665_ _0480_ VGND VGND VPWR VPWR _0481_ sky130_fd_sc_hd__clkbuf_2
X_1734_ net30 _0549_ VGND VGND VPWR VPWR _0550_ sky130_fd_sc_hd__nand2_1
XFILLER_0_40_100 VGND VGND VPWR VPWR sky130_fd_sc_hd__decap_8
X_1596_ reg_file.registers\[10\]\[24\] _0429_ VGND VGND VPWR VPWR _0437_ sky130_fd_sc_hd__and2_1
XFILLER_0_13_369 VGND VGND VPWR VPWR sky130_fd_sc_hd__decap_3
XFILLER_0_21_391 VGND VGND VPWR VPWR sky130_fd_sc_hd__fill_1
XTAP_TAPCELL_ROW_56_607 VGND VPWR sky130_fd_sc_hd__tapvpwrvgnd_1
X_2217_ _0881_ _0975_ _1029_ VGND VGND VPWR VPWR _1030_ sky130_fd_sc_hd__o21ai_1
XPHY_EDGE_ROW_31_Right_31 VGND VGND VPWR VPWR sky130_fd_sc_hd__decap_3
XFILLER_0_22_3 VPWR VGND VPWR VGND sky130_ef_sc_hd__decap_12
X_2148_ reg_file.registers\[10\]\[2\] _0603_ _0608_ reg_file.registers\[11\]\[2\]
+ VGND VGND VPWR VPWR _0963_ sky130_fd_sc_hd__a22o_1
X_2079_ _0883_ _0892_ _0894_ VGND VGND VPWR VPWR _0895_ sky130_fd_sc_hd__mux2_1
XFILLER_0_63_225 VPWR VGND VPWR VGND sky130_ef_sc_hd__decap_12
XFILLER_0_48_299 VGND VGND VPWR VPWR sky130_fd_sc_hd__decap_8
XFILLER_0_48_288 VGND VGND VPWR VPWR sky130_fd_sc_hd__decap_6
XPHY_EDGE_ROW_40_Right_40 VGND VGND VPWR VPWR sky130_fd_sc_hd__decap_3
XFILLER_0_8_396 VGND VGND VPWR VPWR sky130_fd_sc_hd__decap_6
XFILLER_0_16_141 VPWR VGND VPWR VGND sky130_ef_sc_hd__decap_12
XFILLER_0_31_166 VGND VGND VPWR VPWR sky130_fd_sc_hd__fill_2
XFILLER_0_39_211 VPWR VGND VPWR VGND sky130_ef_sc_hd__decap_12
XTAP_TAPCELL_ROW_19_309 VGND VPWR sky130_fd_sc_hd__tapvpwrvgnd_1
XFILLER_0_39_244 VGND VGND VPWR VPWR sky130_fd_sc_hd__decap_4
XTAP_TAPCELL_ROW_27_375 VGND VPWR sky130_fd_sc_hd__tapvpwrvgnd_1
XFILLER_0_27_406 VGND VGND VPWR VPWR sky130_fd_sc_hd__fill_1
XFILLER_0_62_280 VGND VGND VPWR VPWR sky130_fd_sc_hd__decap_8
XFILLER_0_22_122 VGND VGND VPWR VPWR sky130_fd_sc_hd__decap_8
X_3051_ clknet_leaf_18_clk _0274_ _0110_ VGND VGND VPWR VPWR reg_file.registers\[11\]\[21\]
+ sky130_fd_sc_hd__dfrtp_1
X_3120_ clknet_leaf_20_clk _0343_ _0179_ VGND VGND VPWR VPWR reg_file.registers\[5\]\[26\]
+ sky130_fd_sc_hd__dfrtp_1
XTAP_TAPCELL_ROW_61_643 VGND VPWR sky130_fd_sc_hd__tapvpwrvgnd_1
XFILLER_0_42_41 VGND VGND VPWR VPWR sky130_fd_sc_hd__fill_2
XFILLER_0_9_105 VGND VGND VPWR VPWR sky130_fd_sc_hd__decap_6
XFILLER_0_9_149 VPWR VGND VPWR VGND sky130_ef_sc_hd__decap_12
X_2002_ _0575_ _0577_ _0811_ VGND VGND VPWR VPWR _0818_ sky130_fd_sc_hd__o21ai_1
X_2766_ _1451_ VGND VGND VPWR VPWR _0028_ sky130_fd_sc_hd__inv_2
X_2835_ _1459_ VGND VGND VPWR VPWR _0089_ sky130_fd_sc_hd__inv_2
XFILLER_0_45_225 VGND VGND VPWR VPWR sky130_fd_sc_hd__decap_4
XFILLER_0_42_85 VGND VGND VPWR VPWR sky130_fd_sc_hd__fill_1
XFILLER_0_13_111 VGND VGND VPWR VPWR sky130_fd_sc_hd__fill_1
X_2904_ _1462_ VGND VGND VPWR VPWR _1467_ sky130_fd_sc_hd__buf_1
XTAP_TAPCELL_ROW_69_710 VGND VPWR sky130_fd_sc_hd__tapvpwrvgnd_1
X_1648_ imem.address\[31\] imem.address\[30\] _0380_ _0385_ VGND VGND VPWR VPWR _0464_
+ sky130_fd_sc_hd__nor4b_1
X_1717_ _0477_ _0532_ VGND VGND VPWR VPWR _0533_ sky130_fd_sc_hd__and2_1
X_1579_ _0427_ VGND VGND VPWR VPWR _0317_ sky130_fd_sc_hd__clkbuf_1
XFILLER_0_6_85 VPWR VGND VPWR VGND sky130_ef_sc_hd__decap_12
XFILLER_0_6_41 VPWR VGND VPWR VGND sky130_ef_sc_hd__decap_12
X_2697_ _1377_ _1403_ _1412_ _1411_ VGND VGND VPWR VPWR _0002_ sky130_fd_sc_hd__a31o_1
XTAP_TAPCELL_ROW_24_345 VGND VPWR sky130_fd_sc_hd__tapvpwrvgnd_1
XFILLER_0_67_361 VPWR VGND VPWR VGND sky130_ef_sc_hd__decap_12
XFILLER_0_63_18 VPWR VGND VPWR VGND sky130_ef_sc_hd__decap_12
XFILLER_0_59_328 VGND VGND VPWR VPWR sky130_fd_sc_hd__decap_8
X_2620_ _1326_ _1352_ VGND VGND VPWR VPWR _0201_ sky130_fd_sc_hd__nor2_1
XFILLER_0_27_225 VGND VGND VPWR VPWR sky130_fd_sc_hd__decap_3
XFILLER_0_23_420 VGND VGND VPWR VPWR sky130_fd_sc_hd__fill_1
XFILLER_0_12_77 VGND VGND VPWR VPWR sky130_fd_sc_hd__decap_6
X_1502_ imem.address\[10\] imem.address\[12\] imem.address\[11\] imem.address\[13\]
+ VGND VGND VPWR VPWR _0382_ sky130_fd_sc_hd__or4_4
X_2551_ reg_file.registers\[15\]\[8\] _1304_ VGND VGND VPWR VPWR _1312_ sky130_fd_sc_hd__and2_1
X_2482_ _0669_ _1268_ VGND VGND VPWR VPWR _1269_ sky130_fd_sc_hd__nand2_1
X_3034_ clknet_leaf_10_clk _0257_ _0093_ VGND VGND VPWR VPWR reg_file.registers\[11\]\[4\]
+ sky130_fd_sc_hd__dfrtp_1
X_3103_ clknet_leaf_3_clk _0326_ _0162_ VGND VGND VPWR VPWR reg_file.registers\[5\]\[9\]
+ sky130_fd_sc_hd__dfrtp_1
XTAP_TAPCELL_ROW_38_459 VGND VPWR sky130_fd_sc_hd__tapvpwrvgnd_1
XFILLER_0_37_74 VGND VGND VPWR VPWR sky130_fd_sc_hd__fill_1
XTAP_TAPCELL_ROW_21_326 VGND VPWR sky130_fd_sc_hd__tapvpwrvgnd_1
X_2818_ _1455_ VGND VGND VPWR VPWR _0076_ sky130_fd_sc_hd__inv_2
XFILLER_0_26_291 VGND VGND VPWR VPWR sky130_fd_sc_hd__decap_3
X_2749_ _1440_ _1441_ VGND VGND VPWR VPWR _0013_ sky130_fd_sc_hd__nor2_1
XFILLER_0_1_391 VGND VGND VPWR VPWR sky130_fd_sc_hd__fill_1
XFILLER_0_56_309 VPWR VGND VPWR VGND sky130_ef_sc_hd__decap_12
XFILLER_0_64_342 VPWR VGND VPWR VGND sky130_ef_sc_hd__decap_12
XPHY_EDGE_ROW_30_Left_102 VGND VGND VPWR VPWR sky130_fd_sc_hd__decap_3
XFILLER_0_24_217 VGND VGND VPWR VPWR sky130_fd_sc_hd__decap_3
XFILLER_0_58_29 VGND VGND VPWR VPWR sky130_fd_sc_hd__fill_2
XFILLER_0_32_283 VPWR VGND VPWR VGND sky130_ef_sc_hd__decap_12
XFILLER_0_32_250 VGND VGND VPWR VPWR sky130_fd_sc_hd__fill_2
XFILLER_0_67_191 VPWR VGND VPWR VGND sky130_ef_sc_hd__decap_12
X_1982_ _0797_ _0766_ _0768_ VGND VGND VPWR VPWR _0798_ sky130_fd_sc_hd__o21ai_1
XFILLER_0_70_389 VPWR VGND VPWR VGND sky130_ef_sc_hd__decap_12
XFILLER_0_70_345 VPWR VGND VPWR VGND sky130_ef_sc_hd__decap_12
XFILLER_0_70_301 VGND VGND VPWR VPWR sky130_fd_sc_hd__decap_6
X_2603_ imem.address\[22\] _1332_ VGND VGND VPWR VPWR _0211_ sky130_fd_sc_hd__xor2_1
X_2534_ reg_file.registers\[15\]\[16\] _1293_ VGND VGND VPWR VPWR _1303_ sky130_fd_sc_hd__and2_1
XFILLER_0_23_250 VGND VGND VPWR VPWR sky130_fd_sc_hd__fill_1
XFILLER_0_2_133 VGND VGND VPWR VPWR sky130_fd_sc_hd__decap_6
XFILLER_0_11_412 VPWR VGND VPWR VGND sky130_ef_sc_hd__decap_12
X_2465_ _1255_ VGND VGND VPWR VPWR _0259_ sky130_fd_sc_hd__clkbuf_1
X_2396_ _1194_ _0636_ _1193_ VGND VGND VPWR VPWR _1196_ sky130_fd_sc_hd__or3_1
XFILLER_0_2_177 VPWR VGND VPWR VGND sky130_ef_sc_hd__decap_12
X_3017_ clknet_leaf_21_clk _0240_ _0076_ VGND VGND VPWR VPWR reg_file.registers\[15\]\[19\]
+ sky130_fd_sc_hd__dfrtp_1
XFILLER_0_46_386 VPWR VGND VPWR VGND sky130_ef_sc_hd__decap_12
XPHY_EDGE_ROW_69_Right_69 VGND VGND VPWR VPWR sky130_fd_sc_hd__decap_3
XFILLER_0_56_139 VGND VGND VPWR VPWR sky130_fd_sc_hd__fill_1
XFILLER_0_56_106 VPWR VGND VPWR VGND sky130_ef_sc_hd__decap_12
XFILLER_0_71_109 VGND VGND VPWR VPWR sky130_fd_sc_hd__decap_3
XFILLER_0_69_39 VPWR VGND VPWR VGND sky130_ef_sc_hd__decap_12
XFILLER_0_64_161 VGND VGND VPWR VPWR sky130_fd_sc_hd__decap_8
XFILLER_0_52_345 VGND VGND VPWR VPWR sky130_fd_sc_hd__decap_8
XTAP_TAPCELL_ROW_40_476 VGND VPWR sky130_fd_sc_hd__tapvpwrvgnd_1
XFILLER_0_12_209 VPWR VGND VPWR VGND sky130_ef_sc_hd__decap_12
X_2250_ _1060_ _1061_ _0879_ VGND VGND VPWR VPWR _1062_ sky130_fd_sc_hd__mux2_1
XFILLER_0_20_231 VGND VGND VPWR VPWR sky130_fd_sc_hd__fill_2
XFILLER_0_20_253 VGND VGND VPWR VPWR sky130_fd_sc_hd__fill_1
XTAP_TAPCELL_ROW_48_543 VGND VPWR sky130_fd_sc_hd__tapvpwrvgnd_1
XFILLER_0_34_53 VPWR VGND VPWR VGND sky130_ef_sc_hd__decap_12
X_2181_ _0994_ _0900_ _0882_ VGND VGND VPWR VPWR _0995_ sky130_fd_sc_hd__mux2_1
XFILLER_0_18_65 VPWR VGND VPWR VGND sky130_ef_sc_hd__decap_12
XFILLER_0_43_301 VGND VGND VPWR VPWR sky130_fd_sc_hd__fill_1
XFILLER_0_7_225 VPWR VGND VPWR VGND sky130_ef_sc_hd__decap_12
X_1965_ reg_file.registers\[10\]\[22\] _0775_ _0776_ reg_file.registers\[11\]\[22\]
+ VGND VGND VPWR VPWR _0781_ sky130_fd_sc_hd__a22o_1
XFILLER_0_70_197 VPWR VGND VPWR VGND sky130_ef_sc_hd__decap_12
X_1896_ _0556_ _0488_ net25 VGND VGND VPWR VPWR _0712_ sky130_fd_sc_hd__o21a_1
X_2517_ _1294_ VGND VGND VPWR VPWR _0246_ sky130_fd_sc_hd__clkbuf_1
XFILLER_0_52_3 VPWR VGND VPWR VGND sky130_ef_sc_hd__decap_12
X_2448_ _1107_ _1241_ _0866_ VGND VGND VPWR VPWR _1242_ sky130_fd_sc_hd__mux2_1
X_2379_ _1042_ _1106_ _1179_ _1180_ VGND VGND VPWR VPWR _1181_ sky130_fd_sc_hd__a211o_1
XTAP_TAPCELL_ROW_3_179 VGND VPWR sky130_fd_sc_hd__tapvpwrvgnd_1
XFILLER_0_61_131 VGND VGND VPWR VPWR sky130_fd_sc_hd__fill_1
XFILLER_0_34_334 VPWR VGND VPWR VGND sky130_ef_sc_hd__decap_12
XFILLER_0_71_29 VPWR VGND VPWR VGND sky130_ef_sc_hd__decap_12
XTAP_TAPCELL_ROW_45_513 VGND VPWR sky130_fd_sc_hd__tapvpwrvgnd_1
X_1750_ _0478_ VGND VGND VPWR VPWR _0566_ sky130_fd_sc_hd__buf_2
XFILLER_0_29_128 VGND VGND VPWR VPWR sky130_fd_sc_hd__fill_2
XFILLER_0_25_312 VPWR VGND VPWR VGND sky130_ef_sc_hd__decap_12
XFILLER_0_52_197 VPWR VGND VPWR VGND sky130_ef_sc_hd__decap_12
XFILLER_0_52_131 VGND VGND VPWR VPWR sky130_fd_sc_hd__fill_1
X_1681_ _0489_ _0490_ _0477_ _0496_ VGND VGND VPWR VPWR _0497_ sky130_fd_sc_hd__a2bb2o_2
XFILLER_0_40_359 VGND VGND VPWR VPWR sky130_fd_sc_hd__decap_4
XFILLER_0_0_445 VGND VGND VPWR VPWR sky130_fd_sc_hd__decap_3
XFILLER_0_20_77 VGND VGND VPWR VPWR sky130_fd_sc_hd__decap_6
X_2164_ _0909_ _0978_ VGND VGND VPWR VPWR _0979_ sky130_fd_sc_hd__or2_1
X_2233_ _1027_ _1028_ _1039_ _0937_ _1045_ VGND VGND VPWR VPWR _1046_ sky130_fd_sc_hd__a221o_1
X_2302_ _1028_ _1106_ _1109_ _0937_ _1111_ VGND VGND VPWR VPWR _1112_ sky130_fd_sc_hd__a221o_1
X_2095_ _0898_ _0904_ _0908_ _0910_ VGND VGND VPWR VPWR _0911_ sky130_fd_sc_hd__a211o_1
XTAP_TAPCELL_ROW_0_149 VGND VPWR sky130_fd_sc_hd__tapvpwrvgnd_1
XFILLER_0_63_429 VPWR VGND VPWR VGND sky130_ef_sc_hd__decap_12
XFILLER_0_61_73 VPWR VGND VPWR VGND sky130_ef_sc_hd__decap_12
X_1879_ _0688_ _0692_ _0693_ _0694_ VGND VGND VPWR VPWR _0695_ sky130_fd_sc_hd__o211a_1
X_1948_ _0559_ _0763_ VGND VGND VPWR VPWR _0764_ sky130_fd_sc_hd__nand2_1
XFILLER_0_31_326 VGND VGND VPWR VPWR sky130_fd_sc_hd__fill_1
XTAP_TAPCELL_ROW_16_281 VGND VPWR sky130_fd_sc_hd__tapvpwrvgnd_1
XFILLER_0_16_301 VGND VGND VPWR VPWR sky130_fd_sc_hd__decap_6
XFILLER_0_16_389 VPWR VGND VPWR VGND sky130_ef_sc_hd__decap_12
X_2997_ clknet_leaf_13_clk _0006_ VGND VGND VPWR VPWR net16 sky130_fd_sc_hd__dfxtp_1
XFILLER_0_3_261 VPWR VGND VPWR VGND sky130_ef_sc_hd__decap_12
XTAP_TAPCELL_ROW_8_216 VGND VPWR sky130_fd_sc_hd__tapvpwrvgnd_1
XTAP_TAPCELL_ROW_67_693 VGND VPWR sky130_fd_sc_hd__tapvpwrvgnd_1
XTAP_TAPCELL_ROW_59_627 VGND VPWR sky130_fd_sc_hd__tapvpwrvgnd_1
XFILLER_0_39_437 VGND VGND VPWR VPWR sky130_fd_sc_hd__decap_8
XFILLER_0_66_29 VPWR VGND VPWR VGND sky130_ef_sc_hd__decap_12
XFILLER_0_57_234 VGND VGND VPWR VPWR sky130_fd_sc_hd__decap_4
X_2920_ _1470_ VGND VGND VPWR VPWR _0163_ sky130_fd_sc_hd__inv_2
XFILLER_0_15_55 VGND VGND VPWR VPWR sky130_fd_sc_hd__fill_1
X_2782_ _1452_ VGND VGND VPWR VPWR _0043_ sky130_fd_sc_hd__inv_2
X_1733_ reg_file.registers\[15\]\[13\] _0485_ _0467_ reg_file.registers\[5\]\[13\]
+ _0519_ VGND VGND VPWR VPWR _0549_ sky130_fd_sc_hd__a221o_1
X_2851_ _1461_ VGND VGND VPWR VPWR _0103_ sky130_fd_sc_hd__inv_2
XFILLER_0_31_65 VGND VGND VPWR VPWR sky130_fd_sc_hd__fill_1
XFILLER_0_25_153 VGND VGND VPWR VPWR sky130_fd_sc_hd__decap_4
X_1802_ reg_file.registers\[10\]\[28\] _0605_ _0610_ reg_file.registers\[11\]\[28\]
+ VGND VGND VPWR VPWR _0618_ sky130_fd_sc_hd__a22o_1
XTAP_TAPCELL_ROW_13_262 VGND VPWR sky130_fd_sc_hd__tapvpwrvgnd_1
X_1664_ imem.address\[3\] imem.address\[2\] VGND VGND VPWR VPWR _0480_ sky130_fd_sc_hd__and2_1
XFILLER_0_0_253 VPWR VGND VPWR VGND sky130_ef_sc_hd__decap_12
X_1595_ _0436_ VGND VGND VPWR VPWR _0310_ sky130_fd_sc_hd__clkbuf_1
X_2147_ _0959_ _0961_ _0901_ VGND VGND VPWR VPWR _0962_ sky130_fd_sc_hd__mux2_1
X_2216_ _0512_ _0973_ VGND VGND VPWR VPWR _1029_ sky130_fd_sc_hd__or2_1
XFILLER_0_15_3 VPWR VGND VPWR VGND sky130_ef_sc_hd__decap_12
XFILLER_0_63_237 VPWR VGND VPWR VGND sky130_ef_sc_hd__decap_12
X_2078_ _0893_ VGND VGND VPWR VPWR _0894_ sky130_fd_sc_hd__buf_2
XFILLER_0_71_281 VPWR VGND VPWR VGND sky130_ef_sc_hd__decap_12
XFILLER_0_63_259 VPWR VGND VPWR VGND sky130_ef_sc_hd__decap_12
XFILLER_0_31_101 VGND VGND VPWR VPWR sky130_fd_sc_hd__decap_4
XFILLER_0_39_223 VGND VGND VPWR VPWR sky130_fd_sc_hd__fill_1
XFILLER_0_54_215 VGND VGND VPWR VPWR sky130_fd_sc_hd__fill_2
XTAP_TAPCELL_ROW_10_232 VGND VPWR sky130_fd_sc_hd__tapvpwrvgnd_1
XFILLER_0_22_101 VGND VGND VPWR VPWR sky130_fd_sc_hd__fill_1
XFILLER_0_50_421 VPWR VGND VPWR VGND sky130_ef_sc_hd__decap_12
XFILLER_0_22_178 VPWR VGND VPWR VGND sky130_ef_sc_hd__decap_12
XFILLER_0_22_134 VGND VGND VPWR VPWR sky130_fd_sc_hd__decap_3
XFILLER_0_26_65 VGND VGND VPWR VPWR sky130_fd_sc_hd__decap_4
X_3050_ clknet_leaf_17_clk _0273_ _0109_ VGND VGND VPWR VPWR reg_file.registers\[11\]\[20\]
+ sky130_fd_sc_hd__dfrtp_1
X_2001_ _0815_ _0816_ VGND VGND VPWR VPWR _0817_ sky130_fd_sc_hd__or2b_1
XTAP_TAPCELL_ROW_61_644 VGND VPWR sky130_fd_sc_hd__tapvpwrvgnd_1
X_2903_ _1466_ VGND VGND VPWR VPWR _0150_ sky130_fd_sc_hd__inv_2
X_2765_ _1451_ VGND VGND VPWR VPWR _0027_ sky130_fd_sc_hd__inv_2
X_2834_ _1458_ VGND VGND VPWR VPWR _1459_ sky130_fd_sc_hd__buf_1
X_1716_ reg_file.registers\[15\]\[7\] _0485_ _0486_ reg_file.registers\[5\]\[7\] VGND
+ VGND VPWR VPWR _0532_ sky130_fd_sc_hd__a22o_1
XFILLER_0_45_259 VGND VGND VPWR VPWR sky130_fd_sc_hd__decap_8
XFILLER_0_42_97 VGND VGND VPWR VPWR sky130_fd_sc_hd__fill_1
XFILLER_0_41_421 VGND VGND VPWR VPWR sky130_fd_sc_hd__decap_4
X_2696_ _1382_ _1383_ _1393_ VGND VGND VPWR VPWR _1412_ sky130_fd_sc_hd__a21oi_1
XTAP_TAPCELL_ROW_69_711 VGND VPWR sky130_fd_sc_hd__tapvpwrvgnd_1
X_1647_ _0463_ VGND VGND VPWR VPWR _0285_ sky130_fd_sc_hd__clkbuf_1
X_1578_ reg_file.registers\[5\]\[0\] _0392_ VGND VGND VPWR VPWR _0427_ sky130_fd_sc_hd__and2_1
XFILLER_0_6_97 VPWR VGND VPWR VGND sky130_ef_sc_hd__decap_12
XFILLER_0_6_53 VPWR VGND VPWR VGND sky130_ef_sc_hd__decap_12
XFILLER_0_68_307 VGND VGND VPWR VPWR sky130_fd_sc_hd__fill_1
Xrebuffer20 net34 VGND VGND VPWR VPWR net36 sky130_fd_sc_hd__dlymetal6s2s_1
XTAP_TAPCELL_ROW_24_346 VGND VPWR sky130_fd_sc_hd__tapvpwrvgnd_1
XFILLER_0_32_421 VGND VGND VPWR VPWR sky130_fd_sc_hd__fill_2
XFILLER_0_4_3 VPWR VGND VPWR VGND sky130_ef_sc_hd__decap_12
XFILLER_0_67_373 VPWR VGND VPWR VGND sky130_ef_sc_hd__decap_12
XFILLER_0_59_318 VGND VGND VPWR VPWR sky130_fd_sc_hd__decap_3
XFILLER_0_50_251 VGND VGND VPWR VPWR sky130_fd_sc_hd__fill_1
X_2550_ _1311_ VGND VGND VPWR VPWR _0230_ sky130_fd_sc_hd__clkbuf_1
XFILLER_0_35_281 VGND VGND VPWR VPWR sky130_fd_sc_hd__decap_8
XFILLER_0_27_248 VPWR VGND VPWR VGND sky130_ef_sc_hd__decap_12
XFILLER_0_6_109 VPWR VGND VPWR VGND sky130_ef_sc_hd__decap_12
X_1501_ imem.address\[31\] imem.address\[30\] _0380_ VGND VGND VPWR VPWR _0381_ sky130_fd_sc_hd__nor3_4
X_2481_ _0667_ _0668_ VGND VGND VPWR VPWR _1268_ sky130_fd_sc_hd__nand2_1
X_3033_ clknet_leaf_10_clk _0256_ _0092_ VGND VGND VPWR VPWR reg_file.registers\[11\]\[3\]
+ sky130_fd_sc_hd__dfrtp_2
X_3102_ clknet_leaf_3_clk _0325_ _0161_ VGND VGND VPWR VPWR reg_file.registers\[5\]\[8\]
+ sky130_fd_sc_hd__dfrtp_1
XFILLER_0_58_362 VGND VGND VPWR VPWR sky130_fd_sc_hd__fill_2
XTAP_TAPCELL_ROW_21_327 VGND VPWR sky130_fd_sc_hd__tapvpwrvgnd_1
X_2679_ _0509_ _1223_ _1366_ VGND VGND VPWR VPWR _1397_ sky130_fd_sc_hd__and3_1
X_2817_ _1455_ VGND VGND VPWR VPWR _0075_ sky130_fd_sc_hd__inv_2
XFILLER_0_14_432 VPWR VGND VPWR VGND sky130_ef_sc_hd__decap_12
X_2748_ display.counter\[15\] _1438_ VGND VGND VPWR VPWR _1441_ sky130_fd_sc_hd__nor2_1
XFILLER_0_64_365 VGND VGND VPWR VPWR sky130_fd_sc_hd__fill_1
XFILLER_0_64_354 VGND VGND VPWR VPWR sky130_fd_sc_hd__decap_8
XFILLER_0_17_281 VGND VGND VPWR VPWR sky130_fd_sc_hd__decap_4
XFILLER_0_32_295 VPWR VGND VPWR VGND sky130_ef_sc_hd__decap_12
XFILLER_0_55_376 VPWR VGND VPWR VGND sky130_ef_sc_hd__decap_12
XFILLER_0_55_354 VGND VGND VPWR VPWR sky130_fd_sc_hd__fill_1
XTAP_TAPCELL_ROW_43_496 VGND VPWR sky130_fd_sc_hd__tapvpwrvgnd_1
X_1981_ _0747_ _0796_ VGND VGND VPWR VPWR _0797_ sky130_fd_sc_hd__nand2_1
XFILLER_0_23_55 VGND VGND VPWR VPWR sky130_fd_sc_hd__fill_1
XFILLER_0_7_429 VPWR VGND VPWR VGND sky130_ef_sc_hd__decap_12
XFILLER_0_15_218 VGND VGND VPWR VPWR sky130_fd_sc_hd__decap_6
XFILLER_0_70_357 VGND VGND VPWR VPWR sky130_fd_sc_hd__decap_6
X_2602_ _1333_ _1345_ VGND VGND VPWR VPWR _0212_ sky130_fd_sc_hd__nor2_1
X_2533_ _1302_ VGND VGND VPWR VPWR _0238_ sky130_fd_sc_hd__clkbuf_1
XFILLER_0_2_189 VGND VGND VPWR VPWR sky130_fd_sc_hd__decap_6
XFILLER_0_11_424 VGND VGND VPWR VPWR sky130_fd_sc_hd__decap_8
XFILLER_0_15_229 VGND VGND VPWR VPWR sky130_fd_sc_hd__fill_1
X_2464_ reg_file.registers\[11\]\[6\] _1254_ _1234_ VGND VGND VPWR VPWR _1255_ sky130_fd_sc_hd__mux2_1
X_2395_ _0636_ _1193_ _1194_ VGND VGND VPWR VPWR _1195_ sky130_fd_sc_hd__o21ai_1
XFILLER_0_65_107 VGND VGND VPWR VPWR sky130_fd_sc_hd__decap_4
XTAP_TAPCELL_ROW_34_430 VGND VPWR sky130_fd_sc_hd__tapvpwrvgnd_1
X_3016_ clknet_leaf_21_clk _0239_ _0075_ VGND VGND VPWR VPWR reg_file.registers\[15\]\[18\]
+ sky130_fd_sc_hd__dfrtp_1
XFILLER_0_58_192 VGND VGND VPWR VPWR sky130_fd_sc_hd__decap_4
XFILLER_0_58_181 VGND VGND VPWR VPWR sky130_fd_sc_hd__fill_1
XFILLER_0_46_398 VGND VGND VPWR VPWR sky130_fd_sc_hd__fill_2
XFILLER_0_46_365 VPWR VGND VPWR VGND sky130_ef_sc_hd__decap_12
XFILLER_0_46_321 VGND VGND VPWR VPWR sky130_fd_sc_hd__fill_2
XFILLER_0_56_118 VPWR VGND VPWR VGND sky130_ef_sc_hd__decap_12
XTAP_TAPCELL_ROW_40_477 VGND VPWR sky130_fd_sc_hd__tapvpwrvgnd_1
X_2180_ _0801_ _0802_ _0879_ VGND VGND VPWR VPWR _0994_ sky130_fd_sc_hd__mux2_1
XFILLER_0_18_77 VGND VGND VPWR VPWR sky130_fd_sc_hd__decap_6
XPHY_EDGE_ROW_25_Left_97 VGND VGND VPWR VPWR sky130_fd_sc_hd__decap_3
X_1895_ _0488_ net23 VGND VGND VPWR VPWR _0711_ sky130_fd_sc_hd__nor2_1
XFILLER_0_55_173 VGND VGND VPWR VPWR sky130_fd_sc_hd__fill_1
XTAP_TAPCELL_ROW_31_400 VGND VPWR sky130_fd_sc_hd__tapvpwrvgnd_1
XFILLER_0_28_365 VPWR VGND VPWR VGND sky130_ef_sc_hd__decap_12
X_1964_ _0779_ _0568_ VGND VGND VPWR VPWR _0780_ sky130_fd_sc_hd__xnor2_2
XFILLER_0_7_237 VPWR VGND VPWR VGND sky130_ef_sc_hd__decap_12
Xclkbuf_leaf_13_clk clknet_1_1__leaf_clk VGND VGND VPWR VPWR clknet_leaf_13_clk sky130_fd_sc_hd__clkbuf_8
XFILLER_0_59_51 VGND VGND VPWR VPWR sky130_fd_sc_hd__decap_4
XFILLER_0_51_390 VGND VGND VPWR VPWR sky130_fd_sc_hd__fill_2
X_2447_ _1213_ _1215_ _0665_ VGND VGND VPWR VPWR _1241_ sky130_fd_sc_hd__mux2_1
X_2516_ reg_file.registers\[15\]\[25\] _1293_ VGND VGND VPWR VPWR _1294_ sky130_fd_sc_hd__and2_1
XFILLER_0_45_3 VPWR VGND VPWR VGND sky130_ef_sc_hd__decap_12
X_2378_ _1028_ _1108_ _1139_ _1107_ VGND VGND VPWR VPWR _1180_ sky130_fd_sc_hd__a22o_1
XFILLER_0_46_195 VGND VGND VPWR VPWR sky130_fd_sc_hd__fill_1
XFILLER_0_34_346 VGND VGND VPWR VPWR sky130_fd_sc_hd__decap_3
XFILLER_0_57_405 VPWR VGND VPWR VGND sky130_ef_sc_hd__decap_12
XTAP_TAPCELL_ROW_45_514 VGND VPWR sky130_fd_sc_hd__tapvpwrvgnd_1
XFILLER_0_57_449 VGND VGND VPWR VPWR sky130_fd_sc_hd__fill_2
XTAP_TAPCELL_ROW_53_580 VGND VPWR sky130_fd_sc_hd__tapvpwrvgnd_1
XFILLER_0_25_346 VPWR VGND VPWR VGND sky130_ef_sc_hd__decap_12
XFILLER_0_25_335 VGND VGND VPWR VPWR sky130_fd_sc_hd__fill_1
XFILLER_0_25_324 VGND VGND VPWR VPWR sky130_fd_sc_hd__decap_4
X_1680_ reg_file.registers\[5\]\[3\] _0486_ _0493_ _0495_ VGND VGND VPWR VPWR _0496_
+ sky130_fd_sc_hd__a211o_1
X_2301_ _0894_ _0988_ _1042_ _1110_ VGND VGND VPWR VPWR _1111_ sky130_fd_sc_hd__o211a_1
Xclkbuf_leaf_2_clk clknet_1_0__leaf_clk VGND VGND VPWR VPWR clknet_leaf_2_clk sky130_fd_sc_hd__clkbuf_8
X_2163_ _0974_ _0977_ net36 VGND VGND VPWR VPWR _0978_ sky130_fd_sc_hd__mux2_1
X_2232_ _0894_ _1040_ _1042_ _1044_ VGND VGND VPWR VPWR _1045_ sky130_fd_sc_hd__o211a_1
XFILLER_0_61_85 VGND VGND VPWR VPWR sky130_fd_sc_hd__decap_8
X_2094_ _0909_ VGND VGND VPWR VPWR _0910_ sky130_fd_sc_hd__clkbuf_4
XTAP_TAPCELL_ROW_16_282 VGND VPWR sky130_fd_sc_hd__tapvpwrvgnd_1
X_1878_ _0690_ _0691_ VGND VGND VPWR VPWR _0694_ sky130_fd_sc_hd__nand2_1
XFILLER_0_43_154 VGND VGND VPWR VPWR sky130_fd_sc_hd__fill_2
XFILLER_0_43_110 VGND VGND VPWR VPWR sky130_fd_sc_hd__fill_2
X_1947_ net26 _0552_ _0746_ _0557_ VGND VGND VPWR VPWR _0763_ sky130_fd_sc_hd__a31o_1
X_2996_ clknet_leaf_13_clk _0005_ VGND VGND VPWR VPWR net15 sky130_fd_sc_hd__dfxtp_1
XTAP_TAPCELL_ROW_59_628 VGND VPWR sky130_fd_sc_hd__tapvpwrvgnd_1
XFILLER_0_3_273 VGND VGND VPWR VPWR sky130_fd_sc_hd__decap_6
XTAP_TAPCELL_ROW_8_217 VGND VPWR sky130_fd_sc_hd__tapvpwrvgnd_1
XTAP_TAPCELL_ROW_67_694 VGND VPWR sky130_fd_sc_hd__tapvpwrvgnd_1
XFILLER_0_39_405 VGND VGND VPWR VPWR sky130_fd_sc_hd__decap_8
XFILLER_0_54_419 VGND VGND VPWR VPWR sky130_fd_sc_hd__fill_1
XFILLER_0_39_449 VGND VGND VPWR VPWR sky130_fd_sc_hd__fill_2
XFILLER_0_34_154 VGND VGND VPWR VPWR sky130_fd_sc_hd__fill_1
XFILLER_0_30_371 VGND VGND VPWR VPWR sky130_fd_sc_hd__fill_1
XFILLER_0_57_246 VGND VGND VPWR VPWR sky130_fd_sc_hd__decap_8
X_2850_ _1461_ VGND VGND VPWR VPWR _0102_ sky130_fd_sc_hd__inv_2
XFILLER_0_15_89 VGND VGND VPWR VPWR sky130_fd_sc_hd__decap_3
X_2781_ _1452_ VGND VGND VPWR VPWR _0042_ sky130_fd_sc_hd__inv_2
X_1663_ imem.address\[3\] _0372_ VGND VGND VPWR VPWR _0479_ sky130_fd_sc_hd__nor2_1
X_1732_ _0478_ _0547_ VGND VGND VPWR VPWR _0548_ sky130_fd_sc_hd__nand2_1
XFILLER_0_31_77 VGND VGND VPWR VPWR sky130_fd_sc_hd__fill_1
XFILLER_0_31_55 VGND VGND VPWR VPWR sky130_fd_sc_hd__fill_1
XFILLER_0_25_165 VGND VGND VPWR VPWR sky130_fd_sc_hd__decap_3
XTAP_TAPCELL_ROW_13_263 VGND VPWR sky130_fd_sc_hd__tapvpwrvgnd_1
X_1801_ _0589_ _0591_ VGND VGND VPWR VPWR _0617_ sky130_fd_sc_hd__xnor2_1
XFILLER_0_0_221 VGND VGND VPWR VPWR sky130_fd_sc_hd__decap_3
XFILLER_0_0_265 VPWR VGND VPWR VGND sky130_ef_sc_hd__decap_12
XPHY_EDGE_ROW_7_Right_7 VGND VGND VPWR VPWR sky130_fd_sc_hd__decap_3
X_1594_ reg_file.registers\[10\]\[25\] _0429_ VGND VGND VPWR VPWR _0436_ sky130_fd_sc_hd__and2_1
XFILLER_0_21_393 VGND VGND VPWR VPWR sky130_fd_sc_hd__decap_8
XFILLER_0_56_85 VPWR VGND VPWR VGND sky130_ef_sc_hd__decap_12
X_2146_ _0681_ _0960_ _0673_ VGND VGND VPWR VPWR _0961_ sky130_fd_sc_hd__mux2_1
X_2215_ _0909_ _0939_ VGND VGND VPWR VPWR _1028_ sky130_fd_sc_hd__and2_2
X_2077_ _0665_ VGND VGND VPWR VPWR _0893_ sky130_fd_sc_hd__clkbuf_4
X_2979_ clknet_leaf_5_clk _0209_ _0045_ VGND VGND VPWR VPWR imem.address\[20\] sky130_fd_sc_hd__dfrtp_1
XTAP_TAPCELL_ROW_64_664 VGND VPWR sky130_fd_sc_hd__tapvpwrvgnd_1
XFILLER_0_63_249 VGND VGND VPWR VPWR sky130_fd_sc_hd__decap_4
XFILLER_0_48_268 VGND VGND VPWR VPWR sky130_fd_sc_hd__fill_1
XFILLER_0_36_419 VGND VGND VPWR VPWR sky130_fd_sc_hd__fill_1
XFILLER_0_8_321 VGND VGND VPWR VPWR sky130_fd_sc_hd__decap_8
XFILLER_0_71_293 VPWR VGND VPWR VGND sky130_ef_sc_hd__decap_12
XPHY_EDGE_ROW_12_Left_84 VGND VGND VPWR VPWR sky130_fd_sc_hd__decap_3
XFILLER_0_16_176 VGND VGND VPWR VPWR sky130_fd_sc_hd__fill_1
XFILLER_0_39_202 VGND VGND VPWR VPWR sky130_fd_sc_hd__fill_2
XFILLER_0_54_227 VGND VGND VPWR VPWR sky130_fd_sc_hd__decap_4
XFILLER_0_50_433 VGND VGND VPWR VPWR sky130_fd_sc_hd__fill_2
XTAP_TAPCELL_ROW_10_233 VGND VPWR sky130_fd_sc_hd__tapvpwrvgnd_1
X_2000_ _0813_ _0814_ VGND VGND VPWR VPWR _0816_ sky130_fd_sc_hd__nand2_1
XTAP_TAPCELL_ROW_18_300 VGND VPWR sky130_fd_sc_hd__tapvpwrvgnd_1
XTAP_TAPCELL_ROW_61_645 VGND VPWR sky130_fd_sc_hd__tapvpwrvgnd_1
X_2833_ _1449_ VGND VGND VPWR VPWR _1458_ sky130_fd_sc_hd__buf_1
X_2902_ _1466_ VGND VGND VPWR VPWR _0149_ sky130_fd_sc_hd__inv_2
XFILLER_0_18_419 VGND VGND VPWR VPWR sky130_fd_sc_hd__fill_1
X_2764_ _1450_ VGND VGND VPWR VPWR _1451_ sky130_fd_sc_hd__buf_4
XFILLER_0_60_208 VGND VGND VPWR VPWR sky130_fd_sc_hd__fill_1
X_1646_ reg_file.registers\[10\]\[0\] _0428_ VGND VGND VPWR VPWR _0463_ sky130_fd_sc_hd__and2_1
XFILLER_0_53_293 VGND VGND VPWR VPWR sky130_fd_sc_hd__fill_1
X_1715_ _0516_ _0530_ VGND VGND VPWR VPWR _0531_ sky130_fd_sc_hd__and2_1
X_2695_ _1377_ _1409_ _1410_ _1411_ _1408_ VGND VGND VPWR VPWR _0001_ sky130_fd_sc_hd__a311o_1
XFILLER_0_5_335 VGND VGND VPWR VPWR sky130_fd_sc_hd__fill_1
XFILLER_0_13_113 VGND VGND VPWR VPWR sky130_fd_sc_hd__decap_6
XFILLER_0_67_51 VGND VGND VPWR VPWR sky130_fd_sc_hd__decap_4
X_1577_ _0426_ VGND VGND VPWR VPWR _0318_ sky130_fd_sc_hd__clkbuf_1
XFILLER_0_6_65 VPWR VGND VPWR VGND sky130_ef_sc_hd__decap_12
Xrebuffer21 net36 VGND VGND VPWR VPWR net37 sky130_fd_sc_hd__dlygate4sd1_1
X_2129_ _0760_ _0767_ _0878_ VGND VGND VPWR VPWR _0944_ sky130_fd_sc_hd__mux2_1
XTAP_TAPCELL_ROW_24_347 VGND VPWR sky130_fd_sc_hd__tapvpwrvgnd_1
XFILLER_0_8_195 VGND VGND VPWR VPWR sky130_fd_sc_hd__fill_1
XFILLER_0_67_385 VGND VGND VPWR VPWR sky130_fd_sc_hd__decap_6
X_1500_ imem.address\[29\] imem.address\[28\] imem.address\[27\] imem.address\[26\]
+ VGND VGND VPWR VPWR _0380_ sky130_fd_sc_hd__or4_1
X_2480_ _1267_ VGND VGND VPWR VPWR _0256_ sky130_fd_sc_hd__clkbuf_1
XFILLER_0_42_208 VGND VGND VPWR VPWR sky130_fd_sc_hd__decap_3
XFILLER_0_35_260 VGND VGND VPWR VPWR sky130_fd_sc_hd__decap_6
X_3101_ clknet_leaf_3_clk _0324_ _0160_ VGND VGND VPWR VPWR reg_file.registers\[5\]\[7\]
+ sky130_fd_sc_hd__dfrtp_1
X_3032_ clknet_leaf_10_clk _0255_ _0091_ VGND VGND VPWR VPWR reg_file.registers\[11\]\[2\]
+ sky130_fd_sc_hd__dfrtp_1
X_2816_ _1455_ VGND VGND VPWR VPWR _0074_ sky130_fd_sc_hd__inv_2
XFILLER_0_18_249 VGND VGND VPWR VPWR sky130_fd_sc_hd__decap_3
X_1629_ _0454_ VGND VGND VPWR VPWR _0294_ sky130_fd_sc_hd__clkbuf_1
XFILLER_0_41_296 VGND VGND VPWR VPWR sky130_fd_sc_hd__decap_3
X_2678_ _1187_ _1362_ _1371_ _1395_ VGND VGND VPWR VPWR _1396_ sky130_fd_sc_hd__a211o_1
XFILLER_0_1_393 VPWR VGND VPWR VGND sky130_ef_sc_hd__decap_12
XFILLER_0_14_444 VGND VGND VPWR VPWR sky130_fd_sc_hd__decap_6
X_2747_ display.counter\[15\] _1438_ VGND VGND VPWR VPWR _1440_ sky130_fd_sc_hd__and2_1
XFILLER_0_68_149 VGND VGND VPWR VPWR sky130_fd_sc_hd__fill_1
XFILLER_0_68_138 VGND VGND VPWR VPWR sky130_fd_sc_hd__fill_2
XFILLER_0_68_116 VGND VGND VPWR VPWR sky130_fd_sc_hd__fill_1
XFILLER_0_64_322 VPWR VGND VPWR VGND sky130_ef_sc_hd__decap_12
XTAP_TAPCELL_ROW_37_450 VGND VPWR sky130_fd_sc_hd__tapvpwrvgnd_1
XFILLER_0_17_260 VPWR VGND VPWR VGND sky130_ef_sc_hd__decap_12
XFILLER_0_55_388 VGND VGND VPWR VPWR sky130_fd_sc_hd__fill_1
XFILLER_0_55_333 VGND VGND VPWR VPWR sky130_fd_sc_hd__decap_3
XTAP_TAPCELL_ROW_43_497 VGND VPWR sky130_fd_sc_hd__tapvpwrvgnd_1
X_1980_ reg_file.registers\[10\]\[16\] _0604_ _0609_ reg_file.registers\[11\]\[16\]
+ VGND VGND VPWR VPWR _0796_ sky130_fd_sc_hd__a22o_1
X_2601_ imem.address\[22\] _1332_ imem.address\[23\] VGND VGND VPWR VPWR _1345_ sky130_fd_sc_hd__a21oi_1
X_2463_ _0470_ _0698_ _1253_ _1041_ _0971_ VGND VGND VPWR VPWR _1254_ sky130_fd_sc_hd__a32o_1
Xrebuffer1 _0542_ VGND VGND VPWR VPWR net17 sky130_fd_sc_hd__buf_6
X_2532_ reg_file.registers\[15\]\[17\] _1293_ VGND VGND VPWR VPWR _1302_ sky130_fd_sc_hd__and2_1
XFILLER_0_48_75 VGND VGND VPWR VPWR sky130_fd_sc_hd__fill_1
X_2394_ _0628_ _0630_ VGND VGND VPWR VPWR _1194_ sky130_fd_sc_hd__nor2_1
X_3015_ clknet_leaf_21_clk _0238_ _0074_ VGND VGND VPWR VPWR reg_file.registers\[15\]\[17\]
+ sky130_fd_sc_hd__dfrtp_1
XFILLER_0_3_55 VGND VGND VPWR VPWR sky130_fd_sc_hd__fill_1
XFILLER_0_64_85 VGND VGND VPWR VPWR sky130_fd_sc_hd__decap_8
XFILLER_0_64_74 VGND VGND VPWR VPWR sky130_fd_sc_hd__decap_4
XFILLER_0_58_171 VGND VGND VPWR VPWR sky130_fd_sc_hd__fill_1
XFILLER_0_58_160 VGND VGND VPWR VPWR sky130_fd_sc_hd__fill_2
XTAP_TAPCELL_ROW_34_431 VGND VPWR sky130_fd_sc_hd__tapvpwrvgnd_1
XFILLER_0_61_314 VGND VGND VPWR VPWR sky130_fd_sc_hd__decap_8
XFILLER_0_46_377 VGND VGND VPWR VPWR sky130_fd_sc_hd__decap_6
XFILLER_0_46_355 VGND VGND VPWR VPWR sky130_fd_sc_hd__decap_8
XFILLER_0_69_447 VGND VGND VPWR VPWR sky130_fd_sc_hd__fill_1
XFILLER_0_52_303 VGND VGND VPWR VPWR sky130_fd_sc_hd__decap_4
XTAP_TAPCELL_ROW_40_478 VGND VPWR sky130_fd_sc_hd__tapvpwrvgnd_1
XPHY_EDGE_ROW_0_Left_72 VGND VGND VPWR VPWR sky130_fd_sc_hd__decap_3
XFILLER_0_20_288 VGND VGND VPWR VPWR sky130_fd_sc_hd__fill_1
XTAP_TAPCELL_ROW_31_401 VGND VPWR sky130_fd_sc_hd__tapvpwrvgnd_1
XFILLER_0_7_205 VPWR VGND VPWR VGND sky130_ef_sc_hd__decap_12
X_1894_ _0708_ _0709_ VGND VGND VPWR VPWR _0710_ sky130_fd_sc_hd__xnor2_1
XFILLER_0_28_399 VGND VGND VPWR VPWR sky130_fd_sc_hd__decap_4
XFILLER_0_28_377 VGND VGND VPWR VPWR sky130_fd_sc_hd__decap_4
X_1963_ _0565_ _0572_ _0574_ VGND VGND VPWR VPWR _0779_ sky130_fd_sc_hd__nand3b_2
XFILLER_0_7_249 VPWR VGND VPWR VGND sky130_ef_sc_hd__decap_12
XFILLER_0_59_85 VGND VGND VPWR VPWR sky130_fd_sc_hd__decap_8
X_2446_ _0727_ _1225_ _0715_ _0721_ VGND VGND VPWR VPWR _1240_ sky130_fd_sc_hd__a211o_1
X_2515_ _1285_ VGND VGND VPWR VPWR _1293_ sky130_fd_sc_hd__clkbuf_2
XFILLER_0_11_233 VGND VGND VPWR VPWR sky130_fd_sc_hd__decap_4
XFILLER_0_11_266 VGND VGND VPWR VPWR sky130_fd_sc_hd__decap_3
XFILLER_0_11_277 VGND VGND VPWR VPWR sky130_fd_sc_hd__decap_3
XFILLER_0_38_3 VPWR VGND VPWR VGND sky130_ef_sc_hd__decap_12
X_2377_ _0750_ _0752_ _0769_ _1178_ _0498_ VGND VGND VPWR VPWR _1179_ sky130_fd_sc_hd__a311oi_1
XFILLER_0_46_163 VGND VGND VPWR VPWR sky130_fd_sc_hd__fill_1
XFILLER_0_46_141 VGND VGND VPWR VPWR sky130_fd_sc_hd__decap_4
XFILLER_0_34_325 VGND VGND VPWR VPWR sky130_fd_sc_hd__fill_1
XFILLER_0_19_377 VGND VGND VPWR VPWR sky130_fd_sc_hd__fill_1
XFILLER_0_57_417 VPWR VGND VPWR VGND sky130_ef_sc_hd__decap_12
XTAP_TAPCELL_ROW_45_515 VGND VPWR sky130_fd_sc_hd__tapvpwrvgnd_1
XTAP_TAPCELL_ROW_2_170 VGND VPWR sky130_fd_sc_hd__tapvpwrvgnd_1
XTAP_TAPCELL_ROW_53_581 VGND VPWR sky130_fd_sc_hd__tapvpwrvgnd_1
XFILLER_0_40_317 VGND VGND VPWR VPWR sky130_fd_sc_hd__decap_4
XFILLER_0_40_306 VGND VGND VPWR VPWR sky130_fd_sc_hd__fill_2
XFILLER_0_37_163 VGND VGND VPWR VPWR sky130_fd_sc_hd__decap_4
XFILLER_0_25_358 VGND VGND VPWR VPWR sky130_fd_sc_hd__decap_8
XFILLER_0_40_339 VGND VGND VPWR VPWR sky130_fd_sc_hd__decap_8
XFILLER_0_33_391 VGND VGND VPWR VPWR sky130_fd_sc_hd__fill_1
X_2300_ _0897_ _0995_ VGND VGND VPWR VPWR _1110_ sky130_fd_sc_hd__or2_1
XFILLER_0_29_66 VGND VGND VPWR VPWR sky130_fd_sc_hd__fill_1
X_2231_ _0891_ _0951_ _1043_ VGND VGND VPWR VPWR _1044_ sky130_fd_sc_hd__a21o_1
X_2162_ _0975_ _0976_ _0901_ VGND VGND VPWR VPWR _0977_ sky130_fd_sc_hd__mux2_1
X_2093_ _0497_ VGND VGND VPWR VPWR _0909_ sky130_fd_sc_hd__clkbuf_4
XFILLER_0_48_439 VPWR VGND VPWR VGND sky130_ef_sc_hd__decap_12
XFILLER_0_28_130 VGND VGND VPWR VPWR sky130_fd_sc_hd__decap_4
XTAP_TAPCELL_ROW_16_283 VGND VPWR sky130_fd_sc_hd__tapvpwrvgnd_1
X_2995_ clknet_leaf_13_clk _0004_ VGND VGND VPWR VPWR net14 sky130_fd_sc_hd__dfxtp_1
X_1877_ _0662_ _0663_ VGND VGND VPWR VPWR _0693_ sky130_fd_sc_hd__nand2_1
XFILLER_0_43_166 VGND VGND VPWR VPWR sky130_fd_sc_hd__fill_2
X_1946_ _0759_ _0761_ VGND VGND VPWR VPWR _0762_ sky130_fd_sc_hd__nand2_1
XTAP_TAPCELL_ROW_8_218 VGND VPWR sky130_fd_sc_hd__tapvpwrvgnd_1
XTAP_TAPCELL_ROW_59_629 VGND VPWR sky130_fd_sc_hd__tapvpwrvgnd_1
X_2429_ _0728_ _0706_ VGND VGND VPWR VPWR _1225_ sky130_fd_sc_hd__or2_1
XTAP_TAPCELL_ROW_67_695 VGND VPWR sky130_fd_sc_hd__tapvpwrvgnd_1
XFILLER_0_22_339 VGND VGND VPWR VPWR sky130_fd_sc_hd__fill_1
XFILLER_0_15_391 VGND VGND VPWR VPWR sky130_fd_sc_hd__fill_1
XFILLER_0_57_269 VGND VGND VPWR VPWR sky130_fd_sc_hd__decap_8
XFILLER_0_57_203 VGND VGND VPWR VPWR sky130_fd_sc_hd__fill_1
X_1800_ _0614_ _0615_ VGND VGND VPWR VPWR _0616_ sky130_fd_sc_hd__nand2_1
XFILLER_0_15_57 VPWR VGND VPWR VGND sky130_ef_sc_hd__decap_12
X_2780_ _1452_ VGND VGND VPWR VPWR _0041_ sky130_fd_sc_hd__inv_2
X_1662_ _0477_ VGND VGND VPWR VPWR _0478_ sky130_fd_sc_hd__buf_2
XFILLER_0_40_136 VGND VGND VPWR VPWR sky130_fd_sc_hd__decap_4
X_1731_ reg_file.registers\[15\]\[12\] _0485_ _0467_ reg_file.registers\[5\]\[12\]
+ VGND VGND VPWR VPWR _0547_ sky130_fd_sc_hd__a22o_1
X_2214_ _1023_ _1026_ _0897_ VGND VGND VPWR VPWR _1027_ sky130_fd_sc_hd__mux2_1
XFILLER_0_0_277 VGND VGND VPWR VPWR sky130_fd_sc_hd__decap_3
X_1593_ _0435_ VGND VGND VPWR VPWR _0311_ sky130_fd_sc_hd__clkbuf_1
XFILLER_0_21_361 VGND VGND VPWR VPWR sky130_fd_sc_hd__decap_8
XTAP_TAPCELL_ROW_64_665 VGND VPWR sky130_fd_sc_hd__tapvpwrvgnd_1
X_2145_ reg_file.registers\[10\]\[4\] _0604_ _0609_ reg_file.registers\[11\]\[4\]
+ VGND VGND VPWR VPWR _0960_ sky130_fd_sc_hd__a22o_1
X_2076_ _0886_ _0890_ _0891_ VGND VGND VPWR VPWR _0892_ sky130_fd_sc_hd__mux2_1
X_2978_ clknet_leaf_5_clk _0208_ _0044_ VGND VGND VPWR VPWR imem.address\[19\] sky130_fd_sc_hd__dfrtp_1
X_1929_ _0732_ _0739_ _0743_ _0744_ VGND VGND VPWR VPWR _0745_ sky130_fd_sc_hd__a211o_1
XFILLER_0_16_111 VGND VGND VPWR VPWR sky130_fd_sc_hd__decap_4
XFILLER_0_31_169 VPWR VGND VPWR VGND sky130_ef_sc_hd__decap_12
XFILLER_0_31_158 VGND VGND VPWR VPWR sky130_fd_sc_hd__decap_8
XFILLER_0_54_239 VPWR VGND VPWR VGND sky130_ef_sc_hd__decap_12
XTAP_TAPCELL_ROW_10_234 VGND VPWR sky130_fd_sc_hd__tapvpwrvgnd_1
XFILLER_0_10_309 VGND VGND VPWR VPWR sky130_fd_sc_hd__fill_2
XTAP_TAPCELL_ROW_18_301 VGND VPWR sky130_fd_sc_hd__tapvpwrvgnd_1
XTAP_TAPCELL_ROW_61_646 VGND VPWR sky130_fd_sc_hd__tapvpwrvgnd_1
X_2763_ _1449_ VGND VGND VPWR VPWR _1450_ sky130_fd_sc_hd__buf_2
X_2832_ _1457_ VGND VGND VPWR VPWR _0088_ sky130_fd_sc_hd__inv_2
X_2901_ _1466_ VGND VGND VPWR VPWR _0148_ sky130_fd_sc_hd__inv_2
X_1645_ _0462_ VGND VGND VPWR VPWR _0286_ sky130_fd_sc_hd__clkbuf_1
X_1714_ reg_file.registers\[15\]\[6\] _0485_ _0486_ reg_file.registers\[5\]\[6\] _0529_
+ VGND VGND VPWR VPWR _0530_ sky130_fd_sc_hd__a221o_1
X_1576_ reg_file.registers\[5\]\[1\] _0393_ VGND VGND VPWR VPWR _0426_ sky130_fd_sc_hd__or2b_1
X_2694_ _1375_ _1376_ _1385_ _1402_ VGND VGND VPWR VPWR _1411_ sky130_fd_sc_hd__and4_1
XFILLER_0_13_169 VPWR VGND VPWR VGND sky130_ef_sc_hd__decap_12
XFILLER_0_21_191 VGND VGND VPWR VPWR sky130_fd_sc_hd__fill_2
Xrebuffer11 _0565_ VGND VGND VPWR VPWR net27 sky130_fd_sc_hd__dlygate4sd1_1
XFILLER_0_6_77 VGND VGND VPWR VPWR sky130_fd_sc_hd__decap_6
XFILLER_0_20_3 VPWR VGND VPWR VGND sky130_ef_sc_hd__decap_12
XFILLER_0_68_309 VPWR VGND VPWR VGND sky130_ef_sc_hd__decap_12
X_2128_ _0941_ _0942_ _0902_ VGND VGND VPWR VPWR _0943_ sky130_fd_sc_hd__mux2_1
X_2059_ reg_file.registers\[11\]\[18\] _0867_ _0868_ reg_file.registers\[10\]\[18\]
+ VGND VGND VPWR VPWR _0875_ sky130_fd_sc_hd__a22o_1
XTAP_TAPCELL_ROW_24_348 VGND VPWR sky130_fd_sc_hd__tapvpwrvgnd_1
XFILLER_0_8_141 VPWR VGND VPWR VGND sky130_ef_sc_hd__decap_12
XFILLER_0_67_320 VPWR VGND VPWR VGND sky130_ef_sc_hd__decap_12
XFILLER_0_23_445 VGND VGND VPWR VPWR sky130_fd_sc_hd__decap_3
XFILLER_0_10_139 VGND VGND VPWR VPWR sky130_fd_sc_hd__fill_1
X_3031_ clknet_leaf_7_clk _0254_ _0090_ VGND VGND VPWR VPWR reg_file.registers\[11\]\[1\]
+ sky130_fd_sc_hd__dfrtp_1
X_3100_ clknet_leaf_3_clk _0323_ _0159_ VGND VGND VPWR VPWR reg_file.registers\[5\]\[6\]
+ sky130_fd_sc_hd__dfrtp_1
XFILLER_0_37_66 VGND VGND VPWR VPWR sky130_fd_sc_hd__decap_8
XFILLER_0_37_55 VGND VGND VPWR VPWR sky130_fd_sc_hd__fill_1
XFILLER_0_53_98 VGND VGND VPWR VPWR sky130_fd_sc_hd__decap_8
XFILLER_0_41_242 VGND VGND VPWR VPWR sky130_fd_sc_hd__decap_6
XFILLER_0_41_220 VGND VGND VPWR VPWR sky130_fd_sc_hd__decap_4
X_2815_ _1455_ VGND VGND VPWR VPWR _0073_ sky130_fd_sc_hd__inv_2
XFILLER_0_5_111 VGND VGND VPWR VPWR sky130_fd_sc_hd__fill_1
X_2746_ _1438_ _1439_ VGND VGND VPWR VPWR _0012_ sky130_fd_sc_hd__nor2_1
XFILLER_0_68_3 VPWR VGND VPWR VGND sky130_ef_sc_hd__decap_12
X_1628_ reg_file.registers\[10\]\[9\] _0449_ VGND VGND VPWR VPWR _0454_ sky130_fd_sc_hd__and2_1
X_2677_ _1246_ _1394_ _1369_ _1263_ VGND VGND VPWR VPWR _1395_ sky130_fd_sc_hd__a22o_1
X_1559_ _0417_ VGND VGND VPWR VPWR _0327_ sky130_fd_sc_hd__clkbuf_1
XFILLER_0_1_361 VPWR VGND VPWR VGND sky130_ef_sc_hd__decap_12
XTAP_TAPCELL_ROW_37_451 VGND VPWR sky130_fd_sc_hd__tapvpwrvgnd_1
XFILLER_0_64_334 VGND VGND VPWR VPWR sky130_fd_sc_hd__decap_4
XFILLER_0_64_312 VGND VGND VPWR VPWR sky130_fd_sc_hd__decap_4
XFILLER_0_32_275 VGND VGND VPWR VPWR sky130_fd_sc_hd__fill_1
XFILLER_0_17_272 VGND VGND VPWR VPWR sky130_fd_sc_hd__decap_8
XTAP_TAPCELL_ROW_71_730 VGND VPWR sky130_fd_sc_hd__tapvpwrvgnd_1
X_2600_ _1334_ _1344_ VGND VGND VPWR VPWR _0213_ sky130_fd_sc_hd__nor2_1
Xrebuffer2 net26 VGND VGND VPWR VPWR net18 sky130_fd_sc_hd__dlygate4sd1_1
XTAP_TAPCELL_ROW_43_498 VGND VPWR sky130_fd_sc_hd__tapvpwrvgnd_1
XFILLER_0_23_57 VPWR VGND VPWR VGND sky130_ef_sc_hd__decap_12
XFILLER_0_7_409 VGND VGND VPWR VPWR sky130_fd_sc_hd__fill_1
X_2462_ _0664_ _0695_ _0697_ VGND VGND VPWR VPWR _1253_ sky130_fd_sc_hd__o21bai_1
X_2393_ _0742_ _1190_ _1192_ _0740_ VGND VGND VPWR VPWR _1193_ sky130_fd_sc_hd__o211a_1
X_2531_ _1301_ VGND VGND VPWR VPWR _0239_ sky130_fd_sc_hd__clkbuf_1
X_3014_ clknet_leaf_21_clk _0237_ _0073_ VGND VGND VPWR VPWR reg_file.registers\[15\]\[16\]
+ sky130_fd_sc_hd__dfrtp_1
XFILLER_0_61_337 VPWR VGND VPWR VGND sky130_ef_sc_hd__decap_12
X_2729_ display.counter\[7\] _1428_ VGND VGND VPWR VPWR _0024_ sky130_fd_sc_hd__xor2_1
XFILLER_0_14_253 VPWR VGND VPWR VGND sky130_ef_sc_hd__decap_12
XPHY_EDGE_ROW_29_Right_29 VGND VGND VPWR VPWR sky130_fd_sc_hd__decap_3
XFILLER_0_64_197 VGND VGND VPWR VPWR sky130_fd_sc_hd__decap_8
XTAP_TAPCELL_ROW_40_479 VGND VPWR sky130_fd_sc_hd__tapvpwrvgnd_1
XPHY_EDGE_ROW_38_Right_38 VGND VGND VPWR VPWR sky130_fd_sc_hd__decap_3
XFILLER_0_37_389 VGND VGND VPWR VPWR sky130_fd_sc_hd__decap_3
XFILLER_0_37_334 VGND VGND VPWR VPWR sky130_fd_sc_hd__fill_2
XPHY_EDGE_ROW_47_Right_47 VGND VGND VPWR VPWR sky130_fd_sc_hd__decap_3
XPHY_EDGE_ROW_56_Right_56 VGND VGND VPWR VPWR sky130_fd_sc_hd__decap_3
XFILLER_0_55_120 VPWR VGND VPWR VGND sky130_ef_sc_hd__decap_12
XTAP_TAPCELL_ROW_31_402 VGND VPWR sky130_fd_sc_hd__tapvpwrvgnd_1
XFILLER_0_28_301 VGND VGND VPWR VPWR sky130_fd_sc_hd__fill_1
XFILLER_0_7_217 VGND VGND VPWR VPWR sky130_fd_sc_hd__decap_6
X_1962_ _0774_ _0777_ VGND VGND VPWR VPWR _0778_ sky130_fd_sc_hd__xnor2_2
XFILLER_0_70_145 VGND VGND VPWR VPWR sky130_fd_sc_hd__fill_1
X_1893_ reg_file.registers\[10\]\[11\] _0620_ _0622_ reg_file.registers\[11\]\[11\]
+ VGND VGND VPWR VPWR _0709_ sky130_fd_sc_hd__a22o_1
XFILLER_0_59_31 VGND VGND VPWR VPWR sky130_fd_sc_hd__fill_1
XFILLER_0_43_337 VPWR VGND VPWR VGND sky130_ef_sc_hd__decap_12
XFILLER_0_11_223 VGND VGND VPWR VPWR sky130_fd_sc_hd__fill_1
XPHY_EDGE_ROW_65_Right_65 VGND VGND VPWR VPWR sky130_fd_sc_hd__decap_3
XFILLER_0_59_75 VGND VGND VPWR VPWR sky130_fd_sc_hd__fill_2
X_2445_ _0715_ _0721_ _0727_ _1225_ VGND VGND VPWR VPWR _1239_ sky130_fd_sc_hd__o211ai_1
X_2376_ _0750_ _0752_ _0769_ VGND VGND VPWR VPWR _1178_ sky130_fd_sc_hd__a21oi_1
X_2514_ _1292_ VGND VGND VPWR VPWR _0247_ sky130_fd_sc_hd__clkbuf_1
XFILLER_0_61_101 VGND VGND VPWR VPWR sky130_fd_sc_hd__decap_8
XFILLER_0_61_167 VGND VGND VPWR VPWR sky130_fd_sc_hd__fill_1
XFILLER_0_61_156 VGND VGND VPWR VPWR sky130_fd_sc_hd__decap_3
XFILLER_0_69_223 VGND VGND VPWR VPWR sky130_fd_sc_hd__fill_1
XFILLER_0_57_429 VGND VGND VPWR VPWR sky130_fd_sc_hd__decap_3
XTAP_TAPCELL_ROW_53_582 VGND VPWR sky130_fd_sc_hd__tapvpwrvgnd_1
XTAP_TAPCELL_ROW_45_516 VGND VPWR sky130_fd_sc_hd__tapvpwrvgnd_1
XFILLER_0_29_109 VGND VGND VPWR VPWR sky130_fd_sc_hd__decap_3
XTAP_TAPCELL_ROW_2_171 VGND VPWR sky130_fd_sc_hd__tapvpwrvgnd_1
XFILLER_0_52_123 VGND VGND VPWR VPWR sky130_fd_sc_hd__decap_8
XFILLER_0_4_209 VPWR VGND VPWR VGND sky130_ef_sc_hd__decap_12
X_2230_ _0903_ _0953_ _0897_ VGND VGND VPWR VPWR _1043_ sky130_fd_sc_hd__a21o_1
X_2161_ _0726_ _0702_ _0877_ VGND VGND VPWR VPWR _0976_ sky130_fd_sc_hd__mux2_1
XFILLER_0_45_99 VGND VGND VPWR VPWR sky130_fd_sc_hd__fill_2
X_2092_ _0891_ _0905_ _0907_ _0894_ VGND VGND VPWR VPWR _0908_ sky130_fd_sc_hd__o211a_1
XFILLER_0_71_421 VPWR VGND VPWR VGND sky130_ef_sc_hd__decap_12
XFILLER_0_48_429 VGND VGND VPWR VPWR sky130_fd_sc_hd__decap_3
X_1945_ _0757_ _0760_ VGND VGND VPWR VPWR _0761_ sky130_fd_sc_hd__nand2_1
XFILLER_0_0_57 VPWR VGND VPWR VGND sky130_ef_sc_hd__decap_12
XTAP_TAPCELL_ROW_16_284 VGND VPWR sky130_fd_sc_hd__tapvpwrvgnd_1
XFILLER_0_16_315 VGND VGND VPWR VPWR sky130_fd_sc_hd__decap_4
XFILLER_0_16_348 VPWR VGND VPWR VGND sky130_ef_sc_hd__decap_12
X_2994_ clknet_leaf_13_clk _0003_ VGND VGND VPWR VPWR net13 sky130_fd_sc_hd__dfxtp_1
X_1876_ _0690_ _0691_ VGND VGND VPWR VPWR _0692_ sky130_fd_sc_hd__xnor2_1
XFILLER_0_31_318 VGND VGND VPWR VPWR sky130_fd_sc_hd__decap_8
XFILLER_0_24_392 VPWR VGND VPWR VGND sky130_ef_sc_hd__decap_12
XTAP_TAPCELL_ROW_8_219 VGND VPWR sky130_fd_sc_hd__tapvpwrvgnd_1
XFILLER_0_9_55 VGND VGND VPWR VPWR sky130_fd_sc_hd__fill_1
XFILLER_0_50_3 VPWR VGND VPWR VGND sky130_ef_sc_hd__decap_12
X_2428_ _1224_ VGND VGND VPWR VPWR _0265_ sky130_fd_sc_hd__clkbuf_1
X_2359_ _0470_ _1152_ _1160_ _1163_ VGND VGND VPWR VPWR _1164_ sky130_fd_sc_hd__a31o_1
XFILLER_0_66_259 VGND VGND VPWR VPWR sky130_fd_sc_hd__fill_1
XFILLER_0_66_237 VGND VGND VPWR VPWR sky130_fd_sc_hd__fill_2
XFILLER_0_62_421 VPWR VGND VPWR VGND sky130_ef_sc_hd__decap_12
XTAP_TAPCELL_ROW_50_552 VGND VPWR sky130_fd_sc_hd__tapvpwrvgnd_1
XFILLER_0_19_175 VGND VGND VPWR VPWR sky130_fd_sc_hd__fill_1
XFILLER_0_30_384 VGND VGND VPWR VPWR sky130_fd_sc_hd__fill_1
XFILLER_0_30_351 VGND VGND VPWR VPWR sky130_fd_sc_hd__fill_2
XFILLER_0_25_123 VGND VGND VPWR VPWR sky130_fd_sc_hd__decap_6
XFILLER_0_15_69 VPWR VGND VPWR VGND sky130_ef_sc_hd__decap_12
X_1661_ _0389_ _0476_ VGND VGND VPWR VPWR _0477_ sky130_fd_sc_hd__or2_4
XFILLER_0_40_159 VGND VGND VPWR VPWR sky130_fd_sc_hd__fill_1
XFILLER_0_40_115 VGND VGND VPWR VPWR sky130_fd_sc_hd__fill_2
X_1730_ _0478_ _0545_ _0519_ VGND VGND VPWR VPWR _0546_ sky130_fd_sc_hd__a21oi_1
X_1592_ reg_file.registers\[10\]\[26\] _0429_ VGND VGND VPWR VPWR _0435_ sky130_fd_sc_hd__and2_1
X_2144_ _0957_ _0958_ _0871_ VGND VGND VPWR VPWR _0959_ sky130_fd_sc_hd__mux2_1
X_2213_ _1025_ VGND VGND VPWR VPWR _1026_ sky130_fd_sc_hd__inv_2
XPHY_EDGE_ROW_37_Left_109 VGND VGND VPWR VPWR sky130_fd_sc_hd__decap_3
XTAP_TAPCELL_ROW_64_666 VGND VPWR sky130_fd_sc_hd__tapvpwrvgnd_1
XFILLER_0_48_248 VGND VGND VPWR VPWR sky130_fd_sc_hd__fill_1
XPHY_EDGE_ROW_46_Left_118 VGND VGND VPWR VPWR sky130_fd_sc_hd__decap_3
X_2075_ _0882_ VGND VGND VPWR VPWR _0891_ sky130_fd_sc_hd__clkbuf_4
XFILLER_0_8_301 VGND VGND VPWR VPWR sky130_fd_sc_hd__decap_6
X_2977_ clknet_leaf_5_clk _0207_ _0043_ VGND VGND VPWR VPWR imem.address\[18\] sky130_fd_sc_hd__dfrtp_1
X_1859_ _0673_ _0674_ VGND VGND VPWR VPWR _0675_ sky130_fd_sc_hd__nor2_1
XFILLER_0_44_421 VPWR VGND VPWR VGND sky130_ef_sc_hd__decap_12
X_1928_ _0630_ _0636_ _0628_ VGND VGND VPWR VPWR _0744_ sky130_fd_sc_hd__o21ba_1
XFILLER_0_16_123 VGND VGND VPWR VPWR sky130_fd_sc_hd__decap_6
XFILLER_0_16_134 VGND VGND VPWR VPWR sky130_fd_sc_hd__decap_6
XFILLER_0_16_189 VGND VGND VPWR VPWR sky130_fd_sc_hd__decap_6
XPHY_EDGE_ROW_55_Left_127 VGND VGND VPWR VPWR sky130_fd_sc_hd__decap_3
XPHY_EDGE_ROW_64_Left_136 VGND VGND VPWR VPWR sky130_fd_sc_hd__decap_3
XTAP_TAPCELL_ROW_27_368 VGND VPWR sky130_fd_sc_hd__tapvpwrvgnd_1
XFILLER_0_62_295 VPWR VGND VPWR VGND sky130_ef_sc_hd__decap_12
XFILLER_0_62_251 VGND VGND VPWR VPWR sky130_fd_sc_hd__fill_1
XFILLER_0_62_240 VGND VGND VPWR VPWR sky130_fd_sc_hd__decap_8
XTAP_TAPCELL_ROW_10_235 VGND VPWR sky130_fd_sc_hd__tapvpwrvgnd_1
X_2900_ _1466_ VGND VGND VPWR VPWR _0147_ sky130_fd_sc_hd__inv_2
XTAP_TAPCELL_ROW_18_302 VGND VPWR sky130_fd_sc_hd__tapvpwrvgnd_1
XTAP_TAPCELL_ROW_61_647 VGND VPWR sky130_fd_sc_hd__tapvpwrvgnd_1
XFILLER_0_53_251 VPWR VGND VPWR VGND sky130_ef_sc_hd__decap_12
X_1713_ _0528_ VGND VGND VPWR VPWR _0529_ sky130_fd_sc_hd__clkbuf_4
XFILLER_0_45_218 VGND VGND VPWR VPWR sky130_fd_sc_hd__decap_6
XFILLER_0_42_89 VGND VGND VPWR VPWR sky130_fd_sc_hd__decap_8
XFILLER_0_38_281 VPWR VGND VPWR VGND sky130_ef_sc_hd__decap_12
XFILLER_0_38_270 VGND VGND VPWR VPWR sky130_fd_sc_hd__decap_6
X_2762_ reset VGND VGND VPWR VPWR _1449_ sky130_fd_sc_hd__buf_1
X_2831_ _1457_ VGND VGND VPWR VPWR _0087_ sky130_fd_sc_hd__inv_2
XFILLER_0_26_421 VPWR VGND VPWR VGND sky130_ef_sc_hd__decap_12
XFILLER_0_5_337 VPWR VGND VPWR VGND sky130_ef_sc_hd__decap_12
X_1644_ reg_file.registers\[10\]\[1\] _0429_ VGND VGND VPWR VPWR _0462_ sky130_fd_sc_hd__or2b_1
X_1575_ _0425_ VGND VGND VPWR VPWR _0319_ sky130_fd_sc_hd__clkbuf_1
X_2693_ _1385_ _1407_ VGND VGND VPWR VPWR _1410_ sky130_fd_sc_hd__and2_1
Xrebuffer23 _0527_ VGND VGND VPWR VPWR net39 sky130_fd_sc_hd__dlygate4sd1_1
Xrebuffer12 _0542_ VGND VGND VPWR VPWR net28 sky130_fd_sc_hd__dlygate4sd1_1
X_2127_ _0794_ _0785_ _0871_ VGND VGND VPWR VPWR _0942_ sky130_fd_sc_hd__mux2_1
XFILLER_0_13_3 VPWR VGND VPWR VGND sky130_ef_sc_hd__decap_12
X_2058_ reg_file.registers\[11\]\[19\] _0867_ _0868_ reg_file.registers\[10\]\[19\]
+ VGND VGND VPWR VPWR _0874_ sky130_fd_sc_hd__a22o_1
XTAP_TAPCELL_ROW_24_349 VGND VPWR sky130_fd_sc_hd__tapvpwrvgnd_1
XFILLER_0_8_153 VPWR VGND VPWR VGND sky130_ef_sc_hd__decap_12
XFILLER_0_17_421 VGND VGND VPWR VPWR sky130_fd_sc_hd__decap_3
XFILLER_0_44_284 VPWR VGND VPWR VGND sky130_ef_sc_hd__decap_12
XFILLER_0_44_262 VGND VGND VPWR VPWR sky130_fd_sc_hd__decap_3
XFILLER_0_8_197 VPWR VGND VPWR VGND sky130_ef_sc_hd__decap_12
XFILLER_0_67_332 VGND VGND VPWR VPWR sky130_fd_sc_hd__decap_4
XFILLER_0_12_15 VPWR VGND VPWR VGND sky130_ef_sc_hd__decap_12
Xoutput2 net2 VGND VGND VPWR VPWR an[0] sky130_fd_sc_hd__buf_1
XFILLER_0_2_307 VGND VGND VPWR VPWR sky130_fd_sc_hd__fill_1
X_3030_ clknet_leaf_7_clk _0253_ _0089_ VGND VGND VPWR VPWR reg_file.registers\[11\]\[0\]
+ sky130_fd_sc_hd__dfrtp_1
XFILLER_0_58_365 VGND VGND VPWR VPWR sky130_fd_sc_hd__decap_4
XFILLER_0_58_354 VGND VGND VPWR VPWR sky130_fd_sc_hd__decap_8
XFILLER_0_58_343 VGND VGND VPWR VPWR sky130_fd_sc_hd__fill_2
XFILLER_0_53_55 VGND VGND VPWR VPWR sky130_fd_sc_hd__fill_1
XFILLER_0_18_229 VGND VGND VPWR VPWR sky130_fd_sc_hd__decap_6
X_2676_ _0360_ VGND VGND VPWR VPWR _1394_ sky130_fd_sc_hd__inv_2
XFILLER_0_41_232 VGND VGND VPWR VPWR sky130_fd_sc_hd__fill_1
X_2814_ _1455_ VGND VGND VPWR VPWR _0072_ sky130_fd_sc_hd__inv_2
XFILLER_0_26_273 VGND VGND VPWR VPWR sky130_fd_sc_hd__fill_1
XFILLER_0_5_167 VGND VGND VPWR VPWR sky130_fd_sc_hd__fill_1
XFILLER_0_14_424 VGND VGND VPWR VPWR sky130_fd_sc_hd__decap_4
X_2745_ display.counter\[13\] _1436_ display.counter\[14\] VGND VGND VPWR VPWR _1439_
+ sky130_fd_sc_hd__a21oi_1
X_1627_ _0453_ VGND VGND VPWR VPWR _0295_ sky130_fd_sc_hd__clkbuf_1
X_1489_ _0370_ VGND VGND VPWR VPWR _0350_ sky130_fd_sc_hd__clkbuf_1
X_1558_ reg_file.registers\[5\]\[10\] _0414_ VGND VGND VPWR VPWR _0417_ sky130_fd_sc_hd__and2_1
XFILLER_0_1_373 VPWR VGND VPWR VGND sky130_ef_sc_hd__decap_12
X_3159_ clknet_leaf_11_clk _0362_ VGND VGND VPWR VPWR net6 sky130_fd_sc_hd__dfxtp_1
XTAP_TAPCELL_ROW_37_452 VGND VPWR sky130_fd_sc_hd__tapvpwrvgnd_1
XFILLER_0_2_3 VPWR VGND VPWR VGND sky130_ef_sc_hd__decap_12
XTAP_TAPCELL_ROW_71_731 VGND VPWR sky130_fd_sc_hd__tapvpwrvgnd_1
XTAP_TAPCELL_ROW_71_720 VGND VPWR sky130_fd_sc_hd__tapvpwrvgnd_1
XFILLER_0_67_173 VGND VGND VPWR VPWR sky130_fd_sc_hd__fill_1
XFILLER_0_55_302 VPWR VGND VPWR VGND sky130_ef_sc_hd__decap_12
XFILLER_0_23_69 VGND VGND VPWR VPWR sky130_fd_sc_hd__fill_1
XFILLER_0_55_346 VGND VGND VPWR VPWR sky130_fd_sc_hd__decap_8
XTAP_TAPCELL_ROW_43_499 VGND VPWR sky130_fd_sc_hd__tapvpwrvgnd_1
Xrebuffer3 net17 VGND VGND VPWR VPWR net19 sky130_fd_sc_hd__dlygate4sd1_1
X_2530_ reg_file.registers\[15\]\[18\] _1293_ VGND VGND VPWR VPWR _1301_ sky130_fd_sc_hd__and2_1
X_2461_ _1252_ VGND VGND VPWR VPWR _0260_ sky130_fd_sc_hd__clkbuf_1
XFILLER_0_48_55 VPWR VGND VPWR VGND sky130_ef_sc_hd__decap_12
X_2392_ _1191_ VGND VGND VPWR VPWR _1192_ sky130_fd_sc_hd__inv_2
XFILLER_0_23_276 VGND VGND VPWR VPWR sky130_fd_sc_hd__decap_4
XFILLER_0_11_449 VGND VGND VPWR VPWR sky130_fd_sc_hd__fill_2
X_3013_ clknet_leaf_21_clk _0236_ _0072_ VGND VGND VPWR VPWR reg_file.registers\[15\]\[15\]
+ sky130_fd_sc_hd__dfrtp_1
XFILLER_0_3_57 VPWR VGND VPWR VGND sky130_ef_sc_hd__decap_12
XFILLER_0_6_421 VPWR VGND VPWR VGND sky130_ef_sc_hd__decap_12
Xclkbuf_leaf_16_clk clknet_1_1__leaf_clk VGND VGND VPWR VPWR clknet_leaf_16_clk sky130_fd_sc_hd__clkbuf_8
X_2659_ _1375_ _1376_ VGND VGND VPWR VPWR _1377_ sky130_fd_sc_hd__nand2_2
X_2728_ _1428_ _1429_ VGND VGND VPWR VPWR _0023_ sky130_fd_sc_hd__nor2_1
XFILLER_0_14_265 VGND VGND VPWR VPWR sky130_fd_sc_hd__decap_6
XFILLER_0_1_181 VPWR VGND VPWR VGND sky130_ef_sc_hd__decap_12
XFILLER_0_69_449 VGND VGND VPWR VPWR sky130_fd_sc_hd__fill_2
XFILLER_0_69_405 VPWR VGND VPWR VGND sky130_ef_sc_hd__decap_12
XFILLER_0_49_140 VGND VGND VPWR VPWR sky130_fd_sc_hd__fill_1
XFILLER_0_37_346 VGND VGND VPWR VPWR sky130_fd_sc_hd__decap_4
XFILLER_0_9_281 VPWR VGND VPWR VGND sky130_ef_sc_hd__decap_12
XTAP_TAPCELL_ROW_48_536 VGND VPWR sky130_fd_sc_hd__tapvpwrvgnd_1
XFILLER_0_55_132 VGND VGND VPWR VPWR sky130_fd_sc_hd__fill_2
X_1892_ _0542_ _0707_ VGND VGND VPWR VPWR _0708_ sky130_fd_sc_hd__or2_2
XFILLER_0_34_68 VPWR VGND VPWR VGND sky130_ef_sc_hd__decap_12
XTAP_TAPCELL_ROW_31_403 VGND VPWR sky130_fd_sc_hd__tapvpwrvgnd_1
X_1961_ reg_file.registers\[10\]\[23\] _0775_ _0776_ reg_file.registers\[11\]\[23\]
+ VGND VGND VPWR VPWR _0777_ sky130_fd_sc_hd__a22o_1
XFILLER_0_59_65 VGND VGND VPWR VPWR sky130_fd_sc_hd__decap_3
XFILLER_0_51_393 VPWR VGND VPWR VGND sky130_ef_sc_hd__decap_12
XFILLER_0_51_382 VGND VGND VPWR VPWR sky130_fd_sc_hd__decap_8
XFILLER_0_43_349 VPWR VGND VPWR VGND sky130_ef_sc_hd__decap_12
X_2513_ reg_file.registers\[15\]\[26\] _1286_ VGND VGND VPWR VPWR _1292_ sky130_fd_sc_hd__and2_1
Xclkbuf_leaf_5_clk clknet_1_0__leaf_clk VGND VGND VPWR VPWR clknet_leaf_5_clk sky130_fd_sc_hd__clkbuf_8
X_2444_ _1238_ VGND VGND VPWR VPWR _0263_ sky130_fd_sc_hd__clkbuf_1
X_2375_ _1177_ VGND VGND VPWR VPWR _0271_ sky130_fd_sc_hd__clkbuf_1
XFILLER_0_66_419 VGND VGND VPWR VPWR sky130_fd_sc_hd__fill_1
XFILLER_0_61_113 VPWR VGND VPWR VGND sky130_ef_sc_hd__decap_12
XFILLER_0_46_132 VGND VGND VPWR VPWR sky130_fd_sc_hd__fill_1
XFILLER_0_6_251 VGND VGND VPWR VPWR sky130_fd_sc_hd__fill_1
XTAP_TAPCELL_ROW_45_517 VGND VPWR sky130_fd_sc_hd__tapvpwrvgnd_1
XTAP_TAPCELL_ROW_2_172 VGND VPWR sky130_fd_sc_hd__tapvpwrvgnd_1
XFILLER_0_69_279 VGND VGND VPWR VPWR sky130_fd_sc_hd__fill_1
XFILLER_0_65_441 VGND VGND VPWR VPWR sky130_fd_sc_hd__decap_6
XTAP_TAPCELL_ROW_53_583 VGND VPWR sky130_fd_sc_hd__tapvpwrvgnd_1
XFILLER_0_25_305 VGND VGND VPWR VPWR sky130_fd_sc_hd__fill_2
XFILLER_0_52_135 VGND VGND VPWR VPWR sky130_fd_sc_hd__decap_4
XFILLER_0_33_393 VGND VGND VPWR VPWR sky130_fd_sc_hd__decap_6
XFILLER_0_33_371 VGND VGND VPWR VPWR sky130_fd_sc_hd__fill_2
XFILLER_0_0_405 VPWR VGND VPWR VGND sky130_ef_sc_hd__decap_12
XFILLER_0_20_15 VPWR VGND VPWR VGND sky130_ef_sc_hd__decap_12
X_2160_ _0734_ _0720_ _0877_ VGND VGND VPWR VPWR _0975_ sky130_fd_sc_hd__mux2_1
XFILLER_0_29_35 VGND VGND VPWR VPWR sky130_fd_sc_hd__fill_1
XFILLER_0_0_449 VGND VGND VPWR VPWR sky130_fd_sc_hd__fill_2
XFILLER_0_48_419 VGND VGND VPWR VPWR sky130_fd_sc_hd__fill_1
XFILLER_0_48_408 VGND VGND VPWR VPWR sky130_fd_sc_hd__fill_1
XFILLER_0_45_78 VGND VGND VPWR VPWR sky130_fd_sc_hd__fill_1
X_2091_ _0903_ _0906_ VGND VGND VPWR VPWR _0907_ sky130_fd_sc_hd__or2_1
XFILLER_0_71_433 VPWR VGND VPWR VGND sky130_ef_sc_hd__decap_12
X_1875_ reg_file.registers\[10\]\[4\] _0620_ _0622_ reg_file.registers\[11\]\[4\]
+ VGND VGND VPWR VPWR _0691_ sky130_fd_sc_hd__a22o_1
XFILLER_0_43_146 VGND VGND VPWR VPWR sky130_fd_sc_hd__decap_8
X_1944_ reg_file.registers\[10\]\[18\] _0604_ _0609_ reg_file.registers\[11\]\[18\]
+ VGND VGND VPWR VPWR _0760_ sky130_fd_sc_hd__a22o_1
XFILLER_0_28_154 VGND VGND VPWR VPWR sky130_fd_sc_hd__fill_1
XFILLER_0_0_69 VPWR VGND VPWR VGND sky130_ef_sc_hd__decap_12
XTAP_TAPCELL_ROW_16_285 VGND VPWR sky130_fd_sc_hd__tapvpwrvgnd_1
XFILLER_0_16_327 VGND VGND VPWR VPWR sky130_fd_sc_hd__fill_2
X_2993_ clknet_leaf_13_clk _0002_ VGND VGND VPWR VPWR net12 sky130_fd_sc_hd__dfxtp_1
X_2427_ reg_file.registers\[11\]\[12\] _1223_ _1158_ VGND VGND VPWR VPWR _1224_ sky130_fd_sc_hd__mux2_1
XFILLER_0_43_3 VPWR VGND VPWR VGND sky130_ef_sc_hd__decap_12
X_2358_ _1028_ _1033_ _1041_ _1027_ _1162_ VGND VGND VPWR VPWR _1163_ sky130_fd_sc_hd__a221o_1
X_2289_ _0940_ _1094_ _1096_ _1099_ _0937_ VGND VGND VPWR VPWR _1100_ sky130_fd_sc_hd__a32o_1
XFILLER_0_66_205 VGND VGND VPWR VPWR sky130_fd_sc_hd__fill_2
XFILLER_0_62_400 VPWR VGND VPWR VGND sky130_ef_sc_hd__decap_12
XFILLER_0_62_433 VPWR VGND VPWR VGND sky130_ef_sc_hd__decap_12
XTAP_TAPCELL_ROW_50_553 VGND VPWR sky130_fd_sc_hd__tapvpwrvgnd_1
XFILLER_0_42_190 VGND VGND VPWR VPWR sky130_fd_sc_hd__decap_6
XFILLER_0_34_102 VGND VGND VPWR VPWR sky130_fd_sc_hd__decap_8
XFILLER_0_15_360 VGND VGND VPWR VPWR sky130_fd_sc_hd__fill_1
XFILLER_0_15_393 VGND VGND VPWR VPWR sky130_fd_sc_hd__decap_8
XFILLER_0_30_363 VGND VGND VPWR VPWR sky130_fd_sc_hd__fill_1
XTAP_TAPCELL_ROW_58_620 VGND VPWR sky130_fd_sc_hd__tapvpwrvgnd_1
XFILLER_0_15_15 VPWR VGND VPWR VGND sky130_ef_sc_hd__decap_12
XFILLER_0_57_238 VGND VGND VPWR VPWR sky130_fd_sc_hd__fill_1
XFILLER_0_25_157 VGND VGND VPWR VPWR sky130_fd_sc_hd__fill_1
X_1660_ _0388_ _0378_ _0474_ _0475_ VGND VGND VPWR VPWR _0476_ sky130_fd_sc_hd__a31o_1
X_1591_ _0434_ VGND VGND VPWR VPWR _0312_ sky130_fd_sc_hd__clkbuf_1
X_2143_ reg_file.registers\[10\]\[6\] _0604_ _0609_ reg_file.registers\[11\]\[6\]
+ VGND VGND VPWR VPWR _0958_ sky130_fd_sc_hd__a22o_1
X_2212_ _0881_ _0972_ _1024_ VGND VGND VPWR VPWR _1025_ sky130_fd_sc_hd__o21ai_1
XTAP_TAPCELL_ROW_64_667 VGND VPWR sky130_fd_sc_hd__tapvpwrvgnd_1
X_2074_ _0887_ _0888_ _0889_ VGND VGND VPWR VPWR _0890_ sky130_fd_sc_hd__mux2_1
X_2976_ clknet_leaf_5_clk _0206_ _0042_ VGND VGND VPWR VPWR imem.address\[17\] sky130_fd_sc_hd__dfrtp_1
X_1858_ reg_file.registers\[10\]\[0\] _0490_ _0622_ reg_file.registers\[11\]\[0\]
+ VGND VGND VPWR VPWR _0674_ sky130_fd_sc_hd__a22o_1
XFILLER_0_44_433 VGND VGND VPWR VPWR sky130_fd_sc_hd__fill_1
X_1927_ _0637_ _0740_ _0742_ VGND VGND VPWR VPWR _0743_ sky130_fd_sc_hd__and3b_1
XFILLER_0_31_116 VGND VGND VPWR VPWR sky130_fd_sc_hd__decap_6
XFILLER_0_31_105 VGND VGND VPWR VPWR sky130_fd_sc_hd__fill_1
X_1789_ _0604_ VGND VGND VPWR VPWR _0605_ sky130_fd_sc_hd__buf_2
XFILLER_0_12_363 VGND VGND VPWR VPWR sky130_fd_sc_hd__fill_1
XTAP_TAPCELL_ROW_27_369 VGND VPWR sky130_fd_sc_hd__tapvpwrvgnd_1
XTAP_TAPCELL_ROW_10_236 VGND VPWR sky130_fd_sc_hd__tapvpwrvgnd_1
XFILLER_0_30_193 VGND VGND VPWR VPWR sky130_fd_sc_hd__decap_3
XFILLER_0_42_46 VPWR VGND VPWR VGND sky130_ef_sc_hd__decap_12
X_2830_ _1450_ VGND VGND VPWR VPWR _1457_ sky130_fd_sc_hd__buf_1
XTAP_TAPCELL_ROW_18_303 VGND VPWR sky130_fd_sc_hd__tapvpwrvgnd_1
X_1643_ _0461_ VGND VGND VPWR VPWR _0287_ sky130_fd_sc_hd__clkbuf_1
XFILLER_0_53_263 VGND VGND VPWR VPWR sky130_fd_sc_hd__decap_3
X_1712_ _0388_ _0378_ _0481_ VGND VGND VPWR VPWR _0528_ sky130_fd_sc_hd__and3_1
XFILLER_0_41_425 VGND VGND VPWR VPWR sky130_fd_sc_hd__fill_1
XFILLER_0_38_293 VPWR VGND VPWR VGND sky130_ef_sc_hd__decap_12
XANTENNA_1 _0942_ VGND VGND VPWR VPWR sky130_fd_sc_hd__diode_2
XFILLER_0_26_433 VGND VGND VPWR VPWR sky130_fd_sc_hd__fill_2
X_2692_ _1393_ _1403_ VGND VGND VPWR VPWR _1409_ sky130_fd_sc_hd__nand2_1
XFILLER_0_5_349 VPWR VGND VPWR VGND sky130_ef_sc_hd__decap_12
XFILLER_0_5_305 VPWR VGND VPWR VGND sky130_ef_sc_hd__decap_12
X_2761_ display.counter\[0\] VGND VGND VPWR VPWR _0007_ sky130_fd_sc_hd__inv_2
XFILLER_0_13_105 VGND VGND VPWR VPWR sky130_fd_sc_hd__decap_6
XTAP_TAPCELL_ROW_69_704 VGND VPWR sky130_fd_sc_hd__tapvpwrvgnd_1
X_1574_ reg_file.registers\[5\]\[2\] _0392_ VGND VGND VPWR VPWR _0425_ sky130_fd_sc_hd__and2_1
Xrebuffer24 net39 VGND VGND VPWR VPWR net40 sky130_fd_sc_hd__buf_2
Xrebuffer13 _0516_ VGND VGND VPWR VPWR net29 sky130_fd_sc_hd__dlygate4sd1_1
X_2057_ _0869_ _0870_ _0872_ VGND VGND VPWR VPWR _0873_ sky130_fd_sc_hd__mux2_1
X_2126_ _0802_ _0806_ _0878_ VGND VGND VPWR VPWR _0941_ sky130_fd_sc_hd__mux2_1
XPHY_EDGE_ROW_16_Left_88 VGND VGND VPWR VPWR sky130_fd_sc_hd__decap_3
XFILLER_0_36_219 VGND VGND VPWR VPWR sky130_fd_sc_hd__decap_4
X_2959_ _0365_ _1446_ _1479_ VGND VGND VPWR VPWR _0357_ sky130_fd_sc_hd__o21a_1
XFILLER_0_32_90 VGND VGND VPWR VPWR sky130_fd_sc_hd__fill_2
XFILLER_0_8_121 VPWR VGND VPWR VGND sky130_ef_sc_hd__decap_12
XFILLER_0_8_165 VPWR VGND VPWR VGND sky130_ef_sc_hd__decap_12
XFILLER_0_44_296 VPWR VGND VPWR VGND sky130_ef_sc_hd__decap_12
XFILLER_0_27_219 VGND VGND VPWR VPWR sky130_fd_sc_hd__decap_4
XFILLER_0_12_27 VGND VGND VPWR VPWR sky130_fd_sc_hd__fill_1
Xoutput3 net3 VGND VGND VPWR VPWR an[1] sky130_fd_sc_hd__buf_1
X_2813_ _1455_ VGND VGND VPWR VPWR _0071_ sky130_fd_sc_hd__inv_2
XFILLER_0_18_208 VGND VGND VPWR VPWR sky130_fd_sc_hd__fill_1
X_1626_ reg_file.registers\[10\]\[10\] _0449_ VGND VGND VPWR VPWR _0453_ sky130_fd_sc_hd__and2_1
XFILLER_0_41_288 VGND VGND VPWR VPWR sky130_fd_sc_hd__decap_8
X_2675_ _1277_ _0358_ _1392_ VGND VGND VPWR VPWR _1393_ sky130_fd_sc_hd__o21ai_4
XFILLER_0_5_113 VPWR VGND VPWR VGND sky130_ef_sc_hd__decap_12
X_2744_ display.counter\[13\] display.counter\[14\] _1436_ VGND VGND VPWR VPWR _1438_
+ sky130_fd_sc_hd__and3_1
X_1488_ reg_file.registers\[2\]\[2\] VGND VGND VPWR VPWR _0370_ sky130_fd_sc_hd__clkbuf_1
X_1557_ _0416_ VGND VGND VPWR VPWR _0328_ sky130_fd_sc_hd__clkbuf_1
XFILLER_0_1_385 VGND VGND VPWR VPWR sky130_fd_sc_hd__decap_6
X_3158_ clknet_leaf_11_clk _0361_ VGND VGND VPWR VPWR net5 sky130_fd_sc_hd__dfxtp_1
XFILLER_0_49_355 VPWR VGND VPWR VGND sky130_ef_sc_hd__decap_12
X_2109_ _0872_ _0671_ _0675_ _0891_ VGND VGND VPWR VPWR _0925_ sky130_fd_sc_hd__a211oi_1
XTAP_TAPCELL_ROW_37_453 VGND VPWR sky130_fd_sc_hd__tapvpwrvgnd_1
X_3089_ clknet_leaf_15_clk _0312_ _0148_ VGND VGND VPWR VPWR reg_file.registers\[10\]\[27\]
+ sky130_fd_sc_hd__dfrtp_1
XFILLER_0_64_369 VPWR VGND VPWR VGND sky130_ef_sc_hd__decap_12
XFILLER_0_59_119 VGND VGND VPWR VPWR sky130_fd_sc_hd__fill_1
XTAP_TAPCELL_ROW_71_732 VGND VPWR sky130_fd_sc_hd__tapvpwrvgnd_1
XTAP_TAPCELL_ROW_71_721 VGND VPWR sky130_fd_sc_hd__tapvpwrvgnd_1
XFILLER_0_55_314 VGND VGND VPWR VPWR sky130_fd_sc_hd__decap_8
XFILLER_0_23_15 VPWR VGND VPWR VGND sky130_ef_sc_hd__decap_12
X_2460_ reg_file.registers\[11\]\[7\] _1251_ _1234_ VGND VGND VPWR VPWR _1252_ sky130_fd_sc_hd__mux2_1
Xrebuffer4 net17 VGND VGND VPWR VPWR net20 sky130_fd_sc_hd__dlygate4sd1_1
XFILLER_0_23_266 VGND VGND VPWR VPWR sky130_fd_sc_hd__fill_2
XFILLER_0_23_233 VGND VGND VPWR VPWR sky130_fd_sc_hd__decap_3
XFILLER_0_48_67 VGND VGND VPWR VPWR sky130_fd_sc_hd__fill_2
X_2391_ _0634_ _0636_ VGND VGND VPWR VPWR _1191_ sky130_fd_sc_hd__or2_1
XFILLER_0_64_66 VGND VGND VPWR VPWR sky130_fd_sc_hd__decap_3
XFILLER_0_58_141 VGND VGND VPWR VPWR sky130_fd_sc_hd__fill_2
X_3012_ clknet_leaf_21_clk _0235_ _0071_ VGND VGND VPWR VPWR reg_file.registers\[15\]\[14\]
+ sky130_fd_sc_hd__dfrtp_1
XFILLER_0_3_69 VPWR VGND VPWR VGND sky130_ef_sc_hd__decap_12
XFILLER_0_6_433 VPWR VGND VPWR VGND sky130_ef_sc_hd__decap_12
XFILLER_0_13_81 VPWR VGND VPWR VGND sky130_ef_sc_hd__decap_12
XFILLER_0_14_211 VGND VGND VPWR VPWR sky130_fd_sc_hd__decap_3
X_2589_ _1338_ _1339_ VGND VGND VPWR VPWR _1340_ sky130_fd_sc_hd__and2_1
X_1609_ reg_file.registers\[10\]\[18\] _0438_ VGND VGND VPWR VPWR _0444_ sky130_fd_sc_hd__and2_1
X_2658_ _1266_ _0358_ VGND VGND VPWR VPWR _1376_ sky130_fd_sc_hd__or2_1
XFILLER_0_1_193 VPWR VGND VPWR VGND sky130_ef_sc_hd__decap_12
X_2727_ display.counter\[6\] _1426_ VGND VGND VPWR VPWR _1429_ sky130_fd_sc_hd__nor2_1
XFILLER_0_10_450 VGND VGND VPWR VPWR sky130_fd_sc_hd__fill_1
XFILLER_0_14_288 VGND VGND VPWR VPWR sky130_fd_sc_hd__decap_4
XFILLER_0_14_299 VGND VGND VPWR VPWR sky130_fd_sc_hd__decap_8
XFILLER_0_69_417 VPWR VGND VPWR VGND sky130_ef_sc_hd__decap_12
XFILLER_0_49_185 VGND VGND VPWR VPWR sky130_fd_sc_hd__fill_1
XFILLER_0_37_325 VGND VGND VPWR VPWR sky130_fd_sc_hd__fill_2
XPHY_EDGE_ROW_19_Left_91 VGND VGND VPWR VPWR sky130_fd_sc_hd__decap_3
XFILLER_0_9_293 VGND VGND VPWR VPWR sky130_fd_sc_hd__decap_4
XFILLER_0_18_15 VPWR VGND VPWR VGND sky130_ef_sc_hd__decap_12
XTAP_TAPCELL_ROW_48_537 VGND VPWR sky130_fd_sc_hd__tapvpwrvgnd_1
XTAP_TAPCELL_ROW_5_192 VGND VPWR sky130_fd_sc_hd__tapvpwrvgnd_1
XFILLER_0_55_100 VPWR VGND VPWR VGND sky130_ef_sc_hd__decap_12
X_1960_ _0642_ VGND VGND VPWR VPWR _0776_ sky130_fd_sc_hd__clkbuf_4
X_1891_ _0488_ net33 _0541_ _0539_ _0529_ VGND VGND VPWR VPWR _0707_ sky130_fd_sc_hd__o32a_1
XTAP_TAPCELL_ROW_31_404 VGND VPWR sky130_fd_sc_hd__tapvpwrvgnd_1
X_2443_ reg_file.registers\[11\]\[10\] _1237_ _1234_ VGND VGND VPWR VPWR _1238_ sky130_fd_sc_hd__mux2_1
XFILLER_0_59_55 VGND VGND VPWR VPWR sky130_fd_sc_hd__fill_1
XFILLER_0_51_361 VGND VGND VPWR VPWR sky130_fd_sc_hd__fill_1
XFILLER_0_3_447 VGND VGND VPWR VPWR sky130_fd_sc_hd__fill_1
XFILLER_0_11_225 VGND VGND VPWR VPWR sky130_fd_sc_hd__decap_4
XFILLER_0_11_258 VGND VGND VPWR VPWR sky130_fd_sc_hd__decap_8
X_2512_ _1291_ VGND VGND VPWR VPWR _0248_ sky130_fd_sc_hd__clkbuf_1
X_2374_ reg_file.registers\[11\]\[18\] _1176_ _1158_ VGND VGND VPWR VPWR _1177_ sky130_fd_sc_hd__mux2_1
XFILLER_0_61_169 VPWR VGND VPWR VGND sky130_ef_sc_hd__decap_12
XFILLER_0_61_125 VGND VGND VPWR VPWR sky130_fd_sc_hd__decap_6
XFILLER_0_34_306 VGND VGND VPWR VPWR sky130_fd_sc_hd__fill_2
XFILLER_0_27_391 VGND VGND VPWR VPWR sky130_fd_sc_hd__fill_1
XFILLER_0_69_225 VPWR VGND VPWR VGND sky130_ef_sc_hd__decap_12
XFILLER_0_69_203 VPWR VGND VPWR VGND sky130_ef_sc_hd__decap_12
XTAP_TAPCELL_ROW_45_518 VGND VPWR sky130_fd_sc_hd__tapvpwrvgnd_1
XTAP_TAPCELL_ROW_2_173 VGND VPWR sky130_fd_sc_hd__tapvpwrvgnd_1
XFILLER_0_37_177 VGND VGND VPWR VPWR sky130_fd_sc_hd__decap_3
XFILLER_0_37_122 VGND VGND VPWR VPWR sky130_fd_sc_hd__fill_1
XFILLER_0_37_111 VGND VGND VPWR VPWR sky130_fd_sc_hd__fill_1
XFILLER_0_25_328 VGND VGND VPWR VPWR sky130_fd_sc_hd__fill_1
XPHY_EDGE_ROW_4_Left_76 VGND VGND VPWR VPWR sky130_fd_sc_hd__decap_3
XFILLER_0_52_169 VGND VGND VPWR VPWR sky130_fd_sc_hd__decap_3
XFILLER_0_0_417 VGND VGND VPWR VPWR sky130_fd_sc_hd__decap_3
XFILLER_0_20_27 VGND VGND VPWR VPWR sky130_fd_sc_hd__fill_1
X_2090_ _0852_ _0857_ _0872_ VGND VGND VPWR VPWR _0906_ sky130_fd_sc_hd__mux2_1
X_2992_ clknet_leaf_12_clk _0001_ VGND VGND VPWR VPWR net11 sky130_fd_sc_hd__dfxtp_1
XFILLER_0_0_15 VPWR VGND VPWR VGND sky130_ef_sc_hd__decap_12
X_1874_ _0689_ _0659_ VGND VGND VPWR VPWR _0690_ sky130_fd_sc_hd__xor2_1
XFILLER_0_43_169 VGND VGND VPWR VPWR sky130_fd_sc_hd__fill_1
X_1943_ _0757_ _0758_ VGND VGND VPWR VPWR _0759_ sky130_fd_sc_hd__or2_1
XFILLER_0_9_57 VPWR VGND VPWR VGND sky130_ef_sc_hd__decap_12
XTAP_TAPCELL_ROW_16_286 VGND VPWR sky130_fd_sc_hd__tapvpwrvgnd_1
X_2426_ _0470_ _1221_ _1222_ _0940_ _1039_ VGND VGND VPWR VPWR _1223_ sky130_fd_sc_hd__a32o_1
X_2288_ _1097_ _1098_ _0909_ VGND VGND VPWR VPWR _1099_ sky130_fd_sc_hd__mux2_1
X_2357_ _1161_ _1139_ VGND VGND VPWR VPWR _1162_ sky130_fd_sc_hd__and2_1
XFILLER_0_36_3 VPWR VGND VPWR VGND sky130_ef_sc_hd__decap_12
XFILLER_0_66_228 VGND VGND VPWR VPWR sky130_fd_sc_hd__fill_1
XFILLER_0_62_412 VGND VGND VPWR VPWR sky130_fd_sc_hd__decap_8
XTAP_TAPCELL_ROW_50_554 VGND VPWR sky130_fd_sc_hd__tapvpwrvgnd_1
XFILLER_0_62_445 VGND VGND VPWR VPWR sky130_fd_sc_hd__decap_6
XFILLER_0_34_158 VGND VGND VPWR VPWR sky130_fd_sc_hd__decap_4
XFILLER_0_30_342 VGND VGND VPWR VPWR sky130_fd_sc_hd__decap_3
XTAP_TAPCELL_ROW_58_621 VGND VPWR sky130_fd_sc_hd__tapvpwrvgnd_1
XTAP_TAPCELL_ROW_7_210 VGND VPWR sky130_fd_sc_hd__tapvpwrvgnd_1
XFILLER_0_15_27 VPWR VGND VPWR VGND sky130_ef_sc_hd__decap_12
XFILLER_0_65_261 VGND VGND VPWR VPWR sky130_fd_sc_hd__decap_4
XFILLER_0_31_15 VPWR VGND VPWR VGND sky130_ef_sc_hd__decap_12
XTAP_TAPCELL_ROW_13_256 VGND VPWR sky130_fd_sc_hd__tapvpwrvgnd_1
XFILLER_0_0_225 VPWR VGND VPWR VGND sky130_ef_sc_hd__decap_12
X_1590_ reg_file.registers\[10\]\[27\] _0429_ VGND VGND VPWR VPWR _0434_ sky130_fd_sc_hd__and2_1
XFILLER_0_21_331 VGND VGND VPWR VPWR sky130_fd_sc_hd__decap_4
X_2142_ reg_file.registers\[10\]\[5\] _0604_ _0609_ reg_file.registers\[11\]\[5\]
+ VGND VGND VPWR VPWR _0957_ sky130_fd_sc_hd__a22o_1
X_2211_ _0901_ _0945_ VGND VGND VPWR VPWR _1024_ sky130_fd_sc_hd__or2_1
X_2073_ _0879_ VGND VGND VPWR VPWR _0889_ sky130_fd_sc_hd__buf_4
XTAP_TAPCELL_ROW_64_668 VGND VPWR sky130_fd_sc_hd__tapvpwrvgnd_1
XFILLER_0_63_209 VPWR VGND VPWR VGND sky130_ef_sc_hd__decap_12
X_2975_ clknet_leaf_6_clk _0205_ _0041_ VGND VGND VPWR VPWR imem.address\[16\] sky130_fd_sc_hd__dfrtp_1
XFILLER_0_71_253 VPWR VGND VPWR VGND sky130_ef_sc_hd__decap_12
X_1788_ _0603_ VGND VGND VPWR VPWR _0604_ sky130_fd_sc_hd__clkbuf_4
X_1857_ _0506_ _0508_ VGND VGND VPWR VPWR _0673_ sky130_fd_sc_hd__nand2_1
X_1926_ _0648_ _0741_ _0646_ VGND VGND VPWR VPWR _0742_ sky130_fd_sc_hd__a21o_1
X_2409_ _0940_ _0981_ _1207_ VGND VGND VPWR VPWR _1208_ sky130_fd_sc_hd__a21bo_1
XFILLER_0_7_391 VGND VGND VPWR VPWR sky130_fd_sc_hd__fill_1
XTAP_TAPCELL_ROW_10_237 VGND VPWR sky130_fd_sc_hd__tapvpwrvgnd_1
XFILLER_0_26_15 VPWR VGND VPWR VGND sky130_ef_sc_hd__decap_12
XFILLER_0_42_58 VPWR VGND VPWR VGND sky130_ef_sc_hd__decap_12
X_1642_ reg_file.registers\[10\]\[2\] _0428_ VGND VGND VPWR VPWR _0461_ sky130_fd_sc_hd__and2_1
X_1711_ _0526_ _0502_ _0513_ _0497_ VGND VGND VPWR VPWR _0527_ sky130_fd_sc_hd__or4_4
XANTENNA_2 _1223_ VGND VGND VPWR VPWR sky130_fd_sc_hd__diode_2
X_2760_ _1448_ VGND VGND VPWR VPWR _0017_ sky130_fd_sc_hd__clkbuf_1
X_2691_ _1377_ _1405_ _1406_ _1408_ VGND VGND VPWR VPWR _0000_ sky130_fd_sc_hd__a211o_1
XFILLER_0_5_317 VPWR VGND VPWR VGND sky130_ef_sc_hd__decap_12
XTAP_TAPCELL_ROW_69_705 VGND VPWR sky130_fd_sc_hd__tapvpwrvgnd_1
XFILLER_0_67_88 VGND VGND VPWR VPWR sky130_fd_sc_hd__decap_4
XFILLER_0_67_55 VGND VGND VPWR VPWR sky130_fd_sc_hd__fill_1
X_1573_ _0424_ VGND VGND VPWR VPWR _0320_ sky130_fd_sc_hd__clkbuf_1
XFILLER_0_21_183 VGND VGND VPWR VPWR sky130_fd_sc_hd__decap_3
Xrebuffer25 _0390_ VGND VGND VPWR VPWR net41 sky130_fd_sc_hd__dlygate4sd1_1
Xrebuffer14 net29 VGND VGND VPWR VPWR net30 sky130_fd_sc_hd__buf_2
X_2125_ _0939_ VGND VGND VPWR VPWR _0940_ sky130_fd_sc_hd__buf_2
X_2056_ _0871_ VGND VGND VPWR VPWR _0872_ sky130_fd_sc_hd__clkbuf_4
X_1909_ _0723_ _0724_ VGND VGND VPWR VPWR _0725_ sky130_fd_sc_hd__or2_1
X_2958_ display.digit_sel\[2\] _1478_ VGND VGND VPWR VPWR _1479_ sky130_fd_sc_hd__or2_1
XFILLER_0_8_133 VGND VGND VPWR VPWR sky130_fd_sc_hd__decap_6
XFILLER_0_8_177 VPWR VGND VPWR VGND sky130_ef_sc_hd__decap_12
X_2889_ _1465_ VGND VGND VPWR VPWR _0137_ sky130_fd_sc_hd__inv_2
XTAP_TAPCELL_ROW_23_340 VGND VPWR sky130_fd_sc_hd__tapvpwrvgnd_1
XFILLER_0_2_309 VPWR VGND VPWR VGND sky130_ef_sc_hd__decap_12
Xoutput4 net4 VGND VGND VPWR VPWR an[2] sky130_fd_sc_hd__buf_1
XFILLER_0_10_109 VPWR VGND VPWR VGND sky130_ef_sc_hd__decap_12
XFILLER_0_58_323 VGND VGND VPWR VPWR sky130_fd_sc_hd__decap_3
XFILLER_0_53_57 VPWR VGND VPWR VGND sky130_ef_sc_hd__decap_12
XFILLER_0_53_35 VGND VGND VPWR VPWR sky130_fd_sc_hd__decap_3
XFILLER_0_58_378 VGND VGND VPWR VPWR sky130_fd_sc_hd__decap_4
X_2812_ _1455_ VGND VGND VPWR VPWR _0070_ sky130_fd_sc_hd__inv_2
XFILLER_0_5_125 VPWR VGND VPWR VGND sky130_ef_sc_hd__decap_12
X_2743_ display.counter\[13\] _1436_ VGND VGND VPWR VPWR _0011_ sky130_fd_sc_hd__xor2_1
X_1625_ _0452_ VGND VGND VPWR VPWR _0296_ sky130_fd_sc_hd__clkbuf_1
X_1556_ reg_file.registers\[5\]\[11\] _0414_ VGND VGND VPWR VPWR _0416_ sky130_fd_sc_hd__and2_1
X_2674_ _1015_ _1360_ _1391_ VGND VGND VPWR VPWR _1392_ sky130_fd_sc_hd__a21o_1
XFILLER_0_5_169 VPWR VGND VPWR VGND sky130_ef_sc_hd__decap_12
X_3157_ clknet_leaf_11_clk _0360_ VGND VGND VPWR VPWR net4 sky130_fd_sc_hd__dfxtp_1
X_1487_ _0369_ VGND VGND VPWR VPWR _0351_ sky130_fd_sc_hd__clkbuf_1
XFILLER_0_49_367 VGND VGND VPWR VPWR sky130_fd_sc_hd__decap_6
XFILLER_0_49_334 VGND VGND VPWR VPWR sky130_fd_sc_hd__fill_2
X_2108_ _0668_ _0923_ _0872_ VGND VGND VPWR VPWR _0924_ sky130_fd_sc_hd__mux2_1
XTAP_TAPCELL_ROW_37_454 VGND VPWR sky130_fd_sc_hd__tapvpwrvgnd_1
X_2039_ _0616_ _0851_ _0854_ VGND VGND VPWR VPWR _0855_ sky130_fd_sc_hd__a21o_1
XFILLER_0_9_420 VGND VGND VPWR VPWR sky130_fd_sc_hd__fill_1
X_3088_ clknet_leaf_15_clk _0311_ _0147_ VGND VGND VPWR VPWR reg_file.registers\[10\]\[26\]
+ sky130_fd_sc_hd__dfrtp_1
XFILLER_0_32_256 VGND VGND VPWR VPWR sky130_fd_sc_hd__fill_2
XFILLER_0_20_407 VGND VGND VPWR VPWR sky130_fd_sc_hd__fill_1
XFILLER_0_59_109 VGND VGND VPWR VPWR sky130_fd_sc_hd__decap_3
XTAP_TAPCELL_ROW_71_733 VGND VPWR sky130_fd_sc_hd__tapvpwrvgnd_1
XTAP_TAPCELL_ROW_71_722 VGND VPWR sky130_fd_sc_hd__tapvpwrvgnd_1
XFILLER_0_70_307 VGND VGND VPWR VPWR sky130_fd_sc_hd__fill_1
XFILLER_0_55_337 VGND VGND VPWR VPWR sky130_fd_sc_hd__decap_3
XFILLER_0_23_27 VPWR VGND VPWR VGND sky130_ef_sc_hd__decap_12
Xrebuffer5 net26 VGND VGND VPWR VPWR net21 sky130_fd_sc_hd__dlygate4sd1_1
XFILLER_0_23_256 VGND VGND VPWR VPWR sky130_fd_sc_hd__decap_6
XFILLER_0_23_223 VGND VGND VPWR VPWR sky130_fd_sc_hd__fill_1
XFILLER_0_2_139 VGND VGND VPWR VPWR sky130_fd_sc_hd__fill_1
X_2390_ _1189_ _0739_ _0731_ VGND VGND VPWR VPWR _1190_ sky130_fd_sc_hd__o21a_1
X_3011_ clknet_leaf_2_clk _0234_ _0070_ VGND VGND VPWR VPWR reg_file.registers\[15\]\[13\]
+ sky130_fd_sc_hd__dfrtp_1
XFILLER_0_3_15 VPWR VGND VPWR VGND sky130_ef_sc_hd__decap_12
XFILLER_0_58_175 VGND VGND VPWR VPWR sky130_fd_sc_hd__decap_6
XFILLER_0_46_304 VGND VGND VPWR VPWR sky130_fd_sc_hd__decap_4
XTAP_TAPCELL_ROW_34_424 VGND VPWR sky130_fd_sc_hd__tapvpwrvgnd_1
XFILLER_0_58_197 VGND VGND VPWR VPWR sky130_fd_sc_hd__decap_8
XFILLER_0_54_381 VGND VGND VPWR VPWR sky130_fd_sc_hd__fill_1
XTAP_TAPCELL_ROW_42_490 VGND VPWR sky130_fd_sc_hd__tapvpwrvgnd_1
XFILLER_0_6_401 VPWR VGND VPWR VGND sky130_ef_sc_hd__decap_12
XFILLER_0_6_445 VGND VGND VPWR VPWR sky130_fd_sc_hd__decap_3
X_2726_ display.counter\[6\] _1426_ VGND VGND VPWR VPWR _1428_ sky130_fd_sc_hd__and2_1
XFILLER_0_13_93 VPWR VGND VPWR VGND sky130_ef_sc_hd__decap_12
XFILLER_0_14_234 VPWR VGND VPWR VGND sky130_ef_sc_hd__decap_12
XFILLER_0_66_3 VPWR VGND VPWR VGND sky130_ef_sc_hd__decap_12
X_2588_ imem.address\[30\] _1337_ VGND VGND VPWR VPWR _1339_ sky130_fd_sc_hd__or2_1
X_2657_ _1371_ VGND VGND VPWR VPWR _0358_ sky130_fd_sc_hd__inv_2
X_1608_ _0443_ VGND VGND VPWR VPWR _0304_ sky130_fd_sc_hd__clkbuf_1
X_1539_ reg_file.registers\[5\]\[19\] _0403_ VGND VGND VPWR VPWR _0407_ sky130_fd_sc_hd__and2_1
XFILLER_0_1_161 VGND VGND VPWR VPWR sky130_fd_sc_hd__decap_6
XFILLER_0_69_429 VPWR VGND VPWR VGND sky130_ef_sc_hd__decap_12
XFILLER_0_52_307 VGND VGND VPWR VPWR sky130_fd_sc_hd__fill_1
XFILLER_0_49_175 VGND VGND VPWR VPWR sky130_fd_sc_hd__fill_1
XFILLER_0_49_120 VPWR VGND VPWR VGND sky130_ef_sc_hd__decap_12
XFILLER_0_37_359 VPWR VGND VPWR VGND sky130_ef_sc_hd__decap_12
XFILLER_0_9_261 VPWR VGND VPWR VGND sky130_ef_sc_hd__decap_12
XFILLER_0_20_248 VGND VGND VPWR VPWR sky130_fd_sc_hd__decap_4
XFILLER_0_18_27 VGND VGND VPWR VPWR sky130_fd_sc_hd__fill_1
XTAP_TAPCELL_ROW_48_538 VGND VPWR sky130_fd_sc_hd__tapvpwrvgnd_1
XFILLER_0_34_15 VPWR VGND VPWR VGND sky130_ef_sc_hd__decap_12
XTAP_TAPCELL_ROW_5_193 VGND VPWR sky130_fd_sc_hd__tapvpwrvgnd_1
XPHY_EDGE_ROW_16_Right_16 VGND VGND VPWR VPWR sky130_fd_sc_hd__decap_3
X_1890_ _0656_ _0698_ _0703_ _0705_ VGND VGND VPWR VPWR _0706_ sky130_fd_sc_hd__a31o_1
XTAP_TAPCELL_ROW_31_405 VGND VPWR sky130_fd_sc_hd__tapvpwrvgnd_1
XFILLER_0_28_359 VGND VGND VPWR VPWR sky130_fd_sc_hd__decap_4
XPHY_EDGE_ROW_25_Right_25 VGND VGND VPWR VPWR sky130_fd_sc_hd__decap_3
X_2442_ _0470_ _1227_ _1236_ _0940_ _1099_ VGND VGND VPWR VPWR _1237_ sky130_fd_sc_hd__a32o_1
X_2373_ _1042_ _1093_ _1174_ _1175_ VGND VGND VPWR VPWR _1176_ sky130_fd_sc_hd__a211o_1
XFILLER_0_11_237 VGND VGND VPWR VPWR sky130_fd_sc_hd__fill_1
X_2511_ reg_file.registers\[15\]\[27\] _1286_ VGND VGND VPWR VPWR _1291_ sky130_fd_sc_hd__and2_1
XPHY_EDGE_ROW_34_Right_34 VGND VGND VPWR VPWR sky130_fd_sc_hd__decap_3
XPHY_EDGE_ROW_20_Left_92 VGND VGND VPWR VPWR sky130_fd_sc_hd__decap_3
XFILLER_0_19_326 VGND VGND VPWR VPWR sky130_fd_sc_hd__decap_3
XFILLER_0_19_337 VGND VGND VPWR VPWR sky130_fd_sc_hd__fill_1
XFILLER_0_61_148 VGND VGND VPWR VPWR sky130_fd_sc_hd__decap_8
XPHY_EDGE_ROW_43_Right_43 VGND VGND VPWR VPWR sky130_fd_sc_hd__decap_3
XFILLER_0_6_253 VPWR VGND VPWR VGND sky130_ef_sc_hd__decap_12
X_2709_ _1404_ _1420_ _1377_ VGND VGND VPWR VPWR _1421_ sky130_fd_sc_hd__mux2_1
XPHY_EDGE_ROW_52_Right_52 VGND VGND VPWR VPWR sky130_fd_sc_hd__decap_3
XFILLER_0_69_237 VPWR VGND VPWR VGND sky130_ef_sc_hd__decap_12
XFILLER_0_69_215 VGND VGND VPWR VPWR sky130_fd_sc_hd__decap_8
XTAP_TAPCELL_ROW_45_519 VGND VPWR sky130_fd_sc_hd__tapvpwrvgnd_1
XTAP_TAPCELL_ROW_2_174 VGND VPWR sky130_fd_sc_hd__tapvpwrvgnd_1
XPHY_EDGE_ROW_61_Right_61 VGND VGND VPWR VPWR sky130_fd_sc_hd__decap_3
XFILLER_0_37_167 VGND VGND VPWR VPWR sky130_fd_sc_hd__fill_1
XFILLER_0_37_101 VGND VGND VPWR VPWR sky130_fd_sc_hd__fill_1
XPHY_EDGE_ROW_70_Right_70 VGND VGND VPWR VPWR sky130_fd_sc_hd__decap_3
XFILLER_0_29_15 VPWR VGND VPWR VGND sky130_ef_sc_hd__decap_12
XFILLER_0_61_57 VPWR VGND VPWR VGND sky130_ef_sc_hd__decap_12
XFILLER_0_56_421 VPWR VGND VPWR VGND sky130_ef_sc_hd__decap_12
X_1942_ reg_file.registers\[10\]\[18\] _0641_ _0642_ reg_file.registers\[11\]\[18\]
+ VGND VGND VPWR VPWR _0758_ sky130_fd_sc_hd__a22o_1
XFILLER_0_28_134 VGND VGND VPWR VPWR sky130_fd_sc_hd__fill_1
X_2991_ clknet_leaf_12_clk _0000_ VGND VGND VPWR VPWR net10 sky130_fd_sc_hd__dfxtp_1
XFILLER_0_0_27 VGND VGND VPWR VPWR sky130_fd_sc_hd__fill_1
XFILLER_0_16_307 VGND VGND VPWR VPWR sky130_fd_sc_hd__fill_1
XTAP_TAPCELL_ROW_16_287 VGND VPWR sky130_fd_sc_hd__tapvpwrvgnd_1
XFILLER_0_51_192 VPWR VGND VPWR VGND sky130_ef_sc_hd__decap_12
XFILLER_0_51_181 VGND VGND VPWR VPWR sky130_fd_sc_hd__decap_4
X_1873_ _0657_ _0658_ VGND VGND VPWR VPWR _0689_ sky130_fd_sc_hd__nand2_1
XFILLER_0_3_223 VGND VGND VPWR VPWR sky130_fd_sc_hd__fill_1
XFILLER_0_9_69 VPWR VGND VPWR VGND sky130_ef_sc_hd__decap_12
X_2356_ _1036_ VGND VGND VPWR VPWR _1161_ sky130_fd_sc_hd__inv_2
X_2425_ _0731_ _1189_ _0739_ VGND VGND VPWR VPWR _1222_ sky130_fd_sc_hd__or3_1
XFILLER_0_10_83 VGND VGND VPWR VPWR sky130_fd_sc_hd__fill_1
XFILLER_0_19_81 VGND VGND VPWR VPWR sky130_fd_sc_hd__decap_8
XTAP_TAPCELL_ROW_67_688 VGND VPWR sky130_fd_sc_hd__tapvpwrvgnd_1
X_2287_ _0897_ _0969_ VGND VGND VPWR VPWR _1098_ sky130_fd_sc_hd__nor2_1
XFILLER_0_29_3 VPWR VGND VPWR VGND sky130_ef_sc_hd__decap_12
XTAP_TAPCELL_ROW_50_555 VGND VPWR sky130_fd_sc_hd__tapvpwrvgnd_1
XFILLER_0_34_148 VGND VGND VPWR VPWR sky130_fd_sc_hd__decap_6
XFILLER_0_19_156 VGND VGND VPWR VPWR sky130_fd_sc_hd__decap_6
XFILLER_0_19_167 VGND VGND VPWR VPWR sky130_fd_sc_hd__fill_1
XFILLER_0_30_365 VGND VGND VPWR VPWR sky130_fd_sc_hd__decap_6
XFILLER_0_30_321 VGND VGND VPWR VPWR sky130_fd_sc_hd__decap_4
XTAP_TAPCELL_ROW_7_211 VGND VPWR sky130_fd_sc_hd__tapvpwrvgnd_1
XFILLER_0_15_340 VPWR VGND VPWR VGND sky130_ef_sc_hd__decap_12
XTAP_TAPCELL_ROW_58_622 VGND VPWR sky130_fd_sc_hd__tapvpwrvgnd_1
XFILLER_0_38_421 VPWR VGND VPWR VGND sky130_ef_sc_hd__decap_12
XFILLER_0_15_39 VPWR VGND VPWR VGND sky130_ef_sc_hd__decap_12
XFILLER_0_53_402 VPWR VGND VPWR VGND sky130_ef_sc_hd__decap_12
XFILLER_0_33_181 VGND VGND VPWR VPWR sky130_fd_sc_hd__fill_1
XFILLER_0_31_27 VPWR VGND VPWR VGND sky130_ef_sc_hd__decap_12
XTAP_TAPCELL_ROW_13_257 VGND VPWR sky130_fd_sc_hd__tapvpwrvgnd_1
X_2210_ _0942_ _0944_ _0901_ VGND VGND VPWR VPWR _1023_ sky130_fd_sc_hd__mux2_1
XFILLER_0_0_237 VPWR VGND VPWR VGND sky130_ef_sc_hd__decap_12
XTAP_TAPCELL_ROW_29_390 VGND VPWR sky130_fd_sc_hd__tapvpwrvgnd_1
X_2141_ _0950_ _0952_ _0955_ _0898_ _0910_ VGND VGND VPWR VPWR _0956_ sky130_fd_sc_hd__a221o_1
X_2072_ reg_file.registers\[11\]\[22\] _0867_ _0868_ reg_file.registers\[10\]\[22\]
+ VGND VGND VPWR VPWR _0888_ sky130_fd_sc_hd__a22o_1
XFILLER_0_71_221 VGND VGND VPWR VPWR sky130_fd_sc_hd__decap_3
XTAP_TAPCELL_ROW_64_669 VGND VPWR sky130_fd_sc_hd__tapvpwrvgnd_1
X_2974_ clknet_leaf_5_clk _0204_ _0040_ VGND VGND VPWR VPWR imem.address\[15\] sky130_fd_sc_hd__dfrtp_1
XFILLER_0_48_229 VGND VGND VPWR VPWR sky130_fd_sc_hd__decap_6
X_1925_ reg_file.registers\[10\]\[13\] _0603_ _0608_ reg_file.registers\[11\]\[13\]
+ VGND VGND VPWR VPWR _0741_ sky130_fd_sc_hd__a22o_1
XFILLER_0_16_115 VGND VGND VPWR VPWR sky130_fd_sc_hd__fill_1
XFILLER_0_71_265 VPWR VGND VPWR VGND sky130_ef_sc_hd__decap_12
X_1787_ _0507_ VGND VGND VPWR VPWR _0603_ sky130_fd_sc_hd__clkbuf_4
X_1856_ _0513_ _0670_ _0671_ VGND VGND VPWR VPWR _0672_ sky130_fd_sc_hd__and3_1
XFILLER_0_12_365 VPWR VGND VPWR VGND sky130_ef_sc_hd__decap_12
X_2408_ _1191_ _1206_ _1193_ _0468_ net38 VGND VGND VPWR VPWR _1207_ sky130_fd_sc_hd__a2111o_1
XPHY_EDGE_ROW_2_Right_2 VGND VGND VPWR VPWR sky130_fd_sc_hd__decap_3
X_2339_ _1146_ VGND VGND VPWR VPWR _0276_ sky130_fd_sc_hd__clkbuf_1
XFILLER_0_1_81 VPWR VGND VPWR VGND sky130_ef_sc_hd__decap_12
XPHY_EDGE_ROW_33_Left_105 VGND VGND VPWR VPWR sky130_fd_sc_hd__decap_3
XTAP_TAPCELL_ROW_10_238 VGND VPWR sky130_fd_sc_hd__tapvpwrvgnd_1
XFILLER_0_15_181 VPWR VGND VPWR VGND sky130_ef_sc_hd__decap_12
XPHY_EDGE_ROW_42_Left_114 VGND VGND VPWR VPWR sky130_fd_sc_hd__decap_3
XFILLER_0_30_151 VGND VGND VPWR VPWR sky130_fd_sc_hd__decap_3
XFILLER_0_26_27 VGND VGND VPWR VPWR sky130_fd_sc_hd__fill_1
XPHY_EDGE_ROW_51_Left_123 VGND VGND VPWR VPWR sky130_fd_sc_hd__decap_3
XFILLER_0_42_15 VPWR VGND VPWR VGND sky130_ef_sc_hd__decap_12
XTAP_TAPCELL_ROW_26_360 VGND VPWR sky130_fd_sc_hd__tapvpwrvgnd_1
XFILLER_0_5_329 VGND VGND VPWR VPWR sky130_fd_sc_hd__decap_6
X_1641_ _0460_ VGND VGND VPWR VPWR _0288_ sky130_fd_sc_hd__clkbuf_1
XANTENNA_3 _1277_ VGND VGND VPWR VPWR sky130_fd_sc_hd__diode_2
XFILLER_0_53_276 VGND VGND VPWR VPWR sky130_fd_sc_hd__decap_4
X_1572_ reg_file.registers\[5\]\[3\] _0414_ VGND VGND VPWR VPWR _0424_ sky130_fd_sc_hd__and2_1
X_1710_ _0520_ _0516_ _0525_ VGND VGND VPWR VPWR _0526_ sky130_fd_sc_hd__a21o_1
XFILLER_0_41_449 VGND VGND VPWR VPWR sky130_fd_sc_hd__fill_2
X_2690_ _1407_ _1385_ _1376_ _1375_ VGND VGND VPWR VPWR _1408_ sky130_fd_sc_hd__and4bb_1
XFILLER_0_6_15 VPWR VGND VPWR VGND sky130_ef_sc_hd__decap_12
XTAP_TAPCELL_ROW_69_706 VGND VPWR sky130_fd_sc_hd__tapvpwrvgnd_1
XPHY_EDGE_ROW_60_Left_132 VGND VGND VPWR VPWR sky130_fd_sc_hd__decap_3
X_2124_ _0501_ _0938_ _0596_ _0570_ VGND VGND VPWR VPWR _0939_ sky130_fd_sc_hd__o211a_1
Xrebuffer26 _0536_ VGND VGND VPWR VPWR net42 sky130_fd_sc_hd__dlymetal6s2s_1
X_2055_ _0673_ VGND VGND VPWR VPWR _0871_ sky130_fd_sc_hd__clkbuf_4
Xrebuffer15 net30 VGND VGND VPWR VPWR net31 sky130_fd_sc_hd__dlygate4sd1_1
X_1839_ reg_file.registers\[10\]\[6\] _0620_ _0622_ reg_file.registers\[11\]\[6\]
+ VGND VGND VPWR VPWR _0655_ sky130_fd_sc_hd__a22o_1
X_1908_ reg_file.registers\[10\]\[8\] _0641_ _0642_ reg_file.registers\[11\]\[8\]
+ VGND VGND VPWR VPWR _0724_ sky130_fd_sc_hd__a22o_1
X_2888_ _1465_ VGND VGND VPWR VPWR _0136_ sky130_fd_sc_hd__inv_2
X_2957_ _1365_ _1446_ VGND VGND VPWR VPWR _1478_ sky130_fd_sc_hd__nor2_1
XFILLER_0_29_273 VGND VGND VPWR VPWR sky130_fd_sc_hd__decap_6
XFILLER_0_8_189 VGND VGND VPWR VPWR sky130_fd_sc_hd__decap_6
XFILLER_0_12_195 VGND VGND VPWR VPWR sky130_fd_sc_hd__fill_1
XTAP_TAPCELL_ROW_23_341 VGND VPWR sky130_fd_sc_hd__tapvpwrvgnd_1
XFILLER_0_12_29 VPWR VGND VPWR VGND sky130_ef_sc_hd__decap_12
Xoutput5 net5 VGND VGND VPWR VPWR an[3] sky130_fd_sc_hd__buf_1
XFILLER_0_50_224 VPWR VGND VPWR VGND sky130_ef_sc_hd__decap_12
XFILLER_0_23_449 VGND VGND VPWR VPWR sky130_fd_sc_hd__fill_2
XFILLER_0_37_15 VPWR VGND VPWR VGND sky130_ef_sc_hd__decap_12
XFILLER_0_58_335 VGND VGND VPWR VPWR sky130_fd_sc_hd__decap_8
XFILLER_0_53_69 VGND VGND VPWR VPWR sky130_fd_sc_hd__decap_3
XFILLER_0_53_47 VGND VGND VPWR VPWR sky130_fd_sc_hd__decap_8
X_2811_ _1455_ VGND VGND VPWR VPWR _0069_ sky130_fd_sc_hd__inv_2
XFILLER_0_5_137 VPWR VGND VPWR VGND sky130_ef_sc_hd__decap_12
X_2742_ _1436_ _1437_ VGND VGND VPWR VPWR _0010_ sky130_fd_sc_hd__nor2_1
X_1624_ reg_file.registers\[10\]\[11\] _0449_ VGND VGND VPWR VPWR _0452_ sky130_fd_sc_hd__and2_1
XFILLER_0_41_257 VPWR VGND VPWR VGND sky130_ef_sc_hd__decap_12
X_1555_ _0415_ VGND VGND VPWR VPWR _0329_ sky130_fd_sc_hd__clkbuf_1
X_2673_ _1113_ _1386_ _1389_ _1390_ VGND VGND VPWR VPWR _1391_ sky130_fd_sc_hd__a211o_1
X_3156_ clknet_leaf_10_clk _0359_ VGND VGND VPWR VPWR net3 sky130_fd_sc_hd__dfxtp_1
X_1486_ reg_file.registers\[2\]\[3\] VGND VGND VPWR VPWR _0369_ sky130_fd_sc_hd__clkbuf_1
X_2107_ reg_file.registers\[10\]\[3\] _0775_ _0776_ reg_file.registers\[11\]\[3\]
+ VGND VGND VPWR VPWR _0923_ sky130_fd_sc_hd__a22o_1
X_3087_ clknet_leaf_16_clk _0310_ _0146_ VGND VGND VPWR VPWR reg_file.registers\[10\]\[25\]
+ sky130_fd_sc_hd__dfrtp_1
Xclkbuf_leaf_19_clk clknet_1_0__leaf_clk VGND VGND VPWR VPWR clknet_leaf_19_clk sky130_fd_sc_hd__clkbuf_8
XFILLER_0_64_338 VGND VGND VPWR VPWR sky130_fd_sc_hd__fill_1
XFILLER_0_49_346 VGND VGND VPWR VPWR sky130_fd_sc_hd__decap_3
XTAP_TAPCELL_ROW_37_455 VGND VPWR sky130_fd_sc_hd__tapvpwrvgnd_1
XFILLER_0_11_3 VPWR VGND VPWR VGND sky130_ef_sc_hd__decap_12
X_2038_ _0853_ _0612_ VGND VGND VPWR VPWR _0854_ sky130_fd_sc_hd__nand2_1
XFILLER_0_32_268 VGND VGND VPWR VPWR sky130_fd_sc_hd__fill_1
XTAP_TAPCELL_ROW_71_734 VGND VPWR sky130_fd_sc_hd__tapvpwrvgnd_1
XTAP_TAPCELL_ROW_71_723 VGND VPWR sky130_fd_sc_hd__tapvpwrvgnd_1
XFILLER_0_67_165 VGND VGND VPWR VPWR sky130_fd_sc_hd__decap_3
XFILLER_0_63_360 VGND VGND VPWR VPWR sky130_fd_sc_hd__decap_3
XFILLER_0_55_327 VGND VGND VPWR VPWR sky130_fd_sc_hd__fill_1
XFILLER_0_23_39 VPWR VGND VPWR VGND sky130_ef_sc_hd__decap_12
XFILLER_0_63_393 VPWR VGND VPWR VGND sky130_ef_sc_hd__decap_12
Xrebuffer6 _0386_ VGND VGND VPWR VPWR net22 sky130_fd_sc_hd__clkbuf_1
XFILLER_0_31_290 VGND VGND VPWR VPWR sky130_fd_sc_hd__decap_6
X_3010_ clknet_leaf_21_clk _0233_ _0069_ VGND VGND VPWR VPWR reg_file.registers\[15\]\[12\]
+ sky130_fd_sc_hd__dfrtp_1
XFILLER_0_3_27 VPWR VGND VPWR VGND sky130_ef_sc_hd__decap_12
XFILLER_0_46_349 VGND VGND VPWR VPWR sky130_fd_sc_hd__fill_1
XTAP_TAPCELL_ROW_34_425 VGND VPWR sky130_fd_sc_hd__tapvpwrvgnd_1
XTAP_TAPCELL_ROW_42_491 VGND VPWR sky130_fd_sc_hd__tapvpwrvgnd_1
X_2656_ _0931_ _1360_ _1374_ VGND VGND VPWR VPWR _1375_ sky130_fd_sc_hd__a21o_1
XFILLER_0_6_413 VGND VGND VPWR VPWR sky130_fd_sc_hd__decap_6
X_2725_ _1426_ _1427_ VGND VGND VPWR VPWR _0022_ sky130_fd_sc_hd__nor2_1
XFILLER_0_14_246 VGND VGND VPWR VPWR sky130_fd_sc_hd__decap_6
X_2587_ imem.address\[31\] _1338_ VGND VGND VPWR VPWR _0220_ sky130_fd_sc_hd__xnor2_1
XFILLER_0_59_3 VPWR VGND VPWR VGND sky130_ef_sc_hd__decap_12
X_1607_ reg_file.registers\[10\]\[19\] _0438_ VGND VGND VPWR VPWR _0443_ sky130_fd_sc_hd__and2_1
X_1538_ _0406_ VGND VGND VPWR VPWR _0337_ sky130_fd_sc_hd__clkbuf_1
XFILLER_0_22_290 VPWR VGND VPWR VGND sky130_ef_sc_hd__decap_12
XFILLER_0_49_132 VGND VGND VPWR VPWR sky130_fd_sc_hd__decap_8
X_3139_ clknet_leaf_14_clk _0021_ VGND VGND VPWR VPWR display.counter\[4\] sky130_fd_sc_hd__dfxtp_1
XFILLER_0_37_305 VPWR VGND VPWR VGND sky130_ef_sc_hd__decap_12
XFILLER_0_9_273 VGND VGND VPWR VPWR sky130_fd_sc_hd__decap_6
XFILLER_0_45_393 VPWR VGND VPWR VGND sky130_ef_sc_hd__decap_12
XTAP_TAPCELL_ROW_48_539 VGND VPWR sky130_fd_sc_hd__tapvpwrvgnd_1
XTAP_TAPCELL_ROW_5_194 VGND VPWR sky130_fd_sc_hd__tapvpwrvgnd_1
XFILLER_0_0_3 VPWR VGND VPWR VGND sky130_ef_sc_hd__decap_12
XFILLER_0_55_113 VGND VGND VPWR VPWR sky130_fd_sc_hd__fill_1
XFILLER_0_50_15 VPWR VGND VPWR VGND sky130_ef_sc_hd__decap_12
XFILLER_0_34_27 VGND VGND VPWR VPWR sky130_fd_sc_hd__fill_1
XTAP_TAPCELL_ROW_31_406 VGND VPWR sky130_fd_sc_hd__tapvpwrvgnd_1
XFILLER_0_28_338 VPWR VGND VPWR VGND sky130_ef_sc_hd__decap_12
XFILLER_0_55_179 VGND VGND VPWR VPWR sky130_fd_sc_hd__fill_1
XFILLER_0_55_146 VGND VGND VPWR VPWR sky130_fd_sc_hd__decap_3
XFILLER_0_3_449 VGND VGND VPWR VPWR sky130_fd_sc_hd__fill_2
XFILLER_0_3_405 VPWR VGND VPWR VGND sky130_ef_sc_hd__decap_12
XFILLER_0_11_205 VPWR VGND VPWR VGND sky130_ef_sc_hd__decap_12
X_2510_ _1290_ VGND VGND VPWR VPWR _0249_ sky130_fd_sc_hd__clkbuf_1
XFILLER_0_59_57 VGND VGND VPWR VPWR sky130_fd_sc_hd__decap_8
XFILLER_0_59_35 VGND VGND VPWR VPWR sky130_fd_sc_hd__fill_1
X_2441_ _0718_ _1226_ VGND VGND VPWR VPWR _1236_ sky130_fd_sc_hd__or2_1
X_2372_ _1028_ _1097_ _1098_ _1139_ VGND VGND VPWR VPWR _1175_ sky130_fd_sc_hd__a22o_1
XFILLER_0_46_179 VGND VGND VPWR VPWR sky130_fd_sc_hd__fill_1
XFILLER_0_24_82 VGND VGND VPWR VPWR sky130_fd_sc_hd__fill_2
XFILLER_0_6_221 VPWR VGND VPWR VGND sky130_ef_sc_hd__decap_12
XFILLER_0_42_363 VGND VGND VPWR VPWR sky130_fd_sc_hd__fill_1
X_2639_ display.digit_sel\[1\] display.digit_sel\[2\] display.digit_sel\[0\] VGND
+ VGND VPWR VPWR _1361_ sky130_fd_sc_hd__and3b_2
XFILLER_0_6_265 VPWR VGND VPWR VGND sky130_ef_sc_hd__decap_12
X_2708_ net43 _1407_ _1412_ VGND VGND VPWR VPWR _1420_ sky130_fd_sc_hd__a21oi_1
XFILLER_0_69_249 VPWR VGND VPWR VGND sky130_ef_sc_hd__decap_12
XTAP_TAPCELL_ROW_2_175 VGND VPWR sky130_fd_sc_hd__tapvpwrvgnd_1
XFILLER_0_52_149 VGND VGND VPWR VPWR sky130_fd_sc_hd__decap_3
XFILLER_0_37_146 VGND VGND VPWR VPWR sky130_fd_sc_hd__decap_8
XFILLER_0_33_352 VGND VGND VPWR VPWR sky130_fd_sc_hd__fill_1
XFILLER_0_20_29 VPWR VGND VPWR VGND sky130_ef_sc_hd__decap_12
XFILLER_0_60_182 VGND VGND VPWR VPWR sky130_fd_sc_hd__fill_1
XFILLER_0_29_27 VGND VGND VPWR VPWR sky130_fd_sc_hd__decap_8
XFILLER_0_45_15 VPWR VGND VPWR VGND sky130_ef_sc_hd__decap_12
XFILLER_0_61_69 VGND VGND VPWR VPWR sky130_fd_sc_hd__fill_1
X_2990_ clknet_leaf_4_clk _0220_ _0056_ VGND VGND VPWR VPWR imem.address\[31\] sky130_fd_sc_hd__dfrtp_1
XFILLER_0_56_433 VPWR VGND VPWR VGND sky130_ef_sc_hd__decap_12
X_1872_ _0679_ _0682_ _0687_ VGND VGND VPWR VPWR _0688_ sky130_fd_sc_hd__a21oi_1
XFILLER_0_43_105 VGND VGND VPWR VPWR sky130_fd_sc_hd__fill_2
X_1941_ _0559_ _0562_ VGND VGND VPWR VPWR _0757_ sky130_fd_sc_hd__xnor2_1
XFILLER_0_28_146 VGND VGND VPWR VPWR sky130_fd_sc_hd__decap_8
XFILLER_0_9_15 VPWR VGND VPWR VGND sky130_ef_sc_hd__decap_12
XFILLER_0_16_319 VGND VGND VPWR VPWR sky130_fd_sc_hd__fill_1
XFILLER_0_3_279 VGND VGND VPWR VPWR sky130_fd_sc_hd__fill_1
X_2286_ _0977_ _0962_ net34 VGND VGND VPWR VPWR _1097_ sky130_fd_sc_hd__mux2_1
X_2424_ _1189_ _0739_ _0731_ VGND VGND VPWR VPWR _1221_ sky130_fd_sc_hd__o21ai_1
X_2355_ _0786_ _1129_ _1130_ VGND VGND VPWR VPWR _1160_ sky130_fd_sc_hd__or3_1
XTAP_TAPCELL_ROW_67_689 VGND VPWR sky130_fd_sc_hd__tapvpwrvgnd_1
XTAP_TAPCELL_ROW_50_556 VGND VPWR sky130_fd_sc_hd__tapvpwrvgnd_1
XFILLER_0_15_352 VGND VGND VPWR VPWR sky130_fd_sc_hd__decap_8
XTAP_TAPCELL_ROW_7_212 VGND VPWR sky130_fd_sc_hd__tapvpwrvgnd_1
XFILLER_0_15_385 VGND VGND VPWR VPWR sky130_fd_sc_hd__decap_6
XTAP_TAPCELL_ROW_58_623 VGND VPWR sky130_fd_sc_hd__tapvpwrvgnd_1
XFILLER_0_65_274 VGND VGND VPWR VPWR sky130_fd_sc_hd__fill_2
XFILLER_0_53_414 VPWR VGND VPWR VGND sky130_ef_sc_hd__decap_12
XFILLER_0_38_433 VPWR VGND VPWR VGND sky130_ef_sc_hd__decap_12
XFILLER_0_31_39 VPWR VGND VPWR VGND sky130_ef_sc_hd__decap_12
XTAP_TAPCELL_ROW_13_258 VGND VPWR sky130_fd_sc_hd__tapvpwrvgnd_1
X_2140_ _0953_ _0954_ _0902_ VGND VGND VPWR VPWR _0955_ sky130_fd_sc_hd__mux2_1
XFILLER_0_0_249 VGND VGND VPWR VPWR sky130_fd_sc_hd__decap_3
XTAP_TAPCELL_ROW_29_391 VGND VPWR sky130_fd_sc_hd__tapvpwrvgnd_1
X_2071_ reg_file.registers\[11\]\[23\] _0867_ _0868_ reg_file.registers\[10\]\[23\]
+ VGND VGND VPWR VPWR _0887_ sky130_fd_sc_hd__a22o_1
XFILLER_0_71_277 VGND VGND VPWR VPWR sky130_fd_sc_hd__decap_3
X_2973_ clknet_leaf_5_clk _0203_ _0039_ VGND VGND VPWR VPWR imem.address\[14\] sky130_fd_sc_hd__dfrtp_1
X_1855_ reg_file.registers\[10\]\[1\] _0490_ _0621_ reg_file.registers\[11\]\[1\]
+ VGND VGND VPWR VPWR _0671_ sky130_fd_sc_hd__a22oi_2
X_1924_ _0648_ _0649_ VGND VGND VPWR VPWR _0740_ sky130_fd_sc_hd__or2_1
XFILLER_0_12_322 VGND VGND VPWR VPWR sky130_fd_sc_hd__decap_4
XFILLER_0_12_333 VGND VGND VPWR VPWR sky130_fd_sc_hd__decap_3
XFILLER_0_12_377 VPWR VGND VPWR VGND sky130_ef_sc_hd__decap_12
XFILLER_0_21_94 VPWR VGND VPWR VGND sky130_ef_sc_hd__decap_12
X_1786_ _0595_ _0601_ VGND VGND VPWR VPWR _0602_ sky130_fd_sc_hd__xor2_1
X_2269_ reg_file.registers\[11\]\[8\] _0683_ _0685_ reg_file.registers\[10\]\[8\]
+ VGND VGND VPWR VPWR _1081_ sky130_fd_sc_hd__a22o_1
XFILLER_0_41_3 VPWR VGND VPWR VGND sky130_ef_sc_hd__decap_12
X_2407_ _0742_ _1190_ _0740_ VGND VGND VPWR VPWR _1206_ sky130_fd_sc_hd__o21ai_1
X_2338_ reg_file.registers\[11\]\[23\] _1145_ _0933_ VGND VGND VPWR VPWR _1146_ sky130_fd_sc_hd__mux2_1
XFILLER_0_1_93 VPWR VGND VPWR VGND sky130_ef_sc_hd__decap_12
XFILLER_0_62_288 VGND VGND VPWR VPWR sky130_fd_sc_hd__fill_2
XFILLER_0_50_417 VGND VGND VPWR VPWR sky130_fd_sc_hd__decap_3
XFILLER_0_7_393 VPWR VGND VPWR VGND sky130_ef_sc_hd__decap_12
XTAP_TAPCELL_ROW_10_239 VGND VPWR sky130_fd_sc_hd__tapvpwrvgnd_1
XFILLER_0_42_27 VGND VGND VPWR VPWR sky130_fd_sc_hd__fill_1
XTAP_TAPCELL_ROW_26_361 VGND VPWR sky130_fd_sc_hd__tapvpwrvgnd_1
XFILLER_0_67_57 VGND VGND VPWR VPWR sky130_fd_sc_hd__decap_8
X_1640_ reg_file.registers\[10\]\[3\] _0429_ VGND VGND VPWR VPWR _0460_ sky130_fd_sc_hd__or2b_1
X_1571_ _0423_ VGND VGND VPWR VPWR _0321_ sky130_fd_sc_hd__clkbuf_1
XFILLER_0_6_27 VGND VGND VPWR VPWR sky130_fd_sc_hd__fill_1
XFILLER_0_13_119 VGND VGND VPWR VPWR sky130_fd_sc_hd__fill_1
XTAP_TAPCELL_ROW_69_707 VGND VPWR sky130_fd_sc_hd__tapvpwrvgnd_1
Xrebuffer16 net29 VGND VGND VPWR VPWR net32 sky130_fd_sc_hd__dlygate4sd1_1
X_2123_ reg_file.registers\[2\]\[4\] _0494_ _0523_ _0521_ _0937_ VGND VGND VPWR VPWR
+ _0938_ sky130_fd_sc_hd__a2111oi_1
X_2054_ reg_file.registers\[11\]\[17\] _0867_ _0868_ reg_file.registers\[10\]\[17\]
+ VGND VGND VPWR VPWR _0870_ sky130_fd_sc_hd__a22o_1
XFILLER_0_16_83 VGND VGND VPWR VPWR sky130_fd_sc_hd__fill_1
X_1838_ _0652_ _0653_ VGND VGND VPWR VPWR _0654_ sky130_fd_sc_hd__or2_1
X_1907_ net24 _0722_ VGND VGND VPWR VPWR _0723_ sky130_fd_sc_hd__nand2_1
X_2887_ _1465_ VGND VGND VPWR VPWR _0135_ sky130_fd_sc_hd__inv_2
X_2956_ _1365_ _1446_ _1477_ VGND VGND VPWR VPWR _0356_ sky130_fd_sc_hd__o21a_1
XFILLER_0_29_296 VGND VGND VPWR VPWR sky130_fd_sc_hd__decap_8
XFILLER_0_4_363 VGND VGND VPWR VPWR sky130_fd_sc_hd__fill_1
XFILLER_0_17_447 VGND VGND VPWR VPWR sky130_fd_sc_hd__fill_1
XFILLER_0_12_141 VPWR VGND VPWR VGND sky130_ef_sc_hd__decap_12
X_1769_ _0566_ _0584_ _0529_ VGND VGND VPWR VPWR _0585_ sky130_fd_sc_hd__a21oi_1
XTAP_TAPCELL_ROW_23_342 VGND VPWR sky130_fd_sc_hd__tapvpwrvgnd_1
Xoutput6 net6 VGND VGND VPWR VPWR an[4] sky130_fd_sc_hd__buf_1
XFILLER_0_50_236 VGND VGND VPWR VPWR sky130_fd_sc_hd__fill_2
XFILLER_0_35_277 VGND VGND VPWR VPWR sky130_fd_sc_hd__decap_3
XFILLER_0_37_27 VPWR VGND VPWR VGND sky130_ef_sc_hd__decap_12
XFILLER_0_53_15 VPWR VGND VPWR VGND sky130_ef_sc_hd__decap_12
X_2810_ _1455_ VGND VGND VPWR VPWR _0068_ sky130_fd_sc_hd__inv_2
X_2672_ _1157_ _1361_ _1363_ _1181_ VGND VGND VPWR VPWR _1390_ sky130_fd_sc_hd__a22o_1
XFILLER_0_5_149 VPWR VGND VPWR VGND sky130_ef_sc_hd__decap_12
XFILLER_0_5_105 VGND VGND VPWR VPWR sky130_fd_sc_hd__decap_6
X_2741_ display.counter\[12\] _1434_ VGND VGND VPWR VPWR _1437_ sky130_fd_sc_hd__nor2_1
XFILLER_0_14_428 VGND VGND VPWR VPWR sky130_fd_sc_hd__fill_1
X_1623_ _0451_ VGND VGND VPWR VPWR _0297_ sky130_fd_sc_hd__clkbuf_1
X_1485_ _0368_ VGND VGND VPWR VPWR _0352_ sky130_fd_sc_hd__clkbuf_1
X_1554_ reg_file.registers\[5\]\[12\] _0414_ VGND VGND VPWR VPWR _0415_ sky130_fd_sc_hd__and2_1
.ends
